* NGSPICE file created from tt_um_lelo_gr01_analogicus.ext - technology: sky130A

* Replacing the lpe port list (../tech/scripts/fixlpe)
.subckt tt_um_lelo_gr01_analogicus uo_out<7> uo_out<6> uo_out<5> uo_out<4> uo_out<3> uo_out<2>
+ uio_out<7> uio_out<6> uio_out<5> uio_out<4> uio_out<3> uio_out<2> uio_out<1> uio_out<0> uio_oe<7> uio_oe<6> uio_oe<5> uio_oe<4> uio_oe<3> uio_oe<2> uio_oe<1> uio_oe<0> VDPWR VGND
+ ui_in<7> ui_in<6> ui_in<5> ui_in<4> ui_in<3> ui_in<2> ui_in<1> ui_in<0> uio_in<7> uio_in<6> uio_in<5> uio_in<4> uio_in<3> uio_in<2> uio_in<1> uio_in<0> ena rst_n clk uo_out<0> uo_out<1>
*.subckt tt_um_lelo_gr01_analogicus clk ena rst_n ui_in<0> ui_in<1> ui_in<2> ui_in<3>
*+ ui_in<4> ui_in<5> ui_in<6> ui_in<7> uio_in<0> uio_in<1> uio_in<2> uio_in<3> uio_in<4>
*+ uio_in<5> uio_in<6> uio_in<7> uio_oe<0> uio_oe<1> uio_oe<2> uio_oe<3> uio_oe<4>
*+ uio_oe<5> uio_oe<6> uio_oe<7> uio_out<0> uio_out<1> uio_out<2> uio_out<3> uio_out<4>
*+ uio_out<5> uio_out<6> uio_out<7> uo_out<0> uo_out<1> uo_out<2> uo_out<3> uo_out<4>
*+ uo_out<5> uo_out<6> uo_out<7> VDPWR VGND
X0 a_7501_2588# a_7055_2588# a_7405_2588# VGND sky130_fd_pr__special_nfet_01v8 ad=0.1401 pd=1.1 as=0.0594 ps=0.69 w=0.36 l=0.15
X1 a_11758_188# digital_0._063_.A a_11673_n132# VDPWR sky130_fd_pr__pfet_01v8_hvt ad=0.135 pd=1.27 as=0.135 ps=1.27 w=1 l=0.15
X2 a_7302_n132# a_7088_n132# VDPWR VDPWR sky130_fd_pr__pfet_01v8_hvt ad=0.1155 pd=0.97 as=0.07035 ps=0.755 w=0.42 l=0.15
X3 a_8324_2588# digital_0._109_.RESET_B VGND VGND sky130_fd_pr__nfet_01v8 ad=0.06405 pd=0.725 as=0.12495 ps=1.015 w=0.42 l=0.15
X4 digital_0.clkbuf_1_0__f_clk.X a_6315_1474# VGND VGND sky130_fd_pr__nfet_01v8 ad=0.0588 pd=0.7 as=0.0588 ps=0.7 w=0.42 l=0.15
X5 VGND a_10253_930# digital_0._060_.B VGND sky130_fd_pr__nfet_01v8 ad=0.169 pd=1.82 as=0.08775 ps=0.92 w=0.65 l=0.15
X6 VGND VGND LELO_GR01_0.x7.x15.I1 sky130_fd_pr__pnp_05v5_W3p40L3p40
**devattr s=462400,2720
X7 a_6959_234# a_6397_n158# VGND VGND sky130_fd_pr__nfet_01v8 ad=0.0669 pd=0.75 as=0.12495 ps=1.015 w=0.42 l=0.15
X8 VGND digital_0.clkbuf_1_1__f_clk.A a_11388_956# VGND sky130_fd_pr__nfet_01v8 ad=0.0588 pd=0.7 as=0.0588 ps=0.7 w=0.42 l=0.15
X9 VDPWR VGND VDPWR VDPWR sky130_fd_pr__pfet_01v8_hvt ad=0.2262 pd=2.26 as=140.4317 ps=1.24118k w=0.87 l=0.59
X10 VDPWR a_12929_2562# digital_0._110_.Q VDPWR sky130_fd_pr__pfet_01v8_hvt ad=0.26 pd=2.52 as=0.135 ps=1.27 w=1 l=0.15
X11 a_7349_3132# digital_0._109_.Q digital_0._069_.B VDPWR sky130_fd_pr__pfet_01v8_hvt ad=0.36 pd=2.72 as=0.135 ps=1.27 w=1 l=0.15
X12 VDPWR VGND VDPWR VDPWR sky130_fd_pr__pfet_01v8_hvt ad=0.2262 pd=2.26 as=0 ps=0 w=0.87 l=0.59
X13 a_7786_412# a_6705_412# a_7439_654# VDPWR sky130_fd_pr__pfet_01v8_hvt ad=0.0588 pd=0.7 as=0.12915 ps=1.185 w=0.42 l=0.15
X14 a_9631_2050# a_9465_2050# VDPWR VDPWR sky130_fd_pr__pfet_01v8_hvt ad=0.1664 pd=1.8 as=0.0864 ps=0.91 w=0.64 l=0.15
X15 VGND digital_0.hold28.X a_5328_n132# VGND sky130_fd_pr__nfet_01v8 ad=0.2205 pd=1.89 as=0.066 ps=0.745 w=0.42 l=0.15
X16 digital_0.clkbuf_1_1__f_clk.A a_8996_1500# VGND VGND sky130_fd_pr__nfet_01v8 ad=0.0588 pd=0.7 as=0.0588 ps=0.7 w=0.42 l=0.15
X17 VGND a_14175_n702# a_14109_n676# VGND sky130_fd_pr__nfet_01v8 ad=0.1449 pd=1.11 as=0.0693 ps=0.75 w=0.42 l=0.15
X18 a_13746_n524# digital_0._113_.Q a_13888_n676# VGND sky130_fd_pr__nfet_01v8 ad=0.09975 pd=0.895 as=0.0693 ps=0.75 w=0.42 l=0.15
X19 a_12849_1866# a_12225_1500# a_12741_1500# VDPWR sky130_fd_pr__pfet_01v8_hvt ad=0.1155 pd=0.97 as=0.07245 ps=0.765 w=0.42 l=0.15
X20 VDPWR a_5109_2348# a_5096_2044# VDPWR sky130_fd_pr__pfet_01v8_hvt ad=0.0819 pd=0.81 as=0.0567 ps=0.69 w=0.42 l=0.15
X21 a_7961_386# digital_0._115_.RESET_B VDPWR VDPWR sky130_fd_pr__pfet_01v8_hvt ad=0.0567 pd=0.69 as=0.0819 ps=0.81 w=0.42 l=0.15
X22 LELO_GR01_0.x7.x20.D LELO_GR01_0.x8.PWRUP_N_1V8 LELO_GR01_0.x7.x21.D VDPWR sky130_fd_pr__pfet_01v8_lvt ad=0.3168 pd=1.62 as=0.5088 ps=2.98 w=0.96 l=0.94
X23 VDPWR digital_0._080_.A2 a_5785_n426# VDPWR sky130_fd_pr__pfet_01v8_hvt ad=0.1575 pd=1.315 as=0.26 ps=2.52 w=1 l=0.15
X24 digital_0._105_.RESET_B digital_0.load_slew17.X VGND VGND sky130_fd_pr__nfet_01v8 ad=0.08775 pd=0.92 as=0.169 ps=1.82 w=0.65 l=0.15
X25 VDPWR VGND VDPWR VDPWR sky130_fd_pr__pfet_01v8_hvt ad=0.2262 pd=2.26 as=0 ps=0 w=0.87 l=0.59
X26 digital_0._109_.RESET_B digital_0._116_.Q VGND VGND sky130_fd_pr__nfet_01v8 ad=0.08775 pd=0.92 as=0.182 ps=1.86 w=0.65 l=0.15
X27 a_7961_386# a_7786_412# a_8140_412# VGND sky130_fd_pr__nfet_01v8 ad=0.1092 pd=1.36 as=0.06405 ps=0.725 w=0.42 l=0.15
X28 a_6263_2562# digital_0.hold28.A VDPWR VDPWR sky130_fd_pr__pfet_01v8_hvt ad=0.1176 pd=1.4 as=0.0693 ps=0.75 w=0.42 l=0.15
X29 a_10253_930# digital_0._113_.Q a_10839_1276# VGND sky130_fd_pr__nfet_01v8 ad=0.169 pd=1.82 as=0.08775 ps=0.92 w=0.65 l=0.15
X30 VGND a_10721_2348# a_10655_2422# VGND sky130_fd_pr__nfet_01v8 ad=0.12495 pd=1.015 as=0.0669 ps=0.75 w=0.42 l=0.15
X31 VGND VDPWR VGND VGND sky130_fd_pr__nfet_01v8 ad=0.143 pd=1.62 as=167.84656 ps=1.32337k w=0.55 l=0.59
X32 a_10243_2410# a_10199_2018# a_10077_2422# VGND sky130_fd_pr__nfet_01v8 ad=0.0441 pd=0.63 as=0.1401 ps=1.1 w=0.42 l=0.15
X33 digital_0._113_.D a_11758_188# a_12116_n132# VDPWR sky130_fd_pr__pfet_01v8_hvt ad=0.135 pd=1.27 as=0.26 ps=2.52 w=1 l=0.15
X34 digital_0._119_.RESET_B digital_0.load_slew15.X VDPWR VDPWR sky130_fd_pr__pfet_01v8_hvt ad=0.135 pd=1.27 as=0.26 ps=2.52 w=1 l=0.15
X35 VGND a_4609_110# a_4570_n16# VGND sky130_fd_pr__nfet_01v8 ad=0.0567 pd=0.69 as=0.1092 ps=1.36 w=0.42 l=0.15
X36 a_6684_0# a_6962_n16# a_6918_n132# VDPWR sky130_fd_pr__pfet_01v8_hvt ad=0.0588 pd=0.7 as=0.0567 ps=0.69 w=0.42 l=0.15
X37 a_10795_3498# a_10751_3106# a_10629_3510# VGND sky130_fd_pr__nfet_01v8 ad=0.0441 pd=0.63 as=0.1401 ps=1.1 w=0.42 l=0.15
X38 a_11484_1500# digital_0._065_.A2_N VGND VGND sky130_fd_pr__nfet_01v8 ad=0.08937 pd=0.925 as=0.18525 ps=1.87 w=0.65 l=0.15
X39 a_9005_956# digital_0.load_slew15.A digital_0._114_.RESET_B VDPWR sky130_fd_pr__pfet_01v8_hvt ad=0.26 pd=2.52 as=0.135 ps=1.27 w=1 l=0.15
X40 VGND VDPWR VGND VGND sky130_fd_pr__nfet_01v8 ad=0.143 pd=1.62 as=0 ps=0 w=0.55 l=0.59
X41 digital_0._108_.Q a_7593_2348# VDPWR VDPWR sky130_fd_pr__pfet_01v8_hvt ad=0.135 pd=1.27 as=0.3012 ps=2.66 w=1 l=0.15
X42 VDPWR a_10199_n158# a_10089_n132# VDPWR sky130_fd_pr__pfet_01v8_hvt ad=0.07035 pd=0.755 as=0.1155 ps=0.97 w=0.42 l=0.15
X43 a_6209_386# digital_0.output6.A VGND VGND sky130_fd_pr__nfet_01v8 ad=0.1092 pd=1.36 as=0.0567 ps=0.69 w=0.42 l=0.15
X44 a_14727_1474# digital_0.hold28.A VDPWR VDPWR sky130_fd_pr__pfet_01v8_hvt ad=0.1176 pd=1.4 as=0.0693 ps=0.75 w=0.42 l=0.15
X45 digital_0._105_.RESET_B digital_0.load_slew17.X VDPWR VDPWR sky130_fd_pr__pfet_01v8_hvt ad=0.135 pd=1.27 as=0.26 ps=2.52 w=1 l=0.15
X46 LELO_GR01_0.x8.x1.x7.D LELO_GR01_0.PWRUP_1V8 VDPWR VDPWR sky130_fd_pr__pfet_01v8_lvt ad=0.3168 pd=1.62 as=0.5088 ps=2.98 w=0.96 l=0.94
X47 VGND VDPWR VGND VGND sky130_fd_pr__nfet_01v8 ad=0.143 pd=1.62 as=0 ps=0 w=0.55 l=0.59
X48 a_14686_246# a_13771_n126# a_14339_n158# VGND sky130_fd_pr__special_nfet_01v8 ad=0.0711 pd=0.755 as=0.0999 ps=0.985 w=0.36 l=0.15
X49 VGND a_7643_n702# a_7577_n676# VGND sky130_fd_pr__nfet_01v8 ad=0.1449 pd=1.11 as=0.0693 ps=0.75 w=0.42 l=0.15
X50 digital_0._060_.B a_10253_930# VDPWR VDPWR sky130_fd_pr__pfet_01v8_hvt ad=0.135 pd=1.27 as=0.26 ps=2.52 w=1 l=0.15
X51 digital_0._112_.D digital_0._063_.B a_13513_956# VDPWR sky130_fd_pr__pfet_01v8_hvt ad=0.135 pd=1.27 as=0.135 ps=1.27 w=1 l=0.15
X52 a_7099_956# digital_0._115_.Q VDPWR VDPWR sky130_fd_pr__pfet_01v8_hvt ad=0.26 pd=2.52 as=0.135 ps=1.27 w=1 l=0.15
X53 a_12034_2404# digital_0._112_.Q a_11951_2146# VGND sky130_fd_pr__nfet_01v8 ad=0.0441 pd=0.63 as=0.1092 ps=1.36 w=0.42 l=0.15
X54 VDPWR digital_0._108_.Q a_5787_2146# VDPWR sky130_fd_pr__pfet_01v8_hvt ad=0.15075 pd=1.345 as=0.07438 ps=0.815 w=0.42 l=0.15
X55 a_4833_3436# digital_0._117_.RESET_B VDPWR VDPWR sky130_fd_pr__pfet_01v8_hvt ad=0.0567 pd=0.69 as=0.0819 ps=0.81 w=0.42 l=0.15
X56 digital_0._108_.RESET_B digital_0.load_slew15.A a_8837_2838# VDPWR sky130_fd_pr__pfet_01v8_hvt ad=0.135 pd=1.27 as=0.26 ps=2.52 w=1 l=0.15
R0 uio_oe<7> li_28516_19376# sky130_fd_pr__res_generic_m4 w=0.3 l=0.3
X57 VGND digital_0._067_.B digital_0._110_.D VGND sky130_fd_pr__nfet_01v8 ad=0.169 pd=1.82 as=0.08775 ps=0.92 w=0.65 l=0.15
X58 digital_0.clkload0.A a_11388_956# VDPWR VDPWR sky130_fd_pr__pfet_01v8_hvt ad=0.14 pd=1.28 as=0.14 ps=1.28 w=1 l=0.15
X59 digital_0.clkbuf_1_1__f_clk.A a_8996_1500# VDPWR VDPWR sky130_fd_pr__pfet_01v8_hvt ad=0.14 pd=1.28 as=0.14 ps=1.28 w=1 l=0.15
X60 a_11207_3510# a_10017_3138# a_11098_3510# VGND sky130_fd_pr__special_nfet_01v8 ad=0.0669 pd=0.75 as=0.0711 ps=0.755 w=0.36 l=0.15
X61 VGND digital_0._102_.RESET_B a_14291_3498# VGND sky130_fd_pr__nfet_01v8 ad=0.1346 pd=1.15 as=0.0441 ps=0.63 w=0.42 l=0.15
X62 a_14769_3436# a_14594_3510# a_14948_3498# VGND sky130_fd_pr__nfet_01v8 ad=0.1092 pd=1.36 as=0.06405 ps=0.725 w=0.42 l=0.15
X63 a_5595_1334# a_4405_962# a_5486_1334# VGND sky130_fd_pr__special_nfet_01v8 ad=0.0669 pd=0.75 as=0.0711 ps=0.755 w=0.36 l=0.15
X64 VDPWR VGND VDPWR VDPWR sky130_fd_pr__pfet_01v8_hvt ad=0.2262 pd=2.26 as=0 ps=0 w=0.87 l=0.59
X65 VDPWR VGND VDPWR VDPWR sky130_fd_pr__pfet_01v8_hvt ad=0.2262 pd=2.26 as=0 ps=0 w=0.87 l=0.59
X66 VDPWR a_13612_3650# uio_out<2> VDPWR sky130_fd_pr__pfet_01v8_hvt ad=0.2726 pd=1.61 as=0.495 ps=2.99 w=1 l=0.15
X67 VGND a_10495_n702# a_10429_n676# VGND sky130_fd_pr__nfet_01v8 ad=0.1449 pd=1.11 as=0.0693 ps=0.75 w=0.42 l=0.15
X68 a_4396_412# a_4118_412# a_4324_412# VGND sky130_fd_pr__nfet_01v8 ad=0.0441 pd=0.63 as=0.0441 ps=0.63 w=0.42 l=0.15
X69 VGND digital_0.load_slew15.A a_8085_1500# VGND sky130_fd_pr__nfet_01v8 ad=0.08775 pd=0.92 as=0.169 ps=1.82 w=0.65 l=0.15
X70 a_10629_3510# a_10183_3138# a_10533_3510# VGND sky130_fd_pr__special_nfet_01v8 ad=0.1401 pd=1.1 as=0.0594 ps=0.69 w=0.36 l=0.15
X71 digital_0._080_.A2 digital_0.input2.X VDPWR VDPWR sky130_fd_pr__pfet_01v8_hvt ad=0.135 pd=1.27 as=0.26 ps=2.52 w=1 l=0.15
X72 VGND a_10074_2562# digital_0._111_.D VGND sky130_fd_pr__nfet_01v8 ad=0.09862 pd=0.98 as=0.08775 ps=0.92 w=0.65 l=0.15
X73 VGND digital_0.clkload0.A a_13605_n126# VGND sky130_fd_pr__nfet_01v8 ad=0.0567 pd=0.69 as=0.1092 ps=1.36 w=0.42 l=0.15
X74 a_5017_1334# a_4571_962# a_4921_1334# VGND sky130_fd_pr__special_nfet_01v8 ad=0.1401 pd=1.1 as=0.0594 ps=0.69 w=0.36 l=0.15
X75 LELO_GR01_0.x8.x1.x7.D LELO_GR01_0.x8.x1.x7.D VDPWR VDPWR sky130_fd_pr__pfet_01v8_lvt ad=0.3168 pd=1.62 as=0.5088 ps=2.98 w=0.96 l=0.94
X76 a_12959_1742# a_12741_1500# VDPWR VDPWR sky130_fd_pr__pfet_01v8_hvt ad=0.12915 pd=1.185 as=0.2184 ps=2.2 w=0.84 l=0.15
X77 VGND digital_0.input1.X a_12225_1500# VGND sky130_fd_pr__nfet_01v8 ad=0.0567 pd=0.69 as=0.1092 ps=1.36 w=0.42 l=0.15
X78 LELO_GR01_0.x8.x1.x5.x8.G LELO_GR01_0.x8.x1.x5.x9<2>.G VGND VGND sky130_fd_pr__nfet_01v8_lvt ad=0.3168 pd=1.62 as=0.5088 ps=2.98 w=0.96 l=0.94
X79 VDPWR a_8996_1500# digital_0.clkbuf_1_1__f_clk.A VDPWR sky130_fd_pr__pfet_01v8_hvt ad=0.14 pd=1.28 as=0.14 ps=1.28 w=1 l=0.15
X80 LELO_GR01_0.x8.IBP_BG LELO_GR01_0.x7.x18.G VDPWR VDPWR sky130_fd_pr__pfet_01v8_lvt ad=0.3168 pd=1.62 as=0.5088 ps=2.98 w=0.96 l=0.94
X81 digital_0._113_.RESET_B digital_0.input3.X a_15537_n132# VDPWR sky130_fd_pr__pfet_01v8_hvt ad=0.135 pd=1.27 as=0.135 ps=1.27 w=1 l=0.15
X82 VGND a_11388_956# digital_0.clkload0.A VGND sky130_fd_pr__nfet_01v8 ad=0.0588 pd=0.7 as=0.0588 ps=0.7 w=0.42 l=0.15
X83 VDPWR VGND VDPWR VDPWR sky130_fd_pr__pfet_01v8_hvt ad=0.2262 pd=2.26 as=0 ps=0 w=0.87 l=0.59
X84 VDPWR digital_0._116_.Q a_9557_2838# VDPWR sky130_fd_pr__pfet_01v8_hvt ad=0.135 pd=1.27 as=0.28 ps=2.56 w=1 l=0.15
X85 VGND digital_0._100_.RESET_B a_4143_2588# VGND sky130_fd_pr__nfet_01v8 ad=0.12495 pd=1.015 as=0.06405 ps=0.725 w=0.42 l=0.15
X86 a_7155_930# digital_0._115_.Q VGND VGND sky130_fd_pr__nfet_01v8 ad=0.08775 pd=0.92 as=0.08775 ps=0.92 w=0.65 l=0.15
X87 VDPWR digital_0._116_.Q a_3471_1474# VDPWR sky130_fd_pr__pfet_01v8_hvt ad=0.1176 pd=1.4 as=0.0567 ps=0.69 w=0.42 l=0.15
X88 VDPWR a_6209_386# a_5951_386# VDPWR sky130_fd_pr__pfet_01v8_hvt ad=0.0567 pd=0.69 as=0.1092 ps=1.36 w=0.42 l=0.5
X89 digital_0.clkbuf_1_0__f_clk.X a_6315_1474# VGND VGND sky130_fd_pr__nfet_01v8 ad=0.0588 pd=0.7 as=0.0588 ps=0.7 w=0.42 l=0.15
X90 VDPWR a_4833_3436# a_4820_3132# VDPWR sky130_fd_pr__pfet_01v8_hvt ad=0.0819 pd=0.81 as=0.0567 ps=0.69 w=0.42 l=0.15
X91 VGND digital_0._112_.RESET_B a_13003_412# VGND sky130_fd_pr__nfet_01v8 ad=0.1346 pd=1.15 as=0.0441 ps=0.63 w=0.42 l=0.15
X92 LELO_GR01_0.x8.x1.x5.IBN LELO_GR01_0.x8.VREF_BG LELO_GR01_0.x8.x7.D VGND sky130_fd_pr__nfet_01v8_lvt ad=0.5088 pd=2.98 as=0.3168 ps=1.62 w=0.96 l=0.94
X93 digital_0._063_.B digital_0._112_.Q a_11397_1750# VDPWR sky130_fd_pr__pfet_01v8_hvt ad=0.135 pd=1.27 as=0.135 ps=1.27 w=1 l=0.15
X94 a_8895_412# a_8729_412# VDPWR VDPWR sky130_fd_pr__pfet_01v8_hvt ad=0.1664 pd=1.8 as=0.0864 ps=0.91 w=0.64 l=0.15
X95 a_10986_3828# digital_0._111_.Q a_11128_3676# VGND sky130_fd_pr__nfet_01v8 ad=0.09975 pd=0.895 as=0.0693 ps=0.75 w=0.42 l=0.15
X96 VDPWR a_14762_2018# digital_0.load_slew17.X VDPWR sky130_fd_pr__pfet_01v8_hvt ad=0.149 pd=1.325 as=0.135 ps=1.27 w=1 l=0.15
X97 a_6906_3132# digital_0.output13.A VDPWR VDPWR sky130_fd_pr__pfet_01v8_hvt ad=0.275 pd=2.55 as=0.135 ps=1.27 w=1 l=0.15
X98 VGND VDPWR VGND VGND sky130_fd_pr__nfet_01v8 ad=0.143 pd=1.62 as=0 ps=0 w=0.55 l=0.59
X99 a_10721_2348# digital_0._111_.RESET_B VDPWR VDPWR sky130_fd_pr__pfet_01v8_hvt ad=0.0567 pd=0.69 as=0.0819 ps=0.81 w=0.42 l=0.15
X100 VDPWR a_14624_386# digital_0.input3.X VDPWR sky130_fd_pr__pfet_01v8_hvt ad=0.2726 pd=1.61 as=0.495 ps=2.99 w=1 l=0.15
X101 a_12863_2588# a_11673_2588# a_12754_2588# VGND sky130_fd_pr__special_nfet_01v8 ad=0.0669 pd=0.75 as=0.0711 ps=0.755 w=0.36 l=0.15
X102 VDPWR a_11388_956# digital_0.clkload0.A VDPWR sky130_fd_pr__pfet_01v8_hvt ad=0.265 pd=2.53 as=0.14 ps=1.28 w=1 l=0.15
X103 digital_0.hold25.X a_5321_3676# VDPWR VDPWR sky130_fd_pr__pfet_01v8_hvt ad=0.26 pd=2.52 as=0.14075 ps=1.325 w=1 l=0.15
X104 LELO_GR01_0.x8.x1.x5.x9<2>.G LELO_GR01_0.x8.x1.x5.x8.G LELO_GR01_0.x8.x1.x5.x8.G VGND sky130_fd_pr__nfet_01v8_lvt ad=0.5088 pd=2.98 as=0.3168 ps=1.62 w=0.96 l=0.94
X105 digital_0._113_.RESET_B digital_0.input3.X VGND VGND sky130_fd_pr__nfet_01v8 ad=0.08775 pd=0.92 as=0.08775 ps=0.92 w=0.65 l=0.15
X106 a_6235_3106# digital_0.output13.A VGND VGND sky130_fd_pr__nfet_01v8 ad=0.08775 pd=0.92 as=0.08775 ps=0.92 w=0.65 l=0.15
X107 VDPWR a_11273_3436# digital_0.output8.A VDPWR sky130_fd_pr__pfet_01v8_hvt ad=0.26 pd=2.52 as=0.135 ps=1.27 w=1 l=0.15
X108 a_4567_234# a_4005_n158# VGND VGND sky130_fd_pr__nfet_01v8 ad=0.0669 pd=0.75 as=0.12495 ps=1.015 w=0.42 l=0.15
X109 VGND a_14871_n524# digital_0.hold27.X VGND sky130_fd_pr__nfet_01v8 ad=0.097 pd=0.975 as=0.169 ps=1.82 w=0.65 l=0.15
X110 a_6761_930# digital_0.hold28.A VGND VGND sky130_fd_pr__nfet_01v8 ad=0.1092 pd=1.36 as=0.0567 ps=0.69 w=0.42 l=0.15
X111 a_14137_3132# digital_0._102_.RESET_B VDPWR VDPWR sky130_fd_pr__pfet_01v8_hvt ad=0.1092 pd=1.36 as=0.07035 ps=0.755 w=0.42 l=0.15
X112 VDPWR LELO_GR01_0.x8.x1.x7.D LELO_GR01_0.x8.x7.D VDPWR sky130_fd_pr__pfet_01v8_lvt ad=0.5088 pd=2.98 as=0.3168 ps=1.62 w=0.96 l=0.94
X113 VDPWR a_12407_2830# a_12297_2954# VDPWR sky130_fd_pr__pfet_01v8_hvt ad=0.07035 pd=0.755 as=0.1155 ps=0.97 w=0.42 l=0.15
X114 VGND digital_0.load_slew15.X digital_0._118_.RESET_B VGND sky130_fd_pr__nfet_01v8 ad=0.169 pd=1.82 as=0.08775 ps=0.92 w=0.65 l=0.15
X115 a_7717_3926# digital_0.load_slew15.A digital_0._109_.RESET_B VDPWR sky130_fd_pr__pfet_01v8_hvt ad=0.26 pd=2.52 as=0.135 ps=1.27 w=1 l=0.15
X116 a_9810_412# a_8895_412# a_9463_654# VGND sky130_fd_pr__special_nfet_01v8 ad=0.0711 pd=0.755 as=0.0999 ps=0.985 w=0.36 l=0.15
X117 VGND a_6315_1474# digital_0.clkbuf_1_0__f_clk.X VGND sky130_fd_pr__nfet_01v8 ad=0.0588 pd=0.7 as=0.0588 ps=0.7 w=0.42 l=0.15
X118 VDPWR ui_in<0> a_8361_n132# VDPWR sky130_fd_pr__pfet_01v8_hvt ad=0.19265 pd=1.415 as=0.27 ps=2.54 w=1 l=0.15
X119 VDPWR VGND VDPWR VDPWR sky130_fd_pr__pfet_01v8_hvt ad=0.2262 pd=2.26 as=0 ps=0 w=0.87 l=0.59
X120 VGND digital_0.input2.X digital_0._080_.A2 VGND sky130_fd_pr__nfet_01v8 ad=0.169 pd=1.82 as=0.08775 ps=0.92 w=0.65 l=0.15
X121 VGND a_12718_3676# a_12829_3676# VGND sky130_fd_pr__nfet_01v8 ad=0.1856 pd=1.26 as=0.17225 ps=1.83 w=0.65 l=0.25
X122 a_11388_956# digital_0.clkbuf_1_1__f_clk.A VGND VGND sky130_fd_pr__nfet_01v8 ad=0.0588 pd=0.7 as=0.0588 ps=0.7 w=0.42 l=0.15
X123 digital_0.clkload0.A a_11388_956# VDPWR VDPWR sky130_fd_pr__pfet_01v8_hvt ad=0.14 pd=1.28 as=0.14 ps=1.28 w=1 l=0.15
X124 digital_0._100_.RESET_B digital_0.load_slew15.X VDPWR VDPWR sky130_fd_pr__pfet_01v8_hvt ad=0.135 pd=1.27 as=0.26 ps=2.52 w=1 l=0.15
X125 a_4581_2825# a_4425_2730# a_4726_2954# VDPWR sky130_fd_pr__pfet_01v8_hvt ad=0.07245 pd=0.765 as=0.1155 ps=0.97 w=0.42 l=0.15
X126 VDPWR digital_0._065_.A2_N a_10285_2910# VDPWR sky130_fd_pr__pfet_01v8_hvt ad=0.2272 pd=1.35 as=0.173 ps=1.4 w=0.64 l=0.15
X127 a_14781_956# digital_0._104_.RESET_B VDPWR VDPWR sky130_fd_pr__pfet_01v8_hvt ad=0.1092 pd=1.36 as=0.07035 ps=0.755 w=0.42 l=0.15
X128 VDPWR a_14871_n524# digital_0.hold27.X VDPWR sky130_fd_pr__pfet_01v8_hvt ad=0.14075 pd=1.325 as=0.26 ps=2.52 w=1 l=0.15
X129 VGND a_6761_930# a_6503_930# VGND sky130_fd_pr__nfet_01v8 ad=0.0567 pd=0.69 as=0.1092 ps=1.36 w=0.42 l=0.5
X130 a_10986_3828# digital_0.hold20.X a_11128_4003# VDPWR sky130_fd_pr__pfet_01v8_hvt ad=0.1932 pd=1.34 as=0.07665 ps=0.785 w=0.42 l=0.15
X131 a_11772_n702# a_11898_n518# VGND VGND sky130_fd_pr__nfet_01v8 ad=0.17225 pd=1.83 as=0.1856 ps=1.26 w=0.65 l=0.25
X132 VGND VDPWR VGND VGND sky130_fd_pr__nfet_01v8 ad=0.143 pd=1.62 as=0 ps=0 w=0.55 l=0.59
X133 VGND VGND LELO_GR01_0.x7.x15.I2 sky130_fd_pr__pnp_05v5_W3p40L3p40
**devattr s=462400,2720
X134 VGND VDPWR VGND VGND sky130_fd_pr__nfet_01v8 ad=0.143 pd=1.62 as=0 ps=0 w=0.55 l=0.59
X135 a_11128_4003# digital_0.hold28.A VDPWR VDPWR sky130_fd_pr__pfet_01v8_hvt ad=0.07665 pd=0.785 as=0.15835 ps=1.395 w=0.42 l=0.15
X136 VDPWR VGND VDPWR VDPWR sky130_fd_pr__pfet_01v8_hvt ad=0.2262 pd=2.26 as=0 ps=0 w=0.87 l=0.59
X137 VDPWR a_14686_246# a_14861_172# VDPWR sky130_fd_pr__pfet_01v8_hvt ad=0.1134 pd=1.38 as=0.0567 ps=0.69 w=0.42 l=0.15
X138 VDPWR a_3814_386# digital_0._116_.Q VDPWR sky130_fd_pr__pfet_01v8_hvt ad=0.135 pd=1.27 as=0.135 ps=1.27 w=1 l=0.15
X139 a_6293_2915# digital_0._108_.Q a_5834_2740# VDPWR sky130_fd_pr__pfet_01v8_hvt ad=0.0441 pd=0.63 as=0.1932 ps=1.34 w=0.42 l=0.15
X140 VGND digital_0.load_slew17.A digital_0._111_.RESET_B VGND sky130_fd_pr__nfet_01v8 ad=0.169 pd=1.82 as=0.08775 ps=0.92 w=0.65 l=0.15
X141 VDPWR digital_0.load_slew17.A digital_0._103_.RESET_B VDPWR sky130_fd_pr__pfet_01v8_hvt ad=0.26 pd=2.52 as=0.135 ps=1.27 w=1 l=0.15
X142 a_4826_1322# digital_0._118_.D VGND VGND sky130_fd_pr__nfet_01v8 ad=0.066 pd=0.745 as=0.2205 ps=1.89 w=0.42 l=0.15
X143 a_13934_3498# digital_0._102_.D VDPWR VDPWR sky130_fd_pr__pfet_01v8_hvt ad=0.0651 pd=0.73 as=0.1092 ps=1.36 w=0.42 l=0.15
X144 LELO_GR01_0.x7.x7.S LELO_GR01_0.x7.x6<3>.G LELO_GR01_0.x7.x6<3>.G VGND sky130_fd_pr__nfet_01v8_lvt ad=0.5088 pd=2.98 as=0.3168 ps=1.62 w=0.96 l=0.94
X145 VDPWR a_10721_2348# a_10708_2044# VDPWR sky130_fd_pr__pfet_01v8_hvt ad=0.0819 pd=0.81 as=0.0567 ps=0.69 w=0.42 l=0.15
X146 a_14891_930# a_14673_1334# VGND VGND sky130_fd_pr__nfet_01v8 ad=0.0999 pd=0.985 as=0.1346 ps=1.15 w=0.64 l=0.15
X147 digital_0._063_.B digital_0._069_.A a_11484_1500# VGND sky130_fd_pr__nfet_01v8 ad=0.091 pd=0.93 as=0.08937 ps=0.925 w=0.65 l=0.15
X148 a_5144_2954# a_4386_2856# a_4581_2825# VDPWR sky130_fd_pr__pfet_01v8_hvt ad=0.0651 pd=0.73 as=0.07245 ps=0.765 w=0.42 l=0.15
X149 VDPWR a_11673_412# digital_0.clkload0.X VDPWR sky130_fd_pr__pfet_01v8_hvt ad=0.3 pd=2.6 as=0.14 ps=1.28 w=1 l=0.15
X150 a_5056_n702# a_5182_n518# VGND VGND sky130_fd_pr__nfet_01v8 ad=0.17225 pd=1.83 as=0.1856 ps=1.26 w=0.65 l=0.25
X151 LELO_GR01_0.x7.x7.S LELO_GR01_0.x7.x7.G VGND VDPWR sky130_fd_pr__pfet_01v8_lvt ad=0.5088 pd=2.98 as=0.3168 ps=1.62 w=0.96 l=0.94
X152 digital_0._110_.D digital_0._067_.B a_11949_3132# VDPWR sky130_fd_pr__pfet_01v8_hvt ad=0.135 pd=1.27 as=0.135 ps=1.27 w=1 l=0.15
X153 VDPWR VGND VDPWR VDPWR sky130_fd_pr__pfet_01v8_hvt ad=0.2262 pd=2.26 as=0 ps=0 w=0.87 l=0.59
X154 a_13513_956# digital_0._063_.A VDPWR VDPWR sky130_fd_pr__pfet_01v8_hvt ad=0.135 pd=1.27 as=0.135 ps=1.27 w=1 l=0.15
X155 a_4201_3132# digital_0._117_.RESET_B VDPWR VDPWR sky130_fd_pr__pfet_01v8_hvt ad=0.1092 pd=1.36 as=0.07035 ps=0.755 w=0.42 l=0.15
X156 a_11361_n702# digital_0.output11.A VGND VGND sky130_fd_pr__nfet_01v8 ad=0.1092 pd=1.36 as=0.0567 ps=0.69 w=0.42 l=0.15
X157 VDPWR a_8996_1500# digital_0.clkbuf_1_1__f_clk.A VDPWR sky130_fd_pr__pfet_01v8_hvt ad=0.265 pd=2.53 as=0.14 ps=1.28 w=1 l=0.15
X158 VDPWR digital_0._116_.Q a_12977_2044# VDPWR sky130_fd_pr__pfet_01v8_hvt ad=0.135 pd=1.27 as=0.135 ps=1.27 w=1 l=0.15
X159 digital_0.clkload0.X a_11673_412# VDPWR VDPWR sky130_fd_pr__pfet_01v8_hvt ad=0.14 pd=1.28 as=0.14 ps=1.28 w=1 l=0.15
X160 a_4910_n132# a_4696_n132# VDPWR VDPWR sky130_fd_pr__pfet_01v8_hvt ad=0.1155 pd=0.97 as=0.07035 ps=0.755 w=0.42 l=0.15
X161 VGND VDPWR VGND VGND sky130_fd_pr__nfet_01v8 ad=0.143 pd=1.62 as=0 ps=0 w=0.55 l=0.59
X162 LELO_GR01_0.x7.x18.G LELO_GR01_0.x7.x15.I2 LELO_GR01_0.x7.x1.x5.IBN VGND sky130_fd_pr__nfet_01v8_lvt ad=0.3168 pd=1.62 as=0.5088 ps=2.98 w=0.96 l=0.94
X163 VDPWR a_15331_564# digital_0.hold23.X VDPWR sky130_fd_pr__pfet_01v8_hvt ad=0.14075 pd=1.325 as=0.26 ps=2.52 w=1 l=0.15
X164 a_13481_1474# digital_0._113_.RESET_B VDPWR VDPWR sky130_fd_pr__pfet_01v8_hvt ad=0.0567 pd=0.69 as=0.0819 ps=0.81 w=0.42 l=0.15
X165 digital_0._118_.D a_3471_1474# VGND VGND sky130_fd_pr__nfet_01v8 ad=0.12675 pd=1.04 as=0.247 ps=2.06 w=0.65 l=0.15
X166 a_11951_2146# digital_0._069_.A VDPWR VDPWR sky130_fd_pr__pfet_01v8_hvt ad=0.07438 pd=0.815 as=0.0567 ps=0.69 w=0.42 l=0.15
X167 VGND digital_0._067_.A digital_0._110_.D VGND sky130_fd_pr__nfet_01v8 ad=0.08775 pd=0.92 as=0.08775 ps=0.92 w=0.65 l=0.15
X168 VGND VDPWR VGND VGND sky130_fd_pr__nfet_01v8 ad=0.143 pd=1.62 as=0 ps=0 w=0.55 l=0.59
X169 a_15413_1260# a_15238_1334# a_15592_1322# VGND sky130_fd_pr__nfet_01v8 ad=0.1092 pd=1.36 as=0.06405 ps=0.725 w=0.42 l=0.15
X170 a_4581_2825# a_4386_2856# a_4891_2588# VGND sky130_fd_pr__special_nfet_01v8 ad=0.0594 pd=0.69 as=0.1401 ps=1.1 w=0.36 l=0.15
X171 digital_0.output4.A a_4005_n158# VGND VGND sky130_fd_pr__nfet_01v8 ad=0.08775 pd=0.92 as=0.169 ps=1.82 w=0.65 l=0.15
X172 VGND digital_0.load_slew17.X digital_0._112_.RESET_B VGND sky130_fd_pr__nfet_01v8 ad=0.169 pd=1.82 as=0.08775 ps=0.92 w=0.65 l=0.15
X173 a_10285_2910# digital_0._065_.A2_N a_10284_2588# VGND sky130_fd_pr__nfet_01v8 ad=0.1092 pd=1.36 as=0.06615 ps=0.735 w=0.42 l=0.15
X174 a_11372_412# digital_0._065_.A2_N a_11276_412# VGND sky130_fd_pr__nfet_01v8 ad=0.0798 pd=0.8 as=0.0693 ps=0.75 w=0.42 l=0.15
X175 a_14762_2018# digital_0.load_slew17.A VDPWR VDPWR sky130_fd_pr__pfet_01v8_hvt ad=0.1664 pd=1.8 as=0.149 ps=1.325 w=0.64 l=0.15
X176 a_12849_778# digital_0._112_.RESET_B VDPWR VDPWR sky130_fd_pr__pfet_01v8_hvt ad=0.1092 pd=1.36 as=0.07035 ps=0.755 w=0.42 l=0.15
X177 VDPWR a_11835_3828# digital_0.hold20.X VDPWR sky130_fd_pr__pfet_01v8_hvt ad=0.14075 pd=1.325 as=0.26 ps=2.52 w=1 l=0.15
X178 VDPWR digital_0._107_.D a_7720_n132# VDPWR sky130_fd_pr__pfet_01v8_hvt ad=0.1092 pd=1.36 as=0.0651 ps=0.73 w=0.42 l=0.15
X179 VGND a_11361_n702# a_11103_n702# VGND sky130_fd_pr__nfet_01v8 ad=0.0567 pd=0.69 as=0.1092 ps=1.36 w=0.42 l=0.5
X180 VDPWR a_11951_2146# digital_0._063_.A VDPWR sky130_fd_pr__pfet_01v8_hvt ad=0.26 pd=2.52 as=0.135 ps=1.27 w=1 l=0.15
X181 LELO_GR01_0.x7.x1.x5.x8.G LELO_GR01_0.x7.x1.x5.x9<2>.G VGND VGND sky130_fd_pr__nfet_01v8_lvt ad=0.3168 pd=1.62 as=0.5088 ps=2.98 w=0.96 l=0.94
X182 VGND digital_0.load_slew17.A digital_0._110_.RESET_B VGND sky130_fd_pr__nfet_01v8 ad=0.08775 pd=0.92 as=0.08775 ps=0.92 w=0.65 l=0.15
X183 VGND a_6687_n676# a_6793_n676# VGND sky130_fd_pr__nfet_01v8 ad=0.097 pd=0.975 as=0.1092 ps=1.36 w=0.42 l=0.5
X184 VDPWR LELO_GR01_0.x7.x18.G LELO_GR01_0.x7.x15.I2 VDPWR sky130_fd_pr__pfet_01v8_lvt ad=0.5088 pd=2.98 as=0.3168 ps=1.62 w=0.96 l=0.94
X185 VGND digital_0.load_slew17.X digital_0._106_.RESET_B VGND sky130_fd_pr__nfet_01v8 ad=0.169 pd=1.82 as=0.08775 ps=0.92 w=0.65 l=0.15
X186 a_4108_2840# a_4425_2730# a_4383_2588# VGND sky130_fd_pr__special_nfet_01v8 ad=0.0711 pd=0.755 as=0.0669 ps=0.75 w=0.36 l=0.15
X187 VDPWR a_11673_412# digital_0.clkload0.X VDPWR sky130_fd_pr__pfet_01v8_hvt ad=0.14 pd=1.28 as=0.14 ps=1.28 w=1 l=0.15
X188 digital_0.input2.X a_8689_n132# VDPWR VDPWR sky130_fd_pr__pfet_01v8_hvt ad=0.495 pd=2.99 as=0.2726 ps=1.61 w=1 l=0.15
X189 a_12517_2044# digital_0._110_.Q VDPWR VDPWR sky130_fd_pr__pfet_01v8_hvt ad=0.28 pd=2.56 as=0.135 ps=1.27 w=1 l=0.15
X190 a_15537_n426# digital_0.load_slew17.X digital_0._112_.RESET_B VDPWR sky130_fd_pr__pfet_01v8_hvt ad=0.26 pd=2.52 as=0.135 ps=1.27 w=1 l=0.15
X191 VGND a_13481_386# a_13415_412# VGND sky130_fd_pr__nfet_01v8 ad=0.12495 pd=1.015 as=0.0669 ps=0.75 w=0.42 l=0.15
X192 a_11276_412# digital_0._057_.D VGND VGND sky130_fd_pr__nfet_01v8 ad=0.0693 pd=0.75 as=0.17515 ps=1.265 w=0.42 l=0.15
X193 VDPWR a_9463_654# a_9353_778# VDPWR sky130_fd_pr__pfet_01v8_hvt ad=0.07035 pd=0.755 as=0.1155 ps=0.97 w=0.42 l=0.15
X194 VDPWR a_11431_2382# digital_0._065_.A2_N VDPWR sky130_fd_pr__pfet_01v8_hvt ad=0.38 pd=2.76 as=0.195 ps=1.39 w=1 l=0.15
X195 LELO_GR01_0.x8.x1.x5.x9<2>.G LELO_GR01_0.x8.x1.x5.x8.G LELO_GR01_0.x8.x1.x5.x3.S LELO_GR01_0.x8.x1.x5.x3.S sky130_fd_pr__pfet_01v8_lvt ad=0.3168 pd=1.62 as=0.5088 ps=2.98 w=0.96 l=0.94
X196 VGND VGND LELO_GR01_0.x7.x28.e sky130_fd_pr__pnp_05v5_W3p40L3p40
**devattr s=462400,2720
X197 a_6397_n158# a_6684_0# VDPWR VDPWR sky130_fd_pr__pfet_01v8_hvt ad=0.0567 pd=0.69 as=0.1134 ps=1.38 w=0.42 l=0.15
X198 VDPWR a_9985_386# digital_0._114_.Q VDPWR sky130_fd_pr__pfet_01v8_hvt ad=0.26 pd=2.52 as=0.135 ps=1.27 w=1 l=0.15
X199 VDPWR digital_0.load_slew17.A digital_0._104_.RESET_B VDPWR sky130_fd_pr__pfet_01v8_hvt ad=0.26 pd=2.52 as=0.135 ps=1.27 w=1 l=0.15
X200 a_5159_1474# digital_0.hold28.A VGND VGND sky130_fd_pr__nfet_01v8 ad=0.1092 pd=1.36 as=0.1449 ps=1.11 w=0.42 l=0.15
X201 a_12646_1500# digital_0._113_.D VGND VGND sky130_fd_pr__nfet_01v8 ad=0.066 pd=0.745 as=0.2205 ps=1.89 w=0.42 l=0.15
X202 a_13110_3498# digital_0._110_.Q a_12889_3171# VGND sky130_fd_pr__nfet_01v8 ad=0.0693 pd=0.75 as=0.09975 ps=0.895 w=0.42 l=0.15
X203 VDPWR digital_0._116_.Q a_15537_n132# VDPWR sky130_fd_pr__pfet_01v8_hvt ad=0.135 pd=1.27 as=0.28 ps=2.56 w=1 l=0.15
X204 digital_0._067_.B digital_0._110_.Q VGND VGND sky130_fd_pr__nfet_01v8 ad=0.08775 pd=0.92 as=0.08775 ps=0.92 w=0.65 l=0.15
X205 a_15040_234# digital_0._105_.RESET_B VGND VGND sky130_fd_pr__nfet_01v8 ad=0.06405 pd=0.725 as=0.12495 ps=1.015 w=0.42 l=0.15
X206 digital_0.clkbuf_1_1__f_clk.A a_8996_1500# VDPWR VDPWR sky130_fd_pr__pfet_01v8_hvt ad=0.14 pd=1.28 as=0.14 ps=1.28 w=1 l=0.15
X207 VGND VDPWR VGND VGND sky130_fd_pr__nfet_01v8 ad=0.143 pd=1.62 as=0 ps=0 w=0.55 l=0.59
X208 a_14624_386# a_14750_570# VGND VGND sky130_fd_pr__nfet_01v8 ad=0.17225 pd=1.83 as=0.1856 ps=1.26 w=0.65 l=0.25
X209 digital_0.clkload0.A a_11388_956# VGND VGND sky130_fd_pr__nfet_01v8 ad=0.0588 pd=0.7 as=0.0588 ps=0.7 w=0.42 l=0.15
X210 VGND digital_0.clkload0.A a_14157_962# VGND sky130_fd_pr__nfet_01v8 ad=0.0567 pd=0.69 as=0.1092 ps=1.36 w=0.42 l=0.15
X211 VGND VDPWR VGND VGND sky130_fd_pr__nfet_01v8 ad=0.143 pd=1.62 as=0 ps=0 w=0.55 l=0.59
X212 a_3492_n702# a_3618_n518# VGND VGND sky130_fd_pr__nfet_01v8 ad=0.17225 pd=1.83 as=0.1856 ps=1.26 w=0.65 l=0.25
X213 digital_0._114_.RESET_B digital_0.load_slew15.A a_9005_956# VDPWR sky130_fd_pr__pfet_01v8_hvt ad=0.135 pd=1.27 as=0.135 ps=1.27 w=1 l=0.15
X214 a_9631_2050# a_9465_2050# VGND VGND sky130_fd_pr__nfet_01v8 ad=0.1092 pd=1.36 as=0.0567 ps=0.69 w=0.42 l=0.15
X215 a_11107_2562# digital_0._110_.Q a_11353_2616# VGND sky130_fd_pr__nfet_01v8 ad=0.1176 pd=1.4 as=0.0567 ps=0.69 w=0.42 l=0.15
X216 VDPWR digital_0.input1.X a_8729_412# VDPWR sky130_fd_pr__pfet_01v8_hvt ad=0.0864 pd=0.91 as=0.1664 ps=1.8 w=0.64 l=0.15
X217 VGND VDPWR VGND VGND sky130_fd_pr__nfet_01v8 ad=0.143 pd=1.62 as=0 ps=0 w=0.55 l=0.59
X218 VDPWR a_13481_1474# a_13468_1866# VDPWR sky130_fd_pr__pfet_01v8_hvt ad=0.0819 pd=0.81 as=0.0567 ps=0.69 w=0.42 l=0.15
X219 a_7055_2588# a_6889_2588# VDPWR VDPWR sky130_fd_pr__pfet_01v8_hvt ad=0.1664 pd=1.8 as=0.0864 ps=0.91 w=0.64 l=0.15
X220 a_6684_0# a_7001_110# a_6959_234# VGND sky130_fd_pr__special_nfet_01v8 ad=0.0711 pd=0.755 as=0.0669 ps=0.75 w=0.36 l=0.15
X221 a_14990_386# digital_0.rst VDPWR VDPWR sky130_fd_pr__pfet_01v8_hvt ad=0.27 pd=2.54 as=0.19265 ps=1.415 w=1 l=0.15
X222 a_5003_234# digital_0._119_.RESET_B VGND VGND sky130_fd_pr__nfet_01v8 ad=0.0441 pd=0.63 as=0.1346 ps=1.15 w=0.42 l=0.15
X223 LELO_GR01_0.x7.x18.G LELO_GR01_0.x7.x18.D LELO_GR01_0.x7.x6<3>.G VGND sky130_fd_pr__nfet_01v8_lvt ad=0.3168 pd=1.62 as=0.5088 ps=2.98 w=0.96 l=0.94
X224 a_6906_3132# digital_0._108_.Q a_6235_3106# VDPWR sky130_fd_pr__pfet_01v8_hvt ad=0.135 pd=1.27 as=0.135 ps=1.27 w=1 l=0.15
X225 a_6687_n676# a_6451_n676# VGND VGND sky130_fd_pr__nfet_01v8 ad=0.1092 pd=1.36 as=0.0567 ps=0.69 w=0.42 l=0.5
X226 VGND a_8085_1500# digital_0.load_slew15.X VGND sky130_fd_pr__nfet_01v8 ad=0.169 pd=1.82 as=0.08775 ps=0.92 w=0.65 l=0.15
X227 LELO_GR01_0.x7.x18.G LELO_GR01_0.PWRUP_1V8 VDPWR VDPWR sky130_fd_pr__pfet_01v8_lvt ad=0.3168 pd=1.62 as=0.5088 ps=2.98 w=0.96 l=0.94
X228 VGND digital_0.clkload0.A a_11673_412# VGND sky130_fd_pr__nfet_01v8 ad=0.07035 pd=0.755 as=0.1113 ps=1.37 w=0.42 l=0.15
X229 LELO_GR01_0.x7.x1.x5.x9<2>.G LELO_GR01_0.x8.PWRUP_N_1V8 VGND VGND sky130_fd_pr__nfet_01v8_lvt ad=0.3168 pd=1.62 as=0.5088 ps=2.98 w=0.96 l=0.94
X230 a_14871_n524# a_14967_n702# VDPWR VDPWR sky130_fd_pr__pfet_01v8_hvt ad=0.1092 pd=1.36 as=0.14075 ps=1.325 w=0.42 l=0.5
X231 a_4610_386# a_4530_626# a_5014_412# VGND sky130_fd_pr__special_nfet_01v8 ad=0.072 pd=0.76 as=0.06705 ps=0.75 w=0.36 l=0.15
X232 VDPWR a_11107_2562# digital_0._067_.A VDPWR sky130_fd_pr__pfet_01v8_hvt ad=0.16655 pd=1.39 as=0.195 ps=1.39 w=1 l=0.15
X233 a_6179_3132# digital_0.output13.A VDPWR VDPWR sky130_fd_pr__pfet_01v8_hvt ad=0.26 pd=2.52 as=0.135 ps=1.27 w=1 l=0.15
X234 a_3492_3650# a_3618_3834# VDPWR VDPWR sky130_fd_pr__pfet_01v8_hvt ad=0.2173 pd=2.17 as=0.2726 ps=1.61 w=0.82 l=0.25
X235 a_7667_2588# a_7623_2830# a_7501_2588# VGND sky130_fd_pr__nfet_01v8 ad=0.0441 pd=0.63 as=0.1401 ps=1.1 w=0.42 l=0.15
X236 VDPWR digital_0.clkbuf_1_1__f_clk.A a_11388_956# VDPWR sky130_fd_pr__pfet_01v8_hvt ad=0.14 pd=1.28 as=0.14 ps=1.28 w=1 l=0.15
X237 VGND digital_0.output9.A a_15445_2044# VGND sky130_fd_pr__nfet_01v8 ad=0.1228 pd=1.065 as=0.1134 ps=1.38 w=0.42 l=0.15
X238 a_3982_386# digital_0._116_.SET_B VDPWR VDPWR sky130_fd_pr__pfet_01v8_hvt ad=0.1092 pd=1.36 as=0.12075 ps=1.165 w=0.42 l=0.15
X239 VGND a_14727_1474# a_14661_1500# VGND sky130_fd_pr__nfet_01v8 ad=0.1449 pd=1.11 as=0.0693 ps=0.75 w=0.42 l=0.15
X240 a_15685_386# digital_0.output9.A VGND VGND sky130_fd_pr__nfet_01v8 ad=0.1092 pd=1.36 as=0.0567 ps=0.69 w=0.42 l=0.15
X241 VGND a_10721_172# digital_0.output11.A VGND sky130_fd_pr__nfet_01v8 ad=0.169 pd=1.82 as=0.08775 ps=0.92 w=0.65 l=0.15
X242 digital_0.hold26.X a_6793_n676# VGND VGND sky130_fd_pr__nfet_01v8 ad=0.169 pd=1.82 as=0.097 ps=0.975 w=0.65 l=0.15
X243 VDPWR a_5139_930# a_5029_956# VDPWR sky130_fd_pr__pfet_01v8_hvt ad=0.07035 pd=0.755 as=0.1155 ps=0.97 w=0.42 l=0.15
X244 LELO_GR01_0.x8.IBP_BG LELO_GR01_0.x8.PWRUP_N_1V8 VGND VGND sky130_fd_pr__nfet_01v8_lvt ad=0.3168 pd=1.62 as=0.5088 ps=2.98 w=0.96 l=0.94
X245 VGND digital_0.load_slew15.A digital_0._108_.RESET_B VGND sky130_fd_pr__nfet_01v8 ad=0.08775 pd=0.92 as=0.08775 ps=0.92 w=0.65 l=0.15
X246 VGND digital_0.output13.A a_6455_3452# VGND sky130_fd_pr__nfet_01v8 ad=0.08775 pd=0.92 as=0.08775 ps=0.92 w=0.65 l=0.15
X247 VDPWR a_8996_1500# digital_0.clkbuf_1_1__f_clk.A VDPWR sky130_fd_pr__pfet_01v8_hvt ad=0.14 pd=1.28 as=0.14 ps=1.28 w=1 l=0.15
X248 LELO_GR01_0.x8.x1.x5.x8.S LELO_GR01_0.x8.x1.x5.x8.G LELO_GR01_0.x8.x1.x5.x8.G LELO_GR01_0.x8.x1.x5.x8.S sky130_fd_pr__pfet_01v8_lvt ad=0.5088 pd=2.98 as=0.3168 ps=1.62 w=0.96 l=0.94
X249 a_6209_386# digital_0.output6.A VDPWR VDPWR sky130_fd_pr__pfet_01v8_hvt ad=0.1092 pd=1.36 as=0.0567 ps=0.69 w=0.42 l=0.15
X250 a_7593_2348# digital_0._108_.RESET_B VDPWR VDPWR sky130_fd_pr__pfet_01v8_hvt ad=0.0567 pd=0.69 as=0.0819 ps=0.81 w=0.42 l=0.15
X251 a_6503_2050# a_6337_2050# VDPWR VDPWR sky130_fd_pr__pfet_01v8_hvt ad=0.1664 pd=1.8 as=0.0864 ps=0.91 w=0.64 l=0.15
X252 digital_0._065_.A2_N a_11431_2382# VDPWR VDPWR sky130_fd_pr__pfet_01v8_hvt ad=0.195 pd=1.39 as=0.16655 ps=1.39 w=1 l=0.15
X253 VGND digital_0.input1.X a_11673_2588# VGND sky130_fd_pr__nfet_01v8 ad=0.0567 pd=0.69 as=0.1092 ps=1.36 w=0.42 l=0.15
X254 VDPWR VGND VDPWR VDPWR sky130_fd_pr__pfet_01v8_hvt ad=0.2262 pd=2.26 as=0 ps=0 w=0.87 l=0.59
X255 a_4921_1334# a_4571_962# a_4826_1322# VDPWR sky130_fd_pr__pfet_01v8_hvt ad=0.07245 pd=0.765 as=0.0651 ps=0.73 w=0.42 l=0.15
X256 a_11517_2382# digital_0._111_.Q a_11431_2382# VGND sky130_fd_pr__nfet_01v8 ad=0.0567 pd=0.69 as=0.1176 ps=1.4 w=0.42 l=0.15
X257 a_10571_2588# a_10285_2910# a_10074_2562# VGND sky130_fd_pr__nfet_01v8 ad=0.0567 pd=0.69 as=0.1092 ps=1.36 w=0.42 l=0.15
X258 digital_0.hold26.X a_6793_n676# VDPWR VDPWR sky130_fd_pr__pfet_01v8_hvt ad=0.26 pd=2.52 as=0.14075 ps=1.325 w=1 l=0.15
X259 a_9564_930# a_9690_1194# VGND VGND sky130_fd_pr__nfet_01v8 ad=0.17225 pd=1.83 as=0.1856 ps=1.26 w=0.65 l=0.25
X260 VGND digital_0._103_.RESET_B a_10795_3498# VGND sky130_fd_pr__nfet_01v8 ad=0.1346 pd=1.15 as=0.0441 ps=0.63 w=0.42 l=0.15
X261 LELO_GR01_0.x8.x1.x5.x9<2>.G LELO_GR01_0.x8.PWRUP_N_1V8 VGND VGND sky130_fd_pr__nfet_01v8_lvt ad=0.3168 pd=1.62 as=0.5088 ps=2.98 w=0.96 l=0.94
X262 LELO_GR01_0.x7.x6<3>.G LELO_GR01_0.x7.x6<3>.G LELO_GR01_0.x7.x7.S VGND sky130_fd_pr__nfet_01v8_lvt ad=0.3168 pd=1.62 as=0.5088 ps=2.98 w=0.96 l=0.94
X263 VDPWR a_3858_n702# a_3618_n518# VDPWR sky130_fd_pr__pfet_01v8_hvt ad=0.19265 pd=1.415 as=0.2173 ps=2.17 w=0.82 l=0.25
X264 LELO_GR01_0.x7.x1.x5.x8.S LELO_GR01_0.x7.x1.x5.x8.G LELO_GR01_0.x7.x1.x5.x8.G LELO_GR01_0.x7.x1.x5.x8.S sky130_fd_pr__pfet_01v8_lvt ad=0.5088 pd=2.98 as=0.3168 ps=1.62 w=0.96 l=0.94
X265 VGND a_5215_3676# a_5321_3676# VGND sky130_fd_pr__nfet_01v8 ad=0.097 pd=0.975 as=0.1092 ps=1.36 w=0.42 l=0.5
X266 a_13415_412# a_12225_412# a_13306_412# VGND sky130_fd_pr__special_nfet_01v8 ad=0.0669 pd=0.75 as=0.0711 ps=0.755 w=0.36 l=0.15
X267 VGND LELO_GR01_0.x8.PWRUP_N_1V8 LELO_GR01_0.x8.x7.D VGND sky130_fd_pr__nfet_01v8_lvt ad=0.5088 pd=2.98 as=0.3168 ps=1.62 w=0.96 l=0.94
X268 a_4819_2588# digital_0._100_.RESET_B VGND VGND sky130_fd_pr__nfet_01v8 ad=0.0441 pd=0.63 as=0.1346 ps=1.15 w=0.42 l=0.15
X269 a_8996_1500# clk VDPWR VDPWR sky130_fd_pr__pfet_01v8_hvt ad=0.14 pd=1.28 as=0.265 ps=2.53 w=1 l=0.15
X270 VGND digital_0._116_.Q digital_0._111_.RESET_B VGND sky130_fd_pr__nfet_01v8 ad=0.08775 pd=0.92 as=0.08775 ps=0.92 w=0.65 l=0.15
X271 VGND a_15225_n702# a_14967_n702# VGND sky130_fd_pr__nfet_01v8 ad=0.0567 pd=0.69 as=0.1092 ps=1.36 w=0.42 l=0.5
X272 VGND a_15662_2044# a_15773_2044# VGND sky130_fd_pr__nfet_01v8 ad=0.1856 pd=1.26 as=0.17225 ps=1.83 w=0.65 l=0.25
X273 a_10839_1276# digital_0._112_.Q a_10723_1276# VGND sky130_fd_pr__nfet_01v8 ad=0.08775 pd=0.92 as=0.13975 ps=1.08 w=0.65 l=0.15
X274 VGND a_13481_1474# digital_0._113_.Q VGND sky130_fd_pr__nfet_01v8 ad=0.169 pd=1.82 as=0.08775 ps=0.92 w=0.65 l=0.15
X275 digital_0._060_.A_N a_10997_386# VGND VGND sky130_fd_pr__nfet_01v8 ad=0.10725 pd=0.98 as=0.195 ps=1.9 w=0.65 l=0.15
X276 VDPWR a_11388_956# digital_0.clkload0.A VDPWR sky130_fd_pr__pfet_01v8_hvt ad=0.14 pd=1.28 as=0.14 ps=1.28 w=1 l=0.15
X277 digital_0._067_.A a_11107_2562# VDPWR VDPWR sky130_fd_pr__pfet_01v8_hvt ad=0.195 pd=1.39 as=0.38 ps=2.76 w=1 l=0.15
X278 a_5215_3676# a_4979_3676# VDPWR VDPWR sky130_fd_pr__pfet_01v8_hvt ad=0.1092 pd=1.36 as=0.0567 ps=0.69 w=0.42 l=0.5
X279 VGND a_10721_172# a_10655_246# VGND sky130_fd_pr__nfet_01v8 ad=0.12495 pd=1.015 as=0.0669 ps=0.75 w=0.42 l=0.15
X280 a_11655_1500# digital_0._069_.A digital_0._063_.B VGND sky130_fd_pr__nfet_01v8 ad=0.06825 pd=0.86 as=0.091 ps=0.93 w=0.65 l=0.15
X281 VDPWR LELO_GR01_0.PWRUP_1V8 LELO_GR01_0.x7.x1.x7.D VDPWR sky130_fd_pr__pfet_01v8_lvt ad=0.5088 pd=2.98 as=0.3168 ps=1.62 w=0.96 l=0.94
X282 a_11007_n524# a_11103_n702# VDPWR VDPWR sky130_fd_pr__pfet_01v8_hvt ad=0.1092 pd=1.36 as=0.14075 ps=1.325 w=0.42 l=0.5
X283 VDPWR a_7961_386# digital_0._115_.Q VDPWR sky130_fd_pr__pfet_01v8_hvt ad=0.26 pd=2.52 as=0.135 ps=1.27 w=1 l=0.15
X284 a_7088_n132# a_7001_110# a_6684_0# VDPWR sky130_fd_pr__pfet_01v8_hvt ad=0.12915 pd=1.185 as=0.0588 ps=0.7 w=0.42 l=0.15
X285 VDPWR a_9930_930# a_9690_1194# VDPWR sky130_fd_pr__pfet_01v8_hvt ad=0.19265 pd=1.415 as=0.2173 ps=2.17 w=0.82 l=0.25
X286 a_12391_412# a_12225_412# VGND VGND sky130_fd_pr__nfet_01v8 ad=0.1092 pd=1.36 as=0.0567 ps=0.69 w=0.42 l=0.15
X287 VDPWR digital_0._065_.A2_N a_10555_956# VDPWR sky130_fd_pr__pfet_01v8_hvt ad=0.135 pd=1.27 as=0.135 ps=1.27 w=1 l=0.15
X288 digital_0._111_.D a_10074_2562# VDPWR VDPWR sky130_fd_pr__pfet_01v8_hvt ad=0.135 pd=1.27 as=0.285 ps=2.57 w=1 l=0.15
X289 a_7513_2954# digital_0._109_.RESET_B VDPWR VDPWR sky130_fd_pr__pfet_01v8_hvt ad=0.1092 pd=1.36 as=0.07035 ps=0.755 w=0.42 l=0.15
X290 a_5139_930# a_4921_1334# VDPWR VDPWR sky130_fd_pr__pfet_01v8_hvt ad=0.12915 pd=1.185 as=0.2184 ps=2.2 w=0.84 l=0.15
X291 VGND digital_0._116_.Q digital_0._115_.RESET_B VGND sky130_fd_pr__nfet_01v8 ad=0.08775 pd=0.92 as=0.08775 ps=0.92 w=0.65 l=0.15
X292 VGND digital_0._116_.Q digital_0._113_.RESET_B VGND sky130_fd_pr__nfet_01v8 ad=0.08775 pd=0.92 as=0.08775 ps=0.92 w=0.65 l=0.15
X293 VGND digital_0.load_slew15.X digital_0._101_.RESET_B VGND sky130_fd_pr__nfet_01v8 ad=0.169 pd=1.82 as=0.08775 ps=0.92 w=0.65 l=0.15
X294 a_5288_2410# digital_0._101_.RESET_B VGND VGND sky130_fd_pr__nfet_01v8 ad=0.06405 pd=0.725 as=0.12495 ps=1.015 w=0.42 l=0.15
X295 VDPWR a_7593_2348# a_7580_2044# VDPWR sky130_fd_pr__pfet_01v8_hvt ad=0.0819 pd=0.81 as=0.0567 ps=0.69 w=0.42 l=0.15
X296 VDPWR a_4228_3650# uo_out<1> VDPWR sky130_fd_pr__pfet_01v8_hvt ad=0.2726 pd=1.61 as=0.495 ps=2.99 w=1 l=0.15
X297 VDPWR a_4610_386# a_4668_778# VDPWR sky130_fd_pr__pfet_01v8_hvt ad=0.0567 pd=0.69 as=0.0441 ps=0.63 w=0.42 l=0.15
X298 a_8145_2562# digital_0._109_.RESET_B VDPWR VDPWR sky130_fd_pr__pfet_01v8_hvt ad=0.0567 pd=0.69 as=0.0819 ps=0.81 w=0.42 l=0.15
R1 uio_oe<0> li_28516_19376# sky130_fd_pr__res_generic_m4 w=0.3 l=0.3
X299 uio_out<4> a_15773_2044# VGND VGND sky130_fd_pr__nfet_01v8 ad=0.2079 pd=1.83 as=0.1856 ps=1.26 w=0.42 l=0.15
X300 a_14756_3132# a_13679_3138# a_14594_3510# VDPWR sky130_fd_pr__pfet_01v8_hvt ad=0.0567 pd=0.69 as=0.0588 ps=0.7 w=0.42 l=0.15
X301 VGND digital_0._116_.Q digital_0._112_.RESET_B VGND sky130_fd_pr__nfet_01v8 ad=0.08775 pd=0.92 as=0.08775 ps=0.92 w=0.65 l=0.15
X302 VGND a_3821_2562# digital_0.output5.A VGND sky130_fd_pr__nfet_01v8 ad=0.2087 pd=2.02 as=0.08775 ps=0.92 w=0.65 l=0.15
X303 LELO_GR01_0.x7.x7.S LELO_GR01_0.x7.x6<3>.G LELO_GR01_0.x7.x6<3>.G VGND sky130_fd_pr__nfet_01v8_lvt ad=0.5088 pd=2.98 as=0.3168 ps=1.62 w=0.96 l=0.94
X304 VDPWR a_6397_n158# digital_0.output12.A VDPWR sky130_fd_pr__pfet_01v8_hvt ad=0.3012 pd=2.66 as=0.135 ps=1.27 w=1 l=0.15
X305 VDPWR a_7157_n158# a_7088_n132# VDPWR sky130_fd_pr__pfet_01v8_hvt ad=0.2184 pd=2.2 as=0.12915 ps=1.185 w=0.84 l=0.15
X306 VGND LELO_GR01_0.x7.x1.x5.x9<2>.G LELO_GR01_0.x7.x1.x5.x9<2>.G VGND sky130_fd_pr__nfet_01v8_lvt ad=0.5088 pd=2.98 as=0.3168 ps=1.62 w=0.96 l=0.94
X307 digital_0._102_.RESET_B digital_0.load_slew17.A VGND VGND sky130_fd_pr__nfet_01v8 ad=0.08775 pd=0.92 as=0.169 ps=1.82 w=0.65 l=0.15
X308 a_12741_1500# a_12225_1500# a_12646_1500# VGND sky130_fd_pr__special_nfet_01v8 ad=0.0594 pd=0.69 as=0.066 ps=0.745 w=0.36 l=0.15
X309 a_13679_3138# a_13513_3138# VDPWR VDPWR sky130_fd_pr__pfet_01v8_hvt ad=0.1664 pd=1.8 as=0.0864 ps=0.91 w=0.64 l=0.15
X310 VGND a_7155_930# digital_0._115_.D VGND sky130_fd_pr__nfet_01v8 ad=0.169 pd=1.82 as=0.08775 ps=0.92 w=0.65 l=0.15
X311 digital_0._106_.RESET_B digital_0.load_slew17.X VGND VGND sky130_fd_pr__nfet_01v8 ad=0.08775 pd=0.92 as=0.169 ps=1.82 w=0.65 l=0.15
X312 VDPWR a_12754_2588# a_12929_2562# VDPWR sky130_fd_pr__pfet_01v8_hvt ad=0.1134 pd=1.38 as=0.0567 ps=0.69 w=0.42 l=0.15
X313 VDPWR a_14861_172# a_14848_n132# VDPWR sky130_fd_pr__pfet_01v8_hvt ad=0.0819 pd=0.81 as=0.0567 ps=0.69 w=0.42 l=0.15
X314 VGND VDPWR VGND VGND sky130_fd_pr__nfet_01v8 ad=0.143 pd=1.62 as=0 ps=0 w=0.55 l=0.59
X315 a_14319_3828# a_14415_3650# VGND VGND sky130_fd_pr__nfet_01v8 ad=0.1092 pd=1.36 as=0.097 ps=0.975 w=0.42 l=0.5
X316 a_10641_3132# digital_0._103_.RESET_B VDPWR VDPWR sky130_fd_pr__pfet_01v8_hvt ad=0.1092 pd=1.36 as=0.07035 ps=0.755 w=0.42 l=0.15
X317 VGND digital_0._113_.Q a_11758_188# VGND sky130_fd_pr__nfet_01v8 ad=0.08775 pd=0.92 as=0.08775 ps=0.92 w=0.65 l=0.15
X318 VDPWR a_12959_654# a_12849_778# VDPWR sky130_fd_pr__pfet_01v8_hvt ad=0.07035 pd=0.755 as=0.1155 ps=0.97 w=0.42 l=0.15
X319 a_12517_2044# digital_0._069_.A digital_0._067_.B VDPWR sky130_fd_pr__pfet_01v8_hvt ad=0.135 pd=1.27 as=0.135 ps=1.27 w=1 l=0.15
X320 digital_0._114_.Q a_9985_386# VDPWR VDPWR sky130_fd_pr__pfet_01v8_hvt ad=0.135 pd=1.27 as=0.3012 ps=2.66 w=1 l=0.15
X321 a_15537_n426# digital_0._116_.Q VDPWR VDPWR sky130_fd_pr__pfet_01v8_hvt ad=0.135 pd=1.27 as=0.135 ps=1.27 w=1 l=0.15
X322 a_12959_1742# a_12741_1500# VGND VGND sky130_fd_pr__nfet_01v8 ad=0.0999 pd=0.985 as=0.1346 ps=1.15 w=0.64 l=0.15
X323 a_13746_n524# digital_0.hold27.X a_13888_n349# VDPWR sky130_fd_pr__pfet_01v8_hvt ad=0.1932 pd=1.34 as=0.07665 ps=0.785 w=0.42 l=0.15
X324 a_14781_956# a_14157_962# a_14673_1334# VDPWR sky130_fd_pr__pfet_01v8_hvt ad=0.1155 pd=0.97 as=0.07245 ps=0.765 w=0.42 l=0.15
X325 LELO_GR01_0.x7.x20.D LELO_GR01_0.x8.PWRUP_N_1V8 LELO_GR01_0.x7.x19.D VDPWR sky130_fd_pr__pfet_01v8_lvt ad=0.5088 pd=2.98 as=0.3168 ps=1.62 w=0.96 l=0.94
X326 VGND digital_0.load_slew15.X digital_0._100_.RESET_B VGND sky130_fd_pr__nfet_01v8 ad=0.169 pd=1.82 as=0.08775 ps=0.92 w=0.65 l=0.15
X327 a_9151_n702# a_9417_n702# a_9363_n676# VGND sky130_fd_pr__nfet_01v8 ad=0.1092 pd=1.36 as=0.0567 ps=0.69 w=0.42 l=0.15
X328 a_13612_3650# a_13738_3834# VDPWR VDPWR sky130_fd_pr__pfet_01v8_hvt ad=0.2173 pd=2.17 as=0.2726 ps=1.61 w=0.82 l=0.25
X329 VGND a_5159_1474# a_5093_1500# VGND sky130_fd_pr__nfet_01v8 ad=0.1449 pd=1.11 as=0.0693 ps=0.75 w=0.42 l=0.15
X330 LELO_GR01_0.x7.x7.S LELO_GR01_0.x7.x6<3>.G LELO_GR01_0.x7.x6<3>.G VGND sky130_fd_pr__nfet_01v8_lvt ad=0.5088 pd=2.98 as=0.3168 ps=1.62 w=0.96 l=0.94
X331 VDPWR VGND VDPWR VDPWR sky130_fd_pr__pfet_01v8_hvt ad=0.2262 pd=2.26 as=0 ps=0 w=0.87 l=0.59
X332 a_4696_n132# a_4609_110# a_4292_0# VDPWR sky130_fd_pr__pfet_01v8_hvt ad=0.12915 pd=1.185 as=0.0588 ps=0.7 w=0.42 l=0.15
X333 a_4730_1652# digital_0._109_.Q a_4872_1500# VGND sky130_fd_pr__nfet_01v8 ad=0.09975 pd=0.895 as=0.0693 ps=0.75 w=0.42 l=0.15
X334 VGND digital_0.hold28.A a_12635_3171# VGND sky130_fd_pr__nfet_01v8 ad=0.1449 pd=1.11 as=0.1092 ps=1.36 w=0.42 l=0.15
R2 uio_oe<5> li_28516_19376# sky130_fd_pr__res_generic_m4 w=0.3 l=0.3
X335 digital_0._067_.B digital_0._069_.A VGND VGND sky130_fd_pr__nfet_01v8 ad=0.08775 pd=0.92 as=0.169 ps=1.82 w=0.65 l=0.15
X336 a_12094_2588# digital_0._110_.D VDPWR VDPWR sky130_fd_pr__pfet_01v8_hvt ad=0.0651 pd=0.73 as=0.1092 ps=1.36 w=0.42 l=0.15
X337 VGND VDPWR VGND VGND sky130_fd_pr__nfet_01v8 ad=0.143 pd=1.62 as=0 ps=0 w=0.55 l=0.59
X338 VGND LELO_GR01_0.x7.x1.x5.x9<2>.G LELO_GR01_0.x7.x1.x5.IBN VGND sky130_fd_pr__nfet_01v8_lvt ad=0.5088 pd=2.98 as=0.3168 ps=1.62 w=0.96 l=0.94
X339 VGND a_6235_3106# digital_0._108_.D VGND sky130_fd_pr__nfet_01v8 ad=0.169 pd=1.82 as=0.08775 ps=0.92 w=0.65 l=0.15
X340 a_10555_956# digital_0._113_.Q VDPWR VDPWR sky130_fd_pr__pfet_01v8_hvt ad=0.26 pd=2.52 as=0.135 ps=1.27 w=1 l=0.15
X341 a_9005_956# digital_0._116_.Q VDPWR VDPWR sky130_fd_pr__pfet_01v8_hvt ad=0.135 pd=1.27 as=0.135 ps=1.27 w=1 l=0.15
X342 a_6235_3106# digital_0._108_.Q a_6906_3132# VDPWR sky130_fd_pr__pfet_01v8_hvt ad=0.135 pd=1.27 as=0.26 ps=2.52 w=1 l=0.15
X343 a_7221_412# a_6871_412# a_7126_412# VDPWR sky130_fd_pr__pfet_01v8_hvt ad=0.07245 pd=0.765 as=0.0651 ps=0.73 w=0.42 l=0.15
X344 VDPWR VGND VDPWR VDPWR sky130_fd_pr__pfet_01v8_hvt ad=0.2262 pd=2.26 as=0 ps=0 w=0.87 l=0.59
X345 a_6853_2422# a_6337_2050# a_6758_2410# VGND sky130_fd_pr__special_nfet_01v8 ad=0.0594 pd=0.69 as=0.066 ps=0.745 w=0.36 l=0.15
X346 VGND a_11388_956# digital_0.clkload0.A VGND sky130_fd_pr__nfet_01v8 ad=0.0588 pd=0.7 as=0.0588 ps=0.7 w=0.42 l=0.15
X347 digital_0.clkbuf_1_1__f_clk.A a_8996_1500# VGND VGND sky130_fd_pr__nfet_01v8 ad=0.0588 pd=0.7 as=0.05775 ps=0.695 w=0.42 l=0.15
X348 a_11273_3436# digital_0._103_.RESET_B VDPWR VDPWR sky130_fd_pr__pfet_01v8_hvt ad=0.0567 pd=0.69 as=0.0819 ps=0.81 w=0.42 l=0.15
X349 a_14339_n158# a_14121_246# VGND VGND sky130_fd_pr__nfet_01v8 ad=0.0999 pd=0.985 as=0.1346 ps=1.15 w=0.64 l=0.15
X350 a_4342_2954# a_3821_2562# VDPWR VDPWR sky130_fd_pr__pfet_01v8_hvt ad=0.0567 pd=0.69 as=0.0819 ps=0.81 w=0.42 l=0.15
X351 VDPWR a_4015_1652# digital_0.hold19.X VDPWR sky130_fd_pr__pfet_01v8_hvt ad=0.14075 pd=1.325 as=0.26 ps=2.52 w=1 l=0.15
X352 digital_0.clkbuf_1_0__f_clk.X a_6315_1474# VDPWR VDPWR sky130_fd_pr__pfet_01v8_hvt ad=0.14 pd=1.28 as=0.14 ps=1.28 w=1 l=0.15
X353 VDPWR a_7071_2018# a_6961_2044# VDPWR sky130_fd_pr__pfet_01v8_hvt ad=0.07035 pd=0.755 as=0.1155 ps=0.97 w=0.42 l=0.15
X354 VDPWR digital_0._063_.A a_13513_956# VDPWR sky130_fd_pr__pfet_01v8_hvt ad=0.135 pd=1.27 as=0.28 ps=2.56 w=1 l=0.15
X355 VGND digital_0._110_.RESET_B a_12451_2588# VGND sky130_fd_pr__nfet_01v8 ad=0.1346 pd=1.15 as=0.0441 ps=0.63 w=0.42 l=0.15
X356 a_12929_2562# a_12754_2588# a_13108_2588# VGND sky130_fd_pr__nfet_01v8 ad=0.1092 pd=1.36 as=0.06405 ps=0.725 w=0.42 l=0.15
X357 a_11839_2588# a_11673_2588# VDPWR VDPWR sky130_fd_pr__pfet_01v8_hvt ad=0.1664 pd=1.8 as=0.0864 ps=0.91 w=0.64 l=0.15
X358 a_7405_2588# a_6889_2588# a_7310_2588# VGND sky130_fd_pr__special_nfet_01v8 ad=0.0594 pd=0.69 as=0.066 ps=0.745 w=0.36 l=0.15
X359 a_12407_2830# a_12189_2588# VDPWR VDPWR sky130_fd_pr__pfet_01v8_hvt ad=0.12915 pd=1.185 as=0.2184 ps=2.2 w=0.84 l=0.15
X360 a_4324_412# digital_0._116_.SET_B VGND VGND sky130_fd_pr__nfet_01v8 ad=0.0441 pd=0.63 as=0.1137 ps=1.01 w=0.42 l=0.15
X361 VDPWR VGND VDPWR VDPWR sky130_fd_pr__pfet_01v8_hvt ad=0.2262 pd=2.26 as=0 ps=0 w=0.87 l=0.59
X362 VDPWR a_8145_2562# a_8132_2954# VDPWR sky130_fd_pr__pfet_01v8_hvt ad=0.0819 pd=0.81 as=0.0567 ps=0.69 w=0.42 l=0.15
X363 a_11397_1750# digital_0._065_.A2_N VDPWR VDPWR sky130_fd_pr__pfet_01v8_hvt ad=0.135 pd=1.27 as=0.135 ps=1.27 w=1 l=0.15
X364 VDPWR a_4765_n158# a_4696_n132# VDPWR sky130_fd_pr__pfet_01v8_hvt ad=0.2184 pd=2.2 as=0.12915 ps=1.185 w=0.84 l=0.15
X365 VGND digital_0._116_.SET_B a_4828_412# VGND sky130_fd_pr__nfet_01v8 ad=0.0882 pd=0.84 as=0.0441 ps=0.63 w=0.42 l=0.15
X366 VDPWR a_8578_n132# a_8689_n132# VDPWR sky130_fd_pr__pfet_01v8_hvt ad=0.2726 pd=1.61 as=0.2173 ps=2.17 w=0.82 l=0.25
X367 a_10721_172# digital_0._106_.RESET_B VDPWR VDPWR sky130_fd_pr__pfet_01v8_hvt ad=0.0567 pd=0.69 as=0.0819 ps=0.81 w=0.42 l=0.15
X368 VDPWR VGND VDPWR VDPWR sky130_fd_pr__pfet_01v8_hvt ad=0.2262 pd=2.26 as=0 ps=0 w=0.87 l=0.59
X369 VGND VDPWR VGND VGND sky130_fd_pr__nfet_01v8 ad=0.143 pd=1.62 as=0 ps=0 w=0.55 l=0.59
R3 uio_oe<1> li_28516_19376# sky130_fd_pr__res_generic_m4 w=0.3 l=0.3
X370 a_15238_1334# a_14157_962# a_14891_930# VDPWR sky130_fd_pr__pfet_01v8_hvt ad=0.0588 pd=0.7 as=0.12915 ps=1.185 w=0.42 l=0.15
X371 a_5974_n676# digital_0._116_.Q a_5868_n676# VGND sky130_fd_pr__nfet_01v8 ad=0.1625 pd=1.15 as=0.1235 ps=1.03 w=0.65 l=0.15
X372 LELO_GR01_0.x7.x24.D LELO_GR01_0.x8.PWRUP_N_1V8 LELO_GR01_0.x7.x23.D VDPWR sky130_fd_pr__pfet_01v8_lvt ad=0.5088 pd=2.98 as=0.3168 ps=1.62 w=0.96 l=0.94
X373 a_14109_n676# digital_0.hold27.X a_13746_n524# VGND sky130_fd_pr__nfet_01v8 ad=0.0693 pd=0.75 as=0.09975 ps=0.895 w=0.42 l=0.15
X374 VDPWR a_4581_2825# a_4512_2954# VDPWR sky130_fd_pr__pfet_01v8_hvt ad=0.2184 pd=2.2 as=0.12915 ps=1.185 w=0.84 l=0.15
X375 a_7181_3926# digital_0._069_.B digital_0._109_.D VDPWR sky130_fd_pr__pfet_01v8_hvt ad=0.135 pd=1.27 as=0.135 ps=1.27 w=1 l=0.15
X376 LELO_GR01_0.x8.x1.x5.IBN LELO_GR01_0.x8.IBP_BG LELO_GR01_0.x8.x1.x7.D VGND sky130_fd_pr__nfet_01v8_lvt ad=0.5088 pd=2.98 as=0.3168 ps=1.62 w=0.96 l=0.94
X377 VDPWR a_4833_3436# digital_0.hold28.A VDPWR sky130_fd_pr__pfet_01v8_hvt ad=0.26 pd=2.52 as=0.135 ps=1.27 w=1 l=0.15
X378 a_4594_3650# digital_0.output4.A VDPWR VDPWR sky130_fd_pr__pfet_01v8_hvt ad=0.27 pd=2.54 as=0.19265 ps=1.415 w=1 l=0.15
X379 VGND a_13481_386# digital_0._112_.Q VGND sky130_fd_pr__nfet_01v8 ad=0.169 pd=1.82 as=0.08775 ps=0.92 w=0.65 l=0.15
X380 a_13888_n676# digital_0.hold28.A VGND VGND sky130_fd_pr__nfet_01v8 ad=0.0693 pd=0.75 as=0.11285 ps=1.045 w=0.42 l=0.15
X381 VDPWR LELO_GR01_0.x8.PWRUP_N_1V8 LELO_GR01_0.x8.x8.D VDPWR sky130_fd_pr__pfet_01v8_lvt ad=0.5088 pd=2.98 as=0.3168 ps=1.62 w=0.96 l=0.94
X382 a_10077_246# a_9631_n126# a_9981_246# VGND sky130_fd_pr__special_nfet_01v8 ad=0.1401 pd=1.1 as=0.0594 ps=0.69 w=0.36 l=0.15
X383 digital_0.output10.A a_14861_172# VGND VGND sky130_fd_pr__nfet_01v8 ad=0.08775 pd=0.92 as=0.2087 ps=2.02 w=0.65 l=0.15
X384 digital_0._111_.RESET_B digital_0.load_slew17.A a_9557_2838# VDPWR sky130_fd_pr__pfet_01v8_hvt ad=0.135 pd=1.27 as=0.135 ps=1.27 w=1 l=0.15
X385 LELO_GR01_0.x7.x21.D LELO_GR01_0.x8.PWRUP_N_1V8 LELO_GR01_0.x7.x22.D VDPWR sky130_fd_pr__pfet_01v8_lvt ad=0.3168 pd=1.62 as=0.5088 ps=2.98 w=0.96 l=0.94
X386 VGND a_10986_3828# digital_0._103_.D VGND sky130_fd_pr__nfet_01v8 ad=0.11285 pd=1.045 as=0.169 ps=1.82 w=0.65 l=0.15
X387 VDPWR digital_0.hold28.A a_12635_3171# VDPWR sky130_fd_pr__pfet_01v8_hvt ad=0.0693 pd=0.75 as=0.1176 ps=1.4 w=0.42 l=0.15
X388 VGND digital_0._108_.Q a_5942_2404# VGND sky130_fd_pr__nfet_01v8 ad=0.1304 pd=1.105 as=0.05355 ps=0.675 w=0.42 l=0.15
X389 VDPWR a_12189_3650# a_11931_3650# VDPWR sky130_fd_pr__pfet_01v8_hvt ad=0.0567 pd=0.69 as=0.1092 ps=1.36 w=0.42 l=0.5
X390 VGND VDPWR VGND VGND sky130_fd_pr__nfet_01v8 ad=0.143 pd=1.62 as=0 ps=0 w=0.55 l=0.59
X391 VDPWR a_3492_3650# uio_out<0> VDPWR sky130_fd_pr__pfet_01v8_hvt ad=0.2726 pd=1.61 as=0.495 ps=2.99 w=1 l=0.15
X392 VDPWR a_6263_2562# a_6293_2915# VDPWR sky130_fd_pr__pfet_01v8_hvt ad=0.0693 pd=0.75 as=0.0441 ps=0.63 w=0.42 l=0.15
X393 VGND digital_0.clkload0.A a_13513_3138# VGND sky130_fd_pr__nfet_01v8 ad=0.0567 pd=0.69 as=0.1092 ps=1.36 w=0.42 l=0.15
X394 VDPWR digital_0.load_slew15.X digital_0._116_.SET_B VDPWR sky130_fd_pr__pfet_01v8_hvt ad=0.26 pd=2.52 as=0.135 ps=1.27 w=1 l=0.15
X395 a_12189_3650# digital_0.output8.A VGND VGND sky130_fd_pr__nfet_01v8 ad=0.1092 pd=1.36 as=0.0567 ps=0.69 w=0.42 l=0.15
X396 LELO_GR01_0.x7.x15.I2 LELO_GR01_0.x7.x18.G VDPWR VDPWR sky130_fd_pr__pfet_01v8_lvt ad=0.3168 pd=1.62 as=0.5088 ps=2.98 w=0.96 l=0.94
X397 VGND VDPWR VGND VGND sky130_fd_pr__nfet_01v8 ad=0.143 pd=1.62 as=0 ps=0 w=0.55 l=0.59
X398 VDPWR a_14727_1474# a_14757_1827# VDPWR sky130_fd_pr__pfet_01v8_hvt ad=0.0693 pd=0.75 as=0.0441 ps=0.63 w=0.42 l=0.15
X399 VGND a_8996_1500# digital_0.clkbuf_1_1__f_clk.A VGND sky130_fd_pr__nfet_01v8 ad=0.0588 pd=0.7 as=0.0588 ps=0.7 w=0.42 l=0.15
X400 digital_0._113_.Q a_13481_1474# VGND VGND sky130_fd_pr__nfet_01v8 ad=0.08775 pd=0.92 as=0.2087 ps=2.02 w=0.65 l=0.15
X401 a_13306_1500# a_12391_1500# a_12959_1742# VGND sky130_fd_pr__special_nfet_01v8 ad=0.0711 pd=0.755 as=0.0999 ps=0.985 w=0.36 l=0.15
X402 a_4005_n158# a_4292_0# VDPWR VDPWR sky130_fd_pr__pfet_01v8_hvt ad=0.0567 pd=0.69 as=0.1134 ps=1.38 w=0.42 l=0.15
X403 a_9341_412# a_8895_412# a_9245_412# VGND sky130_fd_pr__special_nfet_01v8 ad=0.1401 pd=1.1 as=0.0594 ps=0.69 w=0.36 l=0.15
X404 VGND LELO_GR01_0.x8.x1.x5.x9<2>.G LELO_GR01_0.x8.x1.x5.IBN VGND sky130_fd_pr__nfet_01v8_lvt ad=0.5088 pd=2.98 as=0.3168 ps=1.62 w=0.96 l=0.94
X405 a_4587_2018# a_4369_2422# VDPWR VDPWR sky130_fd_pr__pfet_01v8_hvt ad=0.12915 pd=1.185 as=0.2184 ps=2.2 w=0.84 l=0.15
X406 VDPWR a_11273_3436# a_11260_3132# VDPWR sky130_fd_pr__pfet_01v8_hvt ad=0.0819 pd=0.81 as=0.0567 ps=0.69 w=0.42 l=0.15
X407 VDPWR digital_0._100_.RESET_B a_3821_2562# VDPWR sky130_fd_pr__pfet_01v8_hvt ad=0.0819 pd=0.81 as=0.0567 ps=0.69 w=0.42 l=0.15
X408 digital_0.output6.A a_5109_2348# VDPWR VDPWR sky130_fd_pr__pfet_01v8_hvt ad=0.135 pd=1.27 as=0.3012 ps=2.66 w=1 l=0.15
X409 a_15331_564# a_15427_386# VGND VGND sky130_fd_pr__nfet_01v8 ad=0.1092 pd=1.36 as=0.097 ps=0.975 w=0.42 l=0.5
X410 a_7577_n676# digital_0.hold26.X a_7214_n524# VGND sky130_fd_pr__nfet_01v8 ad=0.0693 pd=0.75 as=0.09975 ps=0.895 w=0.42 l=0.15
X411 VDPWR a_12626_n676# a_12737_n676# VDPWR sky130_fd_pr__pfet_01v8_hvt ad=0.2726 pd=1.61 as=0.2173 ps=2.17 w=0.82 l=0.25
X412 digital_0._101_.RESET_B digital_0.load_slew15.X VDPWR VDPWR sky130_fd_pr__pfet_01v8_hvt ad=0.135 pd=1.27 as=0.26 ps=2.52 w=1 l=0.15
X413 VDPWR a_10721_172# a_10708_n132# VDPWR sky130_fd_pr__pfet_01v8_hvt ad=0.0819 pd=0.81 as=0.0567 ps=0.69 w=0.42 l=0.15
X414 a_10555_956# digital_0._114_.Q a_10253_930# VDPWR sky130_fd_pr__pfet_01v8_hvt ad=0.135 pd=1.27 as=0.26 ps=2.52 w=1 l=0.15
X415 a_12741_1500# a_12391_1500# a_12646_1500# VDPWR sky130_fd_pr__pfet_01v8_hvt ad=0.07245 pd=0.765 as=0.0651 ps=0.73 w=0.42 l=0.15
X416 a_4143_2588# a_4108_2840# a_3821_2562# VGND sky130_fd_pr__nfet_01v8 ad=0.06405 pd=0.725 as=0.1092 ps=1.36 w=0.42 l=0.15
X417 a_14247_3106# a_14029_3510# VGND VGND sky130_fd_pr__nfet_01v8 ad=0.0999 pd=0.985 as=0.1346 ps=1.15 w=0.64 l=0.15
X418 a_7826_956# digital_0._060_.A_N a_7155_930# VDPWR sky130_fd_pr__pfet_01v8_hvt ad=0.135 pd=1.27 as=0.135 ps=1.27 w=1 l=0.15
X419 VGND a_14298_1652# digital_0._104_.D VGND sky130_fd_pr__nfet_01v8 ad=0.11285 pd=1.045 as=0.169 ps=1.82 w=0.65 l=0.15
X420 a_9245_412# a_8729_412# a_9150_412# VGND sky130_fd_pr__special_nfet_01v8 ad=0.0594 pd=0.69 as=0.066 ps=0.745 w=0.36 l=0.15
X421 a_9631_n126# a_9465_n126# VGND VGND sky130_fd_pr__nfet_01v8 ad=0.1092 pd=1.36 as=0.0567 ps=0.69 w=0.42 l=0.15
X422 LELO_GR01_0.x8.IBP_BG LELO_GR01_0.x8.x4.G VGND VGND sky130_fd_pr__nfet_01v8_lvt ad=0.3168 pd=1.62 as=0.5088 ps=2.98 w=0.96 l=0.94
X423 VGND rst_n sky130_fd_pr__diode_pw2nd_05v5 perim=1.8e+06 area=2.025e+11
X424 digital_0._113_.RESET_B digital_0._116_.Q VGND VGND sky130_fd_pr__nfet_01v8 ad=0.08775 pd=0.92 as=0.182 ps=1.86 w=0.65 l=0.15
X425 a_6263_2562# digital_0.hold28.A VGND VGND sky130_fd_pr__nfet_01v8 ad=0.1092 pd=1.36 as=0.1449 ps=1.11 w=0.42 l=0.15
X426 LELO_GR01_0.x7.x6<3>.G LELO_GR01_0.x7.x18.D LELO_GR01_0.x7.x18.G VGND sky130_fd_pr__nfet_01v8_lvt ad=0.5088 pd=2.98 as=0.3168 ps=1.62 w=0.96 l=0.94
X427 a_4934_2422# a_3853_2050# a_4587_2018# VDPWR sky130_fd_pr__pfet_01v8_hvt ad=0.0588 pd=0.7 as=0.12915 ps=1.185 w=0.42 l=0.15
X428 a_10997_386# digital_0._057_.D VDPWR VDPWR sky130_fd_pr__pfet_01v8_hvt ad=0.0588 pd=0.7 as=0.27995 ps=1.615 w=0.42 l=0.15
X429 VDPWR VGND VDPWR VDPWR sky130_fd_pr__pfet_01v8_hvt ad=0.2262 pd=2.26 as=0 ps=0 w=0.87 l=0.59
X430 digital_0.load_slew15.X a_8085_1500# VDPWR VDPWR sky130_fd_pr__pfet_01v8_hvt ad=0.135 pd=1.27 as=0.135 ps=1.27 w=1 l=0.15
X431 a_3492_3650# a_3618_3834# VGND VGND sky130_fd_pr__nfet_01v8 ad=0.17225 pd=1.83 as=0.1856 ps=1.26 w=0.65 l=0.25
X432 a_7418_2422# a_6503_2050# a_7071_2018# VGND sky130_fd_pr__special_nfet_01v8 ad=0.0711 pd=0.755 as=0.0999 ps=0.985 w=0.36 l=0.15
X433 a_10429_n676# digital_0.hold21.X a_10066_n524# VGND sky130_fd_pr__nfet_01v8 ad=0.0693 pd=0.75 as=0.09975 ps=0.895 w=0.42 l=0.15
X434 digital_0.clkbuf_1_1__f_clk.A a_8996_1500# VGND VGND sky130_fd_pr__nfet_01v8 ad=0.0588 pd=0.7 as=0.0588 ps=0.7 w=0.42 l=0.15
X435 VDPWR a_10721_2348# digital_0._111_.Q VDPWR sky130_fd_pr__pfet_01v8_hvt ad=0.26 pd=2.52 as=0.135 ps=1.27 w=1 l=0.15
X436 VGND digital_0.clkbuf_1_0__f_clk.X a_3577_3138# VGND sky130_fd_pr__nfet_01v8 ad=0.0567 pd=0.69 as=0.1092 ps=1.36 w=0.42 l=0.15
X437 digital_0.output11.A a_10721_172# VGND VGND sky130_fd_pr__nfet_01v8 ad=0.08775 pd=0.92 as=0.2087 ps=2.02 w=0.65 l=0.15
X438 digital_0.clkbuf_1_0__f_clk.X a_6315_1474# VDPWR VDPWR sky130_fd_pr__pfet_01v8_hvt ad=0.14 pd=1.28 as=0.1375 ps=1.275 w=1 l=0.15
X439 VGND digital_0.output4.A a_4243_n676# VGND sky130_fd_pr__nfet_01v8 ad=0.0567 pd=0.69 as=0.1092 ps=1.36 w=0.42 l=0.15
X440 a_9151_n702# digital_0._060_.B VDPWR VDPWR sky130_fd_pr__pfet_01v8_hvt ad=0.0609 pd=0.71 as=0.22895 ps=1.745 w=0.42 l=0.15
X441 a_3814_386# a_3982_386# VGND VGND sky130_fd_pr__nfet_01v8 ad=0.169 pd=1.82 as=0.08775 ps=0.92 w=0.65 l=0.15
X442 VDPWR LELO_GR01_0.x8.PWRUP_N_1V8 LELO_GR01_0.x8.x1.x5.x8.S VDPWR sky130_fd_pr__pfet_01v8_lvt ad=0.5088 pd=2.98 as=0.3168 ps=1.62 w=0.96 l=0.94
X443 digital_0.hold18.X a_4585_n676# VGND VGND sky130_fd_pr__nfet_01v8 ad=0.169 pd=1.82 as=0.097 ps=0.975 w=0.65 l=0.15
X444 a_7720_n132# a_7001_110# a_7157_n158# VGND sky130_fd_pr__special_nfet_01v8 ad=0.066 pd=0.745 as=0.0594 ps=0.69 w=0.36 l=0.15
X445 a_14861_172# a_14686_246# a_15040_234# VGND sky130_fd_pr__nfet_01v8 ad=0.1092 pd=1.36 as=0.06405 ps=0.725 w=0.42 l=0.15
X446 VGND VDPWR VGND VGND sky130_fd_pr__nfet_01v8 ad=0.143 pd=1.62 as=0 ps=0 w=0.55 l=0.59
X447 VGND a_5661_1260# digital_0.output13.A VGND sky130_fd_pr__nfet_01v8 ad=0.169 pd=1.82 as=0.08775 ps=0.92 w=0.65 l=0.15
X448 VDPWR LELO_GR01_0.x7.x18.G LELO_GR01_0.x7.x15.I2 VDPWR sky130_fd_pr__pfet_01v8_lvt ad=0.5088 pd=2.98 as=0.3168 ps=1.62 w=0.96 l=0.94
X449 VDPWR a_5855_564# digital_0.hold22.X VDPWR sky130_fd_pr__pfet_01v8_hvt ad=0.14075 pd=1.325 as=0.26 ps=2.52 w=1 l=0.15
X450 a_9886_234# digital_0._106_.D VGND VGND sky130_fd_pr__nfet_01v8 ad=0.066 pd=0.745 as=0.2205 ps=1.89 w=0.42 l=0.15
X451 VGND digital_0.output11.A a_12409_n676# VGND sky130_fd_pr__nfet_01v8 ad=0.1228 pd=1.065 as=0.1134 ps=1.38 w=0.42 l=0.15
X452 digital_0._111_.Q a_10721_2348# VGND VGND sky130_fd_pr__nfet_01v8 ad=0.08775 pd=0.92 as=0.2087 ps=2.02 w=0.65 l=0.15
X453 a_10533_3510# a_10017_3138# a_10438_3498# VGND sky130_fd_pr__special_nfet_01v8 ad=0.0594 pd=0.69 as=0.066 ps=0.745 w=0.36 l=0.15
X454 digital_0._069_.B digital_0._109_.Q VGND VGND sky130_fd_pr__nfet_01v8 ad=0.08775 pd=0.92 as=0.10725 ps=0.98 w=0.65 l=0.15
X455 digital_0.clkload0.A a_11388_956# VGND VGND sky130_fd_pr__nfet_01v8 ad=0.0588 pd=0.7 as=0.0588 ps=0.7 w=0.42 l=0.15
X456 digital_0._114_.D a_9151_n702# VGND VGND sky130_fd_pr__nfet_01v8 ad=0.08775 pd=0.92 as=0.1755 ps=1.84 w=0.65 l=0.15
X457 VGND a_5787_2146# digital_0._069_.A VGND sky130_fd_pr__nfet_01v8 ad=0.17875 pd=1.85 as=0.08775 ps=0.92 w=0.65 l=0.15
X458 a_3858_3650# digital_0.output5.A VDPWR VDPWR sky130_fd_pr__pfet_01v8_hvt ad=0.27 pd=2.54 as=0.19265 ps=1.415 w=1 l=0.15
X459 a_3982_386# a_4530_626# a_4488_778# VDPWR sky130_fd_pr__pfet_01v8_hvt ad=0.0819 pd=0.81 as=0.0441 ps=0.63 w=0.42 l=0.15
X460 digital_0._108_.D a_6235_3106# a_6179_3132# VDPWR sky130_fd_pr__pfet_01v8_hvt ad=0.135 pd=1.27 as=0.28 ps=2.56 w=1 l=0.15
X461 VGND digital_0._114_.RESET_B a_9507_412# VGND sky130_fd_pr__nfet_01v8 ad=0.1346 pd=1.15 as=0.0441 ps=0.63 w=0.42 l=0.15
X462 a_11445_4003# digital_0._111_.Q a_10986_3828# VDPWR sky130_fd_pr__pfet_01v8_hvt ad=0.0441 pd=0.63 as=0.1932 ps=1.34 w=0.42 l=0.15
X463 digital_0.hold18.X a_4585_n676# VDPWR VDPWR sky130_fd_pr__pfet_01v8_hvt ad=0.26 pd=2.52 as=0.14075 ps=1.325 w=1 l=0.15
X464 VDPWR VGND VDPWR VDPWR sky130_fd_pr__pfet_01v8_hvt ad=0.2262 pd=2.26 as=0 ps=0 w=0.87 l=0.59
X465 a_7221_412# a_6705_412# a_7126_412# VGND sky130_fd_pr__special_nfet_01v8 ad=0.0594 pd=0.69 as=0.066 ps=0.745 w=0.36 l=0.15
X466 a_3858_930# digital_0.output6.A VDPWR VDPWR sky130_fd_pr__pfet_01v8_hvt ad=0.27 pd=2.54 as=0.19265 ps=1.415 w=1 l=0.15
X467 VGND VDPWR VGND VGND sky130_fd_pr__nfet_01v8 ad=0.143 pd=1.62 as=0 ps=0 w=0.55 l=0.59
X468 VDPWR VGND VDPWR VDPWR sky130_fd_pr__pfet_01v8_hvt ad=0.2262 pd=2.26 as=0 ps=0 w=0.87 l=0.59
X469 a_15685_386# digital_0.output9.A VDPWR VDPWR sky130_fd_pr__pfet_01v8_hvt ad=0.1092 pd=1.36 as=0.0567 ps=0.69 w=0.42 l=0.15
X470 a_11128_3676# digital_0.hold28.A VGND VGND sky130_fd_pr__nfet_01v8 ad=0.0693 pd=0.75 as=0.11285 ps=1.045 w=0.42 l=0.15
X471 VDPWR digital_0.output11.A a_12409_n676# VDPWR sky130_fd_pr__pfet_01v8_hvt ad=0.19265 pd=1.415 as=0.27 ps=2.54 w=1 l=0.15
X472 VDPWR digital_0._116_.Q a_9005_956# VDPWR sky130_fd_pr__pfet_01v8_hvt ad=0.135 pd=1.27 as=0.28 ps=2.56 w=1 l=0.15
X473 a_10243_234# a_10199_n158# a_10077_246# VGND sky130_fd_pr__nfet_01v8 ad=0.0441 pd=0.63 as=0.1401 ps=1.1 w=0.42 l=0.15
X474 a_4311_3106# a_4093_3510# VGND VGND sky130_fd_pr__nfet_01v8 ad=0.0999 pd=0.985 as=0.1346 ps=1.15 w=0.64 l=0.15
X475 digital_0._114_.D a_9151_n702# VDPWR VDPWR sky130_fd_pr__pfet_01v8_hvt ad=0.135 pd=1.27 as=0.26 ps=2.52 w=1 l=0.15
X476 a_7948_778# a_6871_412# a_7786_412# VDPWR sky130_fd_pr__pfet_01v8_hvt ad=0.0567 pd=0.69 as=0.0588 ps=0.7 w=0.42 l=0.15
X477 VDPWR VGND VDPWR VDPWR sky130_fd_pr__pfet_01v8_hvt ad=0.2262 pd=2.26 as=0 ps=0 w=0.87 l=0.59
X478 VGND digital_0._109_.RESET_B a_7667_2588# VGND sky130_fd_pr__nfet_01v8 ad=0.1346 pd=1.15 as=0.0441 ps=0.63 w=0.42 l=0.15
X479 a_6503_2050# a_6337_2050# VGND VGND sky130_fd_pr__nfet_01v8 ad=0.1092 pd=1.36 as=0.0567 ps=0.69 w=0.42 l=0.15
X480 a_10183_3138# a_10017_3138# VGND VGND sky130_fd_pr__nfet_01v8 ad=0.1092 pd=1.36 as=0.0567 ps=0.69 w=0.42 l=0.15
X481 digital_0._103_.RESET_B digital_0.load_slew17.A VGND VGND sky130_fd_pr__nfet_01v8 ad=0.08775 pd=0.92 as=0.169 ps=1.82 w=0.65 l=0.15
X482 a_12741_412# a_12225_412# a_12646_412# VGND sky130_fd_pr__special_nfet_01v8 ad=0.0594 pd=0.69 as=0.066 ps=0.745 w=0.36 l=0.15
X483 VGND VDPWR VGND VGND sky130_fd_pr__nfet_01v8 ad=0.143 pd=1.62 as=0 ps=0 w=0.55 l=0.59
X484 VGND VDPWR VGND VGND sky130_fd_pr__nfet_01v8 ad=0.143 pd=1.62 as=0 ps=0 w=0.55 l=0.59
X485 a_9353_778# digital_0._114_.RESET_B VDPWR VDPWR sky130_fd_pr__pfet_01v8_hvt ad=0.1092 pd=1.36 as=0.07035 ps=0.755 w=0.42 l=0.15
X486 VDPWR digital_0._116_.Q a_8837_2838# VDPWR sky130_fd_pr__pfet_01v8_hvt ad=0.135 pd=1.27 as=0.135 ps=1.27 w=1 l=0.15
X487 a_14795_246# a_13605_n126# a_14686_246# VGND sky130_fd_pr__special_nfet_01v8 ad=0.0669 pd=0.75 as=0.0711 ps=0.755 w=0.36 l=0.15
X488 VGND digital_0.input1.X a_12225_412# VGND sky130_fd_pr__nfet_01v8 ad=0.0567 pd=0.69 as=0.1092 ps=1.36 w=0.42 l=0.15
X489 VGND digital_0._116_.Q digital_0._110_.RESET_B VGND sky130_fd_pr__nfet_01v8 ad=0.182 pd=1.86 as=0.08775 ps=0.92 w=0.65 l=0.15
X490 VDPWR a_6315_1474# digital_0.clkbuf_1_0__f_clk.X VDPWR sky130_fd_pr__pfet_01v8_hvt ad=0.14 pd=1.28 as=0.14 ps=1.28 w=1 l=0.15
X491 VDPWR a_4005_n158# digital_0.output4.A VDPWR sky130_fd_pr__pfet_01v8_hvt ad=0.3012 pd=2.66 as=0.135 ps=1.27 w=1 l=0.15
X492 VGND a_15413_1260# digital_0.output9.A VGND sky130_fd_pr__nfet_01v8 ad=0.169 pd=1.82 as=0.08775 ps=0.92 w=0.65 l=0.15
X493 LELO_GR01_0.x8.x1.x5.IBN LELO_GR01_0.x8.x1.x5.x9<2>.G VGND VGND sky130_fd_pr__nfet_01v8_lvt ad=0.3168 pd=1.62 as=0.5088 ps=2.98 w=0.96 l=0.94
X494 a_7214_n524# digital_0.hold26.X a_7356_n349# VDPWR sky130_fd_pr__pfet_01v8_hvt ad=0.1932 pd=1.34 as=0.07665 ps=0.785 w=0.42 l=0.15
X495 a_4438_386# digital_0.clkbuf_1_0__f_clk.X VDPWR VDPWR sky130_fd_pr__pfet_01v8_hvt ad=0.1664 pd=1.8 as=0.0864 ps=0.91 w=0.64 l=0.15
X496 VDPWR a_5661_1260# digital_0.output13.A VDPWR sky130_fd_pr__pfet_01v8_hvt ad=0.26 pd=2.52 as=0.135 ps=1.27 w=1 l=0.15
X497 digital_0._112_.Q a_13481_386# VDPWR VDPWR sky130_fd_pr__pfet_01v8_hvt ad=0.135 pd=1.27 as=0.3012 ps=2.66 w=1 l=0.15
X498 a_6853_2422# a_6503_2050# a_6758_2410# VDPWR sky130_fd_pr__pfet_01v8_hvt ad=0.07245 pd=0.765 as=0.0651 ps=0.73 w=0.42 l=0.15
X499 a_10089_2044# a_9465_2050# a_9981_2422# VDPWR sky130_fd_pr__pfet_01v8_hvt ad=0.1155 pd=0.97 as=0.07245 ps=0.765 w=0.42 l=0.15
X500 VGND VDPWR VGND VGND sky130_fd_pr__nfet_01v8 ad=0.143 pd=1.62 as=0 ps=0 w=0.55 l=0.59
X501 VDPWR a_5159_1474# a_5189_1827# VDPWR sky130_fd_pr__pfet_01v8_hvt ad=0.0693 pd=0.75 as=0.0441 ps=0.63 w=0.42 l=0.15
X502 digital_0.clkload0.X a_11673_412# VGND VGND sky130_fd_pr__nfet_01v8 ad=0.0588 pd=0.7 as=0.07035 ps=0.755 w=0.42 l=0.15
X503 a_11431_2382# digital_0._111_.Q VDPWR VDPWR sky130_fd_pr__pfet_01v8_hvt ad=0.0567 pd=0.69 as=0.1176 ps=1.4 w=0.42 l=0.15
X504 a_7317_412# a_6871_412# a_7221_412# VGND sky130_fd_pr__special_nfet_01v8 ad=0.1401 pd=1.1 as=0.0594 ps=0.69 w=0.36 l=0.15
X505 a_12391_1500# a_12225_1500# VDPWR VDPWR sky130_fd_pr__pfet_01v8_hvt ad=0.1664 pd=1.8 as=0.0864 ps=0.91 w=0.64 l=0.15
X506 VDPWR a_4934_2422# a_5109_2348# VDPWR sky130_fd_pr__pfet_01v8_hvt ad=0.1134 pd=1.38 as=0.0567 ps=0.69 w=0.42 l=0.15
X507 a_15592_1322# digital_0._104_.RESET_B VGND VGND sky130_fd_pr__nfet_01v8 ad=0.06405 pd=0.725 as=0.12495 ps=1.015 w=0.42 l=0.15
X508 a_9981_2422# a_9465_2050# a_9886_2410# VGND sky130_fd_pr__special_nfet_01v8 ad=0.0594 pd=0.69 as=0.066 ps=0.745 w=0.36 l=0.15
X509 a_5976_2915# digital_0.hold28.A VDPWR VDPWR sky130_fd_pr__pfet_01v8_hvt ad=0.07665 pd=0.785 as=0.15835 ps=1.395 w=0.42 l=0.15
X510 VDPWR a_5834_2740# digital_0._100_.D VDPWR sky130_fd_pr__pfet_01v8_hvt ad=0.15835 pd=1.395 as=0.26 ps=2.52 w=1 l=0.15
X511 uio_out<6> a_12737_n676# VGND VGND sky130_fd_pr__nfet_01v8 ad=0.2079 pd=1.83 as=0.1856 ps=1.26 w=0.42 l=0.15
X512 digital_0._114_.RESET_B digital_0.load_slew15.A VGND VGND sky130_fd_pr__nfet_01v8 ad=0.08775 pd=0.92 as=0.08775 ps=0.92 w=0.65 l=0.15
X513 a_12407_2830# a_12189_2588# VGND VGND sky130_fd_pr__nfet_01v8 ad=0.0999 pd=0.985 as=0.1346 ps=1.15 w=0.64 l=0.15
X514 a_6761_930# digital_0.hold28.A VDPWR VDPWR sky130_fd_pr__pfet_01v8_hvt ad=0.1092 pd=1.36 as=0.0567 ps=0.69 w=0.42 l=0.15
X515 a_13934_3498# digital_0._102_.D VGND VGND sky130_fd_pr__nfet_01v8 ad=0.066 pd=0.745 as=0.2205 ps=1.89 w=0.42 l=0.15
X516 a_7356_n349# digital_0.hold28.A VDPWR VDPWR sky130_fd_pr__pfet_01v8_hvt ad=0.07665 pd=0.785 as=0.15835 ps=1.395 w=0.42 l=0.15
X517 a_11758_188# digital_0._113_.Q VGND VGND sky130_fd_pr__nfet_01v8 ad=0.08775 pd=0.92 as=0.17875 ps=1.85 w=0.65 l=0.15
X518 VDPWR a_11388_956# digital_0.clkload0.A VDPWR sky130_fd_pr__pfet_01v8_hvt ad=0.14 pd=1.28 as=0.14 ps=1.28 w=1 l=0.15
X519 digital_0.clkbuf_1_0__f_clk.X a_6315_1474# VDPWR VDPWR sky130_fd_pr__pfet_01v8_hvt ad=0.14 pd=1.28 as=0.14 ps=1.28 w=1 l=0.15
X520 VGND VDPWR VGND VGND sky130_fd_pr__nfet_01v8 ad=0.143 pd=1.62 as=0 ps=0 w=0.55 l=0.59
X521 digital_0._117_.RESET_B digital_0.load_slew15.X VDPWR VDPWR sky130_fd_pr__pfet_01v8_hvt ad=0.135 pd=1.27 as=0.26 ps=2.52 w=1 l=0.15
X522 VDPWR LELO_GR01_0.x7.x18.G LELO_GR01_0.x7.x15.I2 VDPWR sky130_fd_pr__pfet_01v8_lvt ad=0.5088 pd=2.98 as=0.3168 ps=1.62 w=0.96 l=0.94
X523 VGND a_3982_386# a_4118_412# VGND sky130_fd_pr__nfet_01v8 ad=0.1137 pd=1.01 as=0.1404 ps=1.6 w=0.54 l=0.15
X524 a_6961_2044# a_6337_2050# a_6853_2422# VDPWR sky130_fd_pr__pfet_01v8_hvt ad=0.1155 pd=0.97 as=0.07245 ps=0.765 w=0.42 l=0.15
X525 VGND VGND LELO_GR01_0.x7.x15.I1 sky130_fd_pr__pnp_05v5_W3p40L3p40
**devattr s=462400,2720
X526 a_5029_956# digital_0._118_.RESET_B VDPWR VDPWR sky130_fd_pr__pfet_01v8_hvt ad=0.1092 pd=1.36 as=0.07035 ps=0.755 w=0.42 l=0.15
X527 a_12959_654# a_12741_412# VDPWR VDPWR sky130_fd_pr__pfet_01v8_hvt ad=0.12915 pd=1.185 as=0.2184 ps=2.2 w=0.84 l=0.15
X528 a_12837_412# a_12391_412# a_12741_412# VGND sky130_fd_pr__special_nfet_01v8 ad=0.1401 pd=1.1 as=0.0594 ps=0.69 w=0.36 l=0.15
X529 VDPWR LELO_GR01_0.x7.x1.x7.D LELO_GR01_0.x7.x1.x7.D VDPWR sky130_fd_pr__pfet_01v8_lvt ad=0.5088 pd=2.98 as=0.3168 ps=1.62 w=0.96 l=0.94
X530 a_12903_206# digital_0._114_.Q VDPWR VDPWR sky130_fd_pr__pfet_01v8_hvt ad=0.0567 pd=0.69 as=0.1176 ps=1.4 w=0.42 l=0.15
X531 VGND digital_0._117_.RESET_B a_4355_3498# VGND sky130_fd_pr__nfet_01v8 ad=0.1346 pd=1.15 as=0.0441 ps=0.63 w=0.42 l=0.15
X532 VGND digital_0.load_slew15.X digital_0._119_.RESET_B VGND sky130_fd_pr__nfet_01v8 ad=0.169 pd=1.82 as=0.08775 ps=0.92 w=0.65 l=0.15
X533 a_10199_2018# a_9981_2422# VGND VGND sky130_fd_pr__nfet_01v8 ad=0.0999 pd=0.985 as=0.1346 ps=1.15 w=0.64 l=0.15
X534 VDPWR VGND VDPWR VDPWR sky130_fd_pr__pfet_01v8_hvt ad=0.2262 pd=2.26 as=0 ps=0 w=0.87 l=0.59
X535 VGND VDPWR VGND VGND sky130_fd_pr__nfet_01v8 ad=0.143 pd=1.62 as=0 ps=0 w=0.55 l=0.59
X536 a_11098_3510# a_10183_3138# a_10751_3106# VGND sky130_fd_pr__special_nfet_01v8 ad=0.0711 pd=0.755 as=0.0999 ps=0.985 w=0.36 l=0.15
X537 a_4274_2410# digital_0._101_.D VDPWR VDPWR sky130_fd_pr__pfet_01v8_hvt ad=0.0651 pd=0.73 as=0.1092 ps=1.36 w=0.42 l=0.15
X538 a_13612_3650# a_13738_3834# VGND VGND sky130_fd_pr__nfet_01v8 ad=0.17225 pd=1.83 as=0.1856 ps=1.26 w=0.65 l=0.25
X539 uio_out<3> a_12829_3676# VGND VGND sky130_fd_pr__nfet_01v8 ad=0.2079 pd=1.83 as=0.1856 ps=1.26 w=0.42 l=0.15
X540 a_10546_246# a_9631_n126# a_10199_n158# VGND sky130_fd_pr__special_nfet_01v8 ad=0.0711 pd=0.755 as=0.0999 ps=0.985 w=0.36 l=0.15
X541 digital_0.clkbuf_1_1__f_clk.A a_8996_1500# VGND VGND sky130_fd_pr__nfet_01v8 ad=0.0588 pd=0.7 as=0.0588 ps=0.7 w=0.42 l=0.15
X542 VDPWR a_9564_930# digital_0.load_slew15.A VDPWR sky130_fd_pr__pfet_01v8_hvt ad=0.2726 pd=1.61 as=0.495 ps=2.99 w=1 l=0.15
X543 digital_0._069_.A a_5787_2146# VDPWR VDPWR sky130_fd_pr__pfet_01v8_hvt ad=0.135 pd=1.27 as=0.15075 ps=1.345 w=1 l=0.15
X544 LELO_GR01_0.x7.x25.S LELO_GR01_0.x8.PWRUP_N_1V8 LELO_GR01_0.x7.x25.D VDPWR sky130_fd_pr__pfet_01v8_lvt ad=0.5088 pd=2.98 as=0.3168 ps=1.62 w=0.96 l=0.94
X545 a_14727_1474# digital_0.hold28.A VGND VGND sky130_fd_pr__nfet_01v8 ad=0.1092 pd=1.36 as=0.1449 ps=1.11 w=0.42 l=0.15
X546 VDPWR VGND VDPWR VDPWR sky130_fd_pr__pfet_01v8_hvt ad=0.2262 pd=2.26 as=0 ps=0 w=0.87 l=0.59
X547 uio_out<6> a_12737_n676# VDPWR VDPWR sky130_fd_pr__pfet_01v8_hvt ad=0.495 pd=2.99 as=0.2726 ps=1.61 w=1 l=0.15
X548 VDPWR VGND VDPWR VDPWR sky130_fd_pr__pfet_01v8_hvt ad=0.2262 pd=2.26 as=0 ps=0 w=0.87 l=0.59
X549 VGND a_3858_n702# a_3618_n518# VGND sky130_fd_pr__nfet_01v8 ad=0.1228 pd=1.065 as=0.17225 ps=1.83 w=0.65 l=0.25
X550 VGND digital_0._114_.Q a_10253_930# VGND sky130_fd_pr__nfet_01v8 ad=0.08775 pd=0.92 as=0.169 ps=1.82 w=0.65 l=0.15
X551 VDPWR digital_0.clkload0.A a_10017_3138# VDPWR sky130_fd_pr__pfet_01v8_hvt ad=0.0864 pd=0.91 as=0.1664 ps=1.8 w=0.64 l=0.15
X552 a_5486_1334# a_4571_962# a_5139_930# VGND sky130_fd_pr__special_nfet_01v8 ad=0.0711 pd=0.755 as=0.0999 ps=0.985 w=0.36 l=0.15
X553 LELO_GR01_0.x7.x1.x5.IBN LELO_GR01_0.x7.x15.I2 LELO_GR01_0.x7.x18.G VGND sky130_fd_pr__nfet_01v8_lvt ad=0.5088 pd=2.98 as=0.3168 ps=1.62 w=0.96 l=0.94
X554 VDPWR a_8145_2562# digital_0._109_.Q VDPWR sky130_fd_pr__pfet_01v8_hvt ad=0.26 pd=2.52 as=0.135 ps=1.27 w=1 l=0.15
X555 digital_0.output5.A a_3821_2562# VDPWR VDPWR sky130_fd_pr__pfet_01v8_hvt ad=0.135 pd=1.27 as=0.26 ps=2.52 w=1 l=0.15
X556 VDPWR LELO_GR01_0.x8.PWRUP_N_1V8 LELO_GR01_0.x7.x1.x5.x8.S VDPWR sky130_fd_pr__pfet_01v8_lvt ad=0.5088 pd=2.98 as=0.3168 ps=1.62 w=0.96 l=0.94
X557 a_10208_n349# digital_0.hold28.A VDPWR VDPWR sky130_fd_pr__pfet_01v8_hvt ad=0.07665 pd=0.785 as=0.15835 ps=1.395 w=0.42 l=0.15
X558 VGND VDPWR VGND VGND sky130_fd_pr__nfet_01v8 ad=0.143 pd=1.62 as=0 ps=0 w=0.55 l=0.59
X559 VDPWR a_15413_1260# digital_0.output9.A VDPWR sky130_fd_pr__pfet_01v8_hvt ad=0.26 pd=2.52 as=0.135 ps=1.27 w=1 l=0.15
X560 digital_0.load_slew17.X a_14762_2018# VGND VGND sky130_fd_pr__nfet_01v8 ad=0.08775 pd=0.92 as=0.17225 ps=1.83 w=0.65 l=0.15
X561 a_10721_2348# a_10546_2422# a_10900_2410# VGND sky130_fd_pr__nfet_01v8 ad=0.1092 pd=1.36 as=0.06405 ps=0.725 w=0.42 l=0.15
X562 VGND a_6263_2562# a_6197_2588# VGND sky130_fd_pr__nfet_01v8 ad=0.1449 pd=1.11 as=0.0693 ps=0.75 w=0.42 l=0.15
X563 VDPWR digital_0.load_slew17.A digital_0._102_.RESET_B VDPWR sky130_fd_pr__pfet_01v8_hvt ad=0.26 pd=2.52 as=0.135 ps=1.27 w=1 l=0.15
X564 VDPWR a_6315_1474# digital_0.clkbuf_1_0__f_clk.X VDPWR sky130_fd_pr__pfet_01v8_hvt ad=0.14 pd=1.28 as=0.14 ps=1.28 w=1 l=0.15
X565 a_7405_2588# a_7055_2588# a_7310_2588# VDPWR sky130_fd_pr__pfet_01v8_hvt ad=0.07245 pd=0.765 as=0.0651 ps=0.73 w=0.42 l=0.15
X566 VDPWR a_3858_3650# a_3618_3834# VDPWR sky130_fd_pr__pfet_01v8_hvt ad=0.19265 pd=1.415 as=0.2173 ps=2.17 w=0.82 l=0.25
X567 a_8578_n676# a_8361_n676# VDPWR VDPWR sky130_fd_pr__pfet_01v8_hvt ad=0.2173 pd=2.17 as=0.19265 ps=1.415 w=0.82 l=0.25
X568 a_7349_3132# digital_0._108_.Q VDPWR VDPWR sky130_fd_pr__pfet_01v8_hvt ad=0.135 pd=1.27 as=0.135 ps=1.27 w=1 l=0.15
X569 VDPWR LELO_GR01_0.x7.x1.x7.D LELO_GR01_0.x7.x18.G VDPWR sky130_fd_pr__pfet_01v8_lvt ad=0.5088 pd=2.98 as=0.3168 ps=1.62 w=0.96 l=0.94
X570 digital_0.output8.A a_11273_3436# VGND VGND sky130_fd_pr__nfet_01v8 ad=0.08775 pd=0.92 as=0.2087 ps=2.02 w=0.65 l=0.15
X571 VGND a_8996_1500# digital_0.clkbuf_1_1__f_clk.A VGND sky130_fd_pr__nfet_01v8 ad=0.0588 pd=0.7 as=0.0588 ps=0.7 w=0.42 l=0.15
X572 VGND a_9985_386# a_9919_412# VGND sky130_fd_pr__nfet_01v8 ad=0.12495 pd=1.015 as=0.0669 ps=0.75 w=0.42 l=0.15
X573 digital_0.load_slew15.X a_8085_1500# VDPWR VDPWR sky130_fd_pr__pfet_01v8_hvt ad=0.135 pd=1.27 as=0.135 ps=1.27 w=1 l=0.15
X574 VGND digital_0._116_.Q digital_0._109_.RESET_B VGND sky130_fd_pr__nfet_01v8 ad=0.08775 pd=0.92 as=0.08775 ps=0.92 w=0.65 l=0.15
X575 VDPWR digital_0.clkbuf_1_1__f_clk.A a_6315_1474# VDPWR sky130_fd_pr__pfet_01v8_hvt ad=0.265 pd=2.53 as=0.14 ps=1.28 w=1 l=0.15
X576 a_6871_412# a_6705_412# VDPWR VDPWR sky130_fd_pr__pfet_01v8_hvt ad=0.1664 pd=1.8 as=0.0864 ps=0.91 w=0.64 l=0.15
X577 VGND VDPWR VGND VGND sky130_fd_pr__nfet_01v8 ad=0.143 pd=1.62 as=0 ps=0 w=0.55 l=0.59
X578 a_7607_3452# digital_0.output13.A digital_0._069_.B VGND sky130_fd_pr__nfet_01v8 ad=0.06825 pd=0.86 as=0.091 ps=0.93 w=0.65 l=0.15
X579 digital_0._109_.D digital_0._069_.A VGND VGND sky130_fd_pr__nfet_01v8 ad=0.08775 pd=0.92 as=0.08775 ps=0.92 w=0.65 l=0.15
X580 VGND digital_0._063_.B digital_0._112_.D VGND sky130_fd_pr__nfet_01v8 ad=0.169 pd=1.82 as=0.08775 ps=0.92 w=0.65 l=0.15
X581 a_7513_2954# a_6889_2588# a_7405_2588# VDPWR sky130_fd_pr__pfet_01v8_hvt ad=0.1155 pd=0.97 as=0.07245 ps=0.765 w=0.42 l=0.15
X582 a_12959_654# a_12741_412# VGND VGND sky130_fd_pr__nfet_01v8 ad=0.0999 pd=0.985 as=0.1346 ps=1.15 w=0.64 l=0.15
X583 a_12989_206# digital_0._114_.Q a_12903_206# VGND sky130_fd_pr__nfet_01v8 ad=0.0567 pd=0.69 as=0.1176 ps=1.4 w=0.42 l=0.15
X584 digital_0._063_.B digital_0._112_.Q VGND VGND sky130_fd_pr__nfet_01v8 ad=0.08775 pd=0.92 as=0.10725 ps=0.98 w=0.65 l=0.15
X585 VDPWR digital_0.load_slew15.X digital_0._119_.RESET_B VDPWR sky130_fd_pr__pfet_01v8_hvt ad=0.26 pd=2.52 as=0.135 ps=1.27 w=1 l=0.15
X586 VGND a_11388_956# digital_0.clkload0.A VGND sky130_fd_pr__nfet_01v8 ad=0.05775 pd=0.695 as=0.0588 ps=0.7 w=0.42 l=0.15
X587 a_12754_2588# a_11839_2588# a_12407_2830# VGND sky130_fd_pr__special_nfet_01v8 ad=0.0711 pd=0.755 as=0.0999 ps=0.985 w=0.36 l=0.15
X588 a_4571_962# a_4405_962# VGND VGND sky130_fd_pr__nfet_01v8 ad=0.1092 pd=1.36 as=0.0567 ps=0.69 w=0.42 l=0.15
X589 VDPWR a_7593_2348# digital_0._108_.Q VDPWR sky130_fd_pr__pfet_01v8_hvt ad=0.26 pd=2.52 as=0.135 ps=1.27 w=1 l=0.15
X590 VGND a_4610_386# a_4568_412# VGND sky130_fd_pr__nfet_01v8 ad=0.1092 pd=1.36 as=0.0441 ps=0.63 w=0.42 l=0.15
X591 VGND VDPWR VGND VGND sky130_fd_pr__nfet_01v8 ad=0.143 pd=1.62 as=0 ps=0 w=0.55 l=0.59
X592 VGND a_14624_386# digital_0.input3.X VGND sky130_fd_pr__nfet_01v8 ad=0.1856 pd=1.26 as=0.2079 ps=1.83 w=0.42 l=0.15
X593 a_14247_3106# a_14029_3510# VDPWR VDPWR sky130_fd_pr__pfet_01v8_hvt ad=0.12915 pd=1.185 as=0.2184 ps=2.2 w=0.84 l=0.15
X594 digital_0.output7.A a_14769_3436# VDPWR VDPWR sky130_fd_pr__pfet_01v8_hvt ad=0.135 pd=1.27 as=0.3012 ps=2.66 w=1 l=0.15
X595 VGND a_7593_2348# a_7527_2422# VGND sky130_fd_pr__nfet_01v8 ad=0.12495 pd=1.015 as=0.0669 ps=0.75 w=0.42 l=0.15
X596 VGND a_11273_3436# a_11207_3510# VGND sky130_fd_pr__nfet_01v8 ad=0.12495 pd=1.015 as=0.0669 ps=0.75 w=0.42 l=0.15
X597 a_7115_2410# a_7071_2018# a_6949_2422# VGND sky130_fd_pr__nfet_01v8 ad=0.0441 pd=0.63 as=0.1401 ps=1.1 w=0.42 l=0.15
X598 a_9564_930# a_9690_1194# VDPWR VDPWR sky130_fd_pr__pfet_01v8_hvt ad=0.2173 pd=2.17 as=0.2726 ps=1.61 w=0.82 l=0.25
X599 LELO_GR01_0.x7.x6<3>.G LELO_GR01_0.x7.x18.D LELO_GR01_0.x7.x18.G VGND sky130_fd_pr__nfet_01v8_lvt ad=0.5088 pd=2.98 as=0.3168 ps=1.62 w=0.96 l=0.94
X600 a_10533_3510# a_10183_3138# a_10438_3498# VDPWR sky130_fd_pr__pfet_01v8_hvt ad=0.07245 pd=0.765 as=0.0651 ps=0.73 w=0.42 l=0.15
X601 VDPWR VGND VDPWR VDPWR sky130_fd_pr__pfet_01v8_hvt ad=0.2262 pd=2.26 as=0 ps=0 w=0.87 l=0.59
X602 VDPWR a_4425_2730# a_4386_2856# VDPWR sky130_fd_pr__pfet_01v8_hvt ad=0.0864 pd=0.91 as=0.1664 ps=1.8 w=0.64 l=0.15
X603 a_6719_234# a_6684_0# a_6397_n158# VGND sky130_fd_pr__nfet_01v8 ad=0.06405 pd=0.725 as=0.1092 ps=1.36 w=0.42 l=0.15
X604 a_7099_956# a_7155_930# digital_0._115_.D VDPWR sky130_fd_pr__pfet_01v8_hvt ad=0.26 pd=2.52 as=0.135 ps=1.27 w=1 l=0.15
X605 a_14578_1322# digital_0._104_.D VDPWR VDPWR sky130_fd_pr__pfet_01v8_hvt ad=0.0651 pd=0.73 as=0.1092 ps=1.36 w=0.42 l=0.15
X606 a_14323_962# a_14157_962# VDPWR VDPWR sky130_fd_pr__pfet_01v8_hvt ad=0.1664 pd=1.8 as=0.0864 ps=0.91 w=0.64 l=0.15
X607 a_7214_n524# digital_0._115_.Q a_7356_n676# VGND sky130_fd_pr__nfet_01v8 ad=0.09975 pd=0.895 as=0.0693 ps=0.75 w=0.42 l=0.15
X608 a_14594_3510# a_13513_3138# a_14247_3106# VDPWR sky130_fd_pr__pfet_01v8_hvt ad=0.0588 pd=0.7 as=0.12915 ps=1.185 w=0.42 l=0.15
X609 a_5855_564# a_5951_386# VGND VGND sky130_fd_pr__nfet_01v8 ad=0.1092 pd=1.36 as=0.097 ps=0.975 w=0.42 l=0.5
X610 a_7155_930# digital_0._060_.A_N a_7826_956# VDPWR sky130_fd_pr__pfet_01v8_hvt ad=0.135 pd=1.27 as=0.26 ps=2.52 w=1 l=0.15
X611 VDPWR VGND VDPWR VDPWR sky130_fd_pr__pfet_01v8_hvt ad=0.2262 pd=2.26 as=0 ps=0 w=0.87 l=0.59
X612 a_9930_930# digital_0.load_slew17.X VDPWR VDPWR sky130_fd_pr__pfet_01v8_hvt ad=0.27 pd=2.54 as=0.19265 ps=1.415 w=1 l=0.15
X613 VGND digital_0.clkload0.A a_9465_n126# VGND sky130_fd_pr__nfet_01v8 ad=0.0567 pd=0.69 as=0.1092 ps=1.36 w=0.42 l=0.15
X614 VGND digital_0.load_slew15.X digital_0._116_.SET_B VGND sky130_fd_pr__nfet_01v8 ad=0.169 pd=1.82 as=0.08775 ps=0.92 w=0.65 l=0.15
X615 digital_0.clkload0.A a_11388_956# VGND VGND sky130_fd_pr__nfet_01v8 ad=0.0588 pd=0.7 as=0.0588 ps=0.7 w=0.42 l=0.15
X616 a_13003_1500# a_12959_1742# a_12837_1500# VGND sky130_fd_pr__nfet_01v8 ad=0.0441 pd=0.63 as=0.1401 ps=1.1 w=0.42 l=0.15
X617 a_10641_3132# a_10017_3138# a_10533_3510# VDPWR sky130_fd_pr__pfet_01v8_hvt ad=0.1155 pd=0.97 as=0.07245 ps=0.765 w=0.42 l=0.15
X618 a_4730_1652# digital_0.hold22.X a_4872_1827# VDPWR sky130_fd_pr__pfet_01v8_hvt ad=0.1932 pd=1.34 as=0.07665 ps=0.785 w=0.42 l=0.15
X619 VGND LELO_GR01_0.x8.x1.x5.x9<2>.G LELO_GR01_0.x8.x1.x5.IBN VGND sky130_fd_pr__nfet_01v8_lvt ad=0.5088 pd=2.98 as=0.3168 ps=1.62 w=0.96 l=0.94
X620 a_5218_778# a_4530_626# a_4610_386# VDPWR sky130_fd_pr__pfet_01v8_hvt ad=0.12495 pd=1.175 as=0.0567 ps=0.69 w=0.42 l=0.15
X621 VDPWR a_4438_386# a_4530_626# VDPWR sky130_fd_pr__pfet_01v8_hvt ad=0.0864 pd=0.91 as=0.1664 ps=1.8 w=0.64 l=0.15
X622 a_11388_956# digital_0.clkbuf_1_1__f_clk.A VDPWR VDPWR sky130_fd_pr__pfet_01v8_hvt ad=0.14 pd=1.28 as=0.265 ps=2.53 w=1 l=0.15
X623 a_15331_564# a_15427_386# VDPWR VDPWR sky130_fd_pr__pfet_01v8_hvt ad=0.1092 pd=1.36 as=0.14075 ps=1.325 w=0.42 l=0.5
X624 a_9150_412# digital_0._114_.D VGND VGND sky130_fd_pr__nfet_01v8 ad=0.066 pd=0.745 as=0.2205 ps=1.89 w=0.42 l=0.15
X625 a_5014_412# a_4746_412# VGND VGND sky130_fd_pr__nfet_01v8 ad=0.06705 pd=0.75 as=0.0882 ps=0.84 w=0.42 l=0.15
X626 VGND a_3814_386# digital_0._116_.Q VGND sky130_fd_pr__nfet_01v8 ad=0.08775 pd=0.92 as=0.08775 ps=0.92 w=0.65 l=0.15
X627 a_15662_2044# a_15445_2044# VDPWR VDPWR sky130_fd_pr__pfet_01v8_hvt ad=0.2173 pd=2.17 as=0.19265 ps=1.415 w=0.82 l=0.25
X628 a_10751_3106# a_10533_3510# VGND VGND sky130_fd_pr__nfet_01v8 ad=0.0999 pd=0.985 as=0.1346 ps=1.15 w=0.64 l=0.15
X629 a_4019_2050# a_3853_2050# VDPWR VDPWR sky130_fd_pr__pfet_01v8_hvt ad=0.1664 pd=1.8 as=0.0864 ps=0.91 w=0.64 l=0.15
X630 VGND VDPWR VGND VGND sky130_fd_pr__nfet_01v8 ad=0.143 pd=1.62 as=0 ps=0 w=0.55 l=0.59
X631 a_11107_2562# digital_0._069_.A VDPWR VDPWR sky130_fd_pr__pfet_01v8_hvt ad=0.0567 pd=0.69 as=0.16655 ps=1.39 w=0.42 l=0.15
X632 a_10066_n524# digital_0._114_.Q a_10208_n676# VGND sky130_fd_pr__nfet_01v8 ad=0.09975 pd=0.895 as=0.0693 ps=0.75 w=0.42 l=0.15
X633 a_9919_412# a_8729_412# a_9810_412# VGND sky130_fd_pr__special_nfet_01v8 ad=0.0669 pd=0.75 as=0.0711 ps=0.755 w=0.36 l=0.15
X634 a_4311_3106# a_4093_3510# VDPWR VDPWR sky130_fd_pr__pfet_01v8_hvt ad=0.12915 pd=1.185 as=0.2184 ps=2.2 w=0.84 l=0.15
X635 a_4872_1827# digital_0.hold28.A VDPWR VDPWR sky130_fd_pr__pfet_01v8_hvt ad=0.07665 pd=0.785 as=0.15835 ps=1.395 w=0.42 l=0.15
X636 a_15537_n132# digital_0.input3.X digital_0._113_.RESET_B VDPWR sky130_fd_pr__pfet_01v8_hvt ad=0.26 pd=2.52 as=0.135 ps=1.27 w=1 l=0.15
X637 VGND LELO_GR01_0.x8.x1.x5.x9<2>.G LELO_GR01_0.x8.x1.x5.x9<2>.G VGND sky130_fd_pr__nfet_01v8_lvt ad=0.5088 pd=2.98 as=0.3168 ps=1.62 w=0.96 l=0.94
X638 a_4292_0# a_4570_n16# a_4526_n132# VDPWR sky130_fd_pr__pfet_01v8_hvt ad=0.0588 pd=0.7 as=0.0567 ps=0.69 w=0.42 l=0.15
X639 VGND digital_0._060_.A_N a_7155_930# VGND sky130_fd_pr__nfet_01v8 ad=0.08775 pd=0.92 as=0.08775 ps=0.92 w=0.65 l=0.15
X640 VDPWR a_5422_n702# a_5182_n518# VDPWR sky130_fd_pr__pfet_01v8_hvt ad=0.19265 pd=1.415 as=0.2173 ps=2.17 w=0.82 l=0.25
X641 a_7001_110# digital_0.clkload0.A VDPWR VDPWR sky130_fd_pr__pfet_01v8_hvt ad=0.1664 pd=1.8 as=0.0864 ps=0.91 w=0.64 l=0.15
X642 digital_0.clkload0.A a_11388_956# VDPWR VDPWR sky130_fd_pr__pfet_01v8_hvt ad=0.14 pd=1.28 as=0.14 ps=1.28 w=1 l=0.15
X643 a_10089_2044# digital_0._111_.RESET_B VDPWR VDPWR sky130_fd_pr__pfet_01v8_hvt ad=0.1092 pd=1.36 as=0.07035 ps=0.755 w=0.42 l=0.15
X644 VGND VDPWR VGND VGND sky130_fd_pr__nfet_01v8 ad=0.143 pd=1.62 as=0 ps=0 w=0.55 l=0.59
X645 VGND VDPWR VGND VGND sky130_fd_pr__nfet_01v8 ad=0.143 pd=1.62 as=0 ps=0 w=0.55 l=0.59
X646 VDPWR a_15413_1260# a_15400_956# VDPWR sky130_fd_pr__pfet_01v8_hvt ad=0.0819 pd=0.81 as=0.0567 ps=0.69 w=0.42 l=0.15
X647 digital_0._119_.RESET_B digital_0.load_slew15.X VGND VGND sky130_fd_pr__nfet_01v8 ad=0.08775 pd=0.92 as=0.169 ps=1.82 w=0.65 l=0.15
X648 VGND a_8996_1500# digital_0.clkbuf_1_1__f_clk.A VGND sky130_fd_pr__nfet_01v8 ad=0.1113 pd=1.37 as=0.0588 ps=0.7 w=0.42 l=0.15
X649 LELO_GR01_0.x7.x1.x5.x3.S LELO_GR01_0.x7.x1.x5.x8.G LELO_GR01_0.x7.x1.x5.x9<2>.G LELO_GR01_0.x7.x1.x5.x3.S sky130_fd_pr__pfet_01v8_lvt ad=0.5088 pd=2.98 as=0.3168 ps=1.62 w=0.96 l=0.94
X650 a_11397_1750# digital_0._112_.Q digital_0._063_.B VDPWR sky130_fd_pr__pfet_01v8_hvt ad=0.36 pd=2.72 as=0.135 ps=1.27 w=1 l=0.15
X651 VDPWR a_6315_1474# digital_0.clkbuf_1_0__f_clk.X VDPWR sky130_fd_pr__pfet_01v8_hvt ad=0.14 pd=1.28 as=0.14 ps=1.28 w=1 l=0.15
X652 digital_0._104_.RESET_B digital_0.load_slew17.A VGND VGND sky130_fd_pr__nfet_01v8 ad=0.08775 pd=0.92 as=0.169 ps=1.82 w=0.65 l=0.15
X653 a_11361_n702# digital_0.output11.A VDPWR VDPWR sky130_fd_pr__pfet_01v8_hvt ad=0.1092 pd=1.36 as=0.0567 ps=0.69 w=0.42 l=0.15
X654 VDPWR a_10546_2422# a_10721_2348# VDPWR sky130_fd_pr__pfet_01v8_hvt ad=0.1134 pd=1.38 as=0.0567 ps=0.69 w=0.42 l=0.15
X655 VDPWR a_13978_3650# a_13738_3834# VDPWR sky130_fd_pr__pfet_01v8_hvt ad=0.19265 pd=1.415 as=0.2173 ps=2.17 w=0.82 l=0.25
X656 VGND a_15331_564# digital_0.hold23.X VGND sky130_fd_pr__nfet_01v8 ad=0.097 pd=0.975 as=0.169 ps=1.82 w=0.65 l=0.15
X657 a_8895_412# a_8729_412# VGND VGND sky130_fd_pr__nfet_01v8 ad=0.1092 pd=1.36 as=0.0567 ps=0.69 w=0.42 l=0.15
X658 a_4658_3510# a_3577_3138# a_4311_3106# VDPWR sky130_fd_pr__pfet_01v8_hvt ad=0.0588 pd=0.7 as=0.12915 ps=1.185 w=0.42 l=0.15
X659 VDPWR VGND VDPWR VDPWR sky130_fd_pr__pfet_01v8_hvt ad=0.2262 pd=2.26 as=0 ps=0 w=0.87 l=0.59
X660 a_7181_3926# digital_0._069_.A VDPWR VDPWR sky130_fd_pr__pfet_01v8_hvt ad=0.28 pd=2.56 as=0.135 ps=1.27 w=1 l=0.15
X661 a_7786_412# a_6871_412# a_7439_654# VGND sky130_fd_pr__special_nfet_01v8 ad=0.0711 pd=0.755 as=0.0999 ps=0.985 w=0.36 l=0.15
X662 VDPWR digital_0._115_.Q a_7099_956# VDPWR sky130_fd_pr__pfet_01v8_hvt ad=0.135 pd=1.27 as=0.135 ps=1.27 w=1 l=0.15
X663 a_9981_2422# a_9631_2050# a_9886_2410# VDPWR sky130_fd_pr__pfet_01v8_hvt ad=0.07245 pd=0.765 as=0.0651 ps=0.73 w=0.42 l=0.15
X664 a_4668_778# a_4438_386# a_3982_386# VDPWR sky130_fd_pr__pfet_01v8_hvt ad=0.0441 pd=0.63 as=0.0819 ps=0.81 w=0.42 l=0.15
X665 digital_0.output9.A a_15413_1260# VDPWR VDPWR sky130_fd_pr__pfet_01v8_hvt ad=0.135 pd=1.27 as=0.3012 ps=2.66 w=1 l=0.15
X666 a_15268_1474# a_15394_1658# VDPWR VDPWR sky130_fd_pr__pfet_01v8_hvt ad=0.2173 pd=2.17 as=0.2726 ps=1.61 w=0.82 l=0.25
X667 digital_0._109_.RESET_B digital_0.load_slew15.A a_7717_3926# VDPWR sky130_fd_pr__pfet_01v8_hvt ad=0.135 pd=1.27 as=0.135 ps=1.27 w=1 l=0.15
X668 VDPWR a_5215_3676# a_5321_3676# VDPWR sky130_fd_pr__pfet_01v8_hvt ad=0.14075 pd=1.325 as=0.1092 ps=1.36 w=0.42 l=0.5
X669 a_7088_n132# a_6962_n16# a_6684_0# VGND sky130_fd_pr__special_nfet_01v8 ad=0.0999 pd=0.985 as=0.0711 ps=0.755 w=0.36 l=0.15
X670 VDPWR VGND VDPWR VDPWR sky130_fd_pr__pfet_01v8_hvt ad=0.2262 pd=2.26 as=0 ps=0 w=0.87 l=0.59
X671 LELO_GR01_0.x7.x6<3>.G LELO_GR01_0.x7.x18.D LELO_GR01_0.x7.x18.G VGND sky130_fd_pr__nfet_01v8_lvt ad=0.5088 pd=2.98 as=0.3168 ps=1.62 w=0.96 l=0.94
X672 a_15225_n702# digital_0.output10.A VGND VGND sky130_fd_pr__nfet_01v8 ad=0.1092 pd=1.36 as=0.0567 ps=0.69 w=0.42 l=0.15
X673 a_8996_1500# clk VDPWR VDPWR sky130_fd_pr__pfet_01v8_hvt ad=0.14 pd=1.28 as=0.14 ps=1.28 w=1 l=0.15
X674 a_5785_1750# digital_0.load_slew17.X digital_0._115_.RESET_B VDPWR sky130_fd_pr__pfet_01v8_hvt ad=0.26 pd=2.52 as=0.135 ps=1.27 w=1 l=0.15
X675 VDPWR VGND VDPWR VDPWR sky130_fd_pr__pfet_01v8_hvt ad=0.2262 pd=2.26 as=0 ps=0 w=0.87 l=0.59
X676 VDPWR a_15238_1334# a_15413_1260# VDPWR sky130_fd_pr__pfet_01v8_hvt ad=0.1134 pd=1.38 as=0.0567 ps=0.69 w=0.42 l=0.15
X677 a_6407_1188# a_6503_930# VDPWR VDPWR sky130_fd_pr__pfet_01v8_hvt ad=0.1092 pd=1.36 as=0.14075 ps=1.325 w=0.42 l=0.5
X678 VDPWR a_11361_n702# a_11103_n702# VDPWR sky130_fd_pr__pfet_01v8_hvt ad=0.0567 pd=0.69 as=0.1092 ps=1.36 w=0.42 l=0.5
X679 VGND digital_0._116_.D a_5218_778# VGND sky130_fd_pr__nfet_01v8 ad=0.1664 pd=1.8 as=0.0935 ps=0.965 w=0.64 l=0.15
X680 VGND digital_0._111_.RESET_B a_10243_2410# VGND sky130_fd_pr__nfet_01v8 ad=0.1346 pd=1.15 as=0.0441 ps=0.63 w=0.42 l=0.15
X681 VDPWR digital_0.output8.A a_12501_3676# VDPWR sky130_fd_pr__pfet_01v8_hvt ad=0.19265 pd=1.415 as=0.27 ps=2.54 w=1 l=0.15
X682 VGND a_12626_n676# a_12737_n676# VGND sky130_fd_pr__nfet_01v8 ad=0.1856 pd=1.26 as=0.17225 ps=1.83 w=0.65 l=0.25
X683 a_15347_1334# a_14157_962# a_15238_1334# VGND sky130_fd_pr__special_nfet_01v8 ad=0.0669 pd=0.75 as=0.0711 ps=0.755 w=0.36 l=0.15
X684 digital_0._110_.Q a_12929_2562# VDPWR VDPWR sky130_fd_pr__pfet_01v8_hvt ad=0.135 pd=1.27 as=0.3012 ps=2.66 w=1 l=0.15
X685 a_7310_2588# digital_0._109_.D VGND VGND sky130_fd_pr__nfet_01v8 ad=0.066 pd=0.745 as=0.2205 ps=1.89 w=0.42 l=0.15
X686 VDPWR a_11388_956# digital_0.clkload0.A VDPWR sky130_fd_pr__pfet_01v8_hvt ad=0.14 pd=1.28 as=0.14 ps=1.28 w=1 l=0.15
X687 VDPWR digital_0.input1.X a_9465_2050# VDPWR sky130_fd_pr__pfet_01v8_hvt ad=0.0864 pd=0.91 as=0.1664 ps=1.8 w=0.64 l=0.15
X688 VDPWR a_6687_n676# a_6793_n676# VDPWR sky130_fd_pr__pfet_01v8_hvt ad=0.14075 pd=1.325 as=0.1092 ps=1.36 w=0.42 l=0.5
X689 VDPWR VGND VDPWR VDPWR sky130_fd_pr__pfet_01v8_hvt ad=0.2262 pd=2.26 as=0 ps=0 w=0.87 l=0.59
X690 a_12285_2588# a_11839_2588# a_12189_2588# VGND sky130_fd_pr__special_nfet_01v8 ad=0.1401 pd=1.1 as=0.0594 ps=0.69 w=0.36 l=0.15
X691 VGND digital_0._116_.Q digital_0._108_.RESET_B VGND sky130_fd_pr__nfet_01v8 ad=0.182 pd=1.86 as=0.08775 ps=0.92 w=0.65 l=0.15
X692 a_7055_2588# a_6889_2588# VGND VGND sky130_fd_pr__nfet_01v8 ad=0.1092 pd=1.36 as=0.0567 ps=0.69 w=0.42 l=0.15
X693 VDPWR VGND VDPWR VDPWR sky130_fd_pr__pfet_01v8_hvt ad=0.2262 pd=2.26 as=0 ps=0 w=0.87 l=0.59
X694 a_11673_n132# digital_0._113_.Q VDPWR VDPWR sky130_fd_pr__pfet_01v8_hvt ad=0.135 pd=1.27 as=0.135 ps=1.27 w=1 l=0.15
X695 digital_0.clkbuf_1_0__f_clk.X a_6315_1474# VDPWR VDPWR sky130_fd_pr__pfet_01v8_hvt ad=0.14 pd=1.28 as=0.14 ps=1.28 w=1 l=0.15
X696 a_13108_2588# digital_0._110_.RESET_B VGND VGND sky130_fd_pr__nfet_01v8 ad=0.06405 pd=0.725 as=0.12495 ps=1.015 w=0.42 l=0.15
X697 a_4609_110# digital_0.clkbuf_1_0__f_clk.X VDPWR VDPWR sky130_fd_pr__pfet_01v8_hvt ad=0.1664 pd=1.8 as=0.0864 ps=0.91 w=0.64 l=0.15
X698 a_14673_3650# digital_0.output7.A VGND VGND sky130_fd_pr__nfet_01v8 ad=0.1092 pd=1.36 as=0.0567 ps=0.69 w=0.42 l=0.15
X699 a_5096_2044# a_4019_2050# a_4934_2422# VDPWR sky130_fd_pr__pfet_01v8_hvt ad=0.0567 pd=0.69 as=0.0588 ps=0.7 w=0.42 l=0.15
X700 VGND VDPWR VGND VGND sky130_fd_pr__nfet_01v8 ad=0.143 pd=1.62 as=0 ps=0 w=0.55 l=0.59
X701 VGND a_9985_386# digital_0._114_.Q VGND sky130_fd_pr__nfet_01v8 ad=0.169 pd=1.82 as=0.08775 ps=0.92 w=0.65 l=0.15
X702 a_10900_234# digital_0._106_.RESET_B VGND VGND sky130_fd_pr__nfet_01v8 ad=0.06405 pd=0.725 as=0.12495 ps=1.015 w=0.42 l=0.15
X703 VGND VDPWR VGND VGND sky130_fd_pr__nfet_01v8 ad=0.143 pd=1.62 as=0 ps=0 w=0.55 l=0.59
X704 VDPWR a_10721_172# digital_0.output11.A VDPWR sky130_fd_pr__pfet_01v8_hvt ad=0.26 pd=2.52 as=0.135 ps=1.27 w=1 l=0.15
X705 VGND VDPWR VGND VGND sky130_fd_pr__nfet_01v8 ad=0.143 pd=1.62 as=0 ps=0 w=0.55 l=0.59
X706 VDPWR a_14594_3510# a_14769_3436# VDPWR sky130_fd_pr__pfet_01v8_hvt ad=0.1134 pd=1.38 as=0.0567 ps=0.69 w=0.42 l=0.15
X707 a_14769_1334# a_14323_962# a_14673_1334# VGND sky130_fd_pr__special_nfet_01v8 ad=0.1401 pd=1.1 as=0.0594 ps=0.69 w=0.36 l=0.15
X708 VGND a_5661_1260# a_5595_1334# VGND sky130_fd_pr__nfet_01v8 ad=0.12495 pd=1.015 as=0.0669 ps=0.75 w=0.42 l=0.15
X709 VGND VDPWR VGND VGND sky130_fd_pr__nfet_01v8 ad=0.143 pd=1.62 as=0 ps=0 w=0.55 l=0.59
X710 a_13978_3650# digital_0.output7.A VDPWR VDPWR sky130_fd_pr__pfet_01v8_hvt ad=0.27 pd=2.54 as=0.19265 ps=1.415 w=1 l=0.15
X711 digital_0.clkbuf_1_1__f_clk.A a_8996_1500# VGND VGND sky130_fd_pr__nfet_01v8 ad=0.0588 pd=0.7 as=0.0588 ps=0.7 w=0.42 l=0.15
X712 VGND a_14319_3828# digital_0.hold24.X VGND sky130_fd_pr__nfet_01v8 ad=0.097 pd=0.975 as=0.169 ps=1.82 w=0.65 l=0.15
X713 VGND digital_0.hold18.X a_5974_n676# VGND sky130_fd_pr__nfet_01v8 ad=0.1105 pd=0.99 as=0.1625 ps=1.15 w=0.65 l=0.15
X714 a_7593_2348# a_7418_2422# a_7772_2410# VGND sky130_fd_pr__nfet_01v8 ad=0.1092 pd=1.36 as=0.06405 ps=0.725 w=0.42 l=0.15
X715 digital_0._116_.Q a_3814_386# VDPWR VDPWR sky130_fd_pr__pfet_01v8_hvt ad=0.135 pd=1.27 as=0.26 ps=2.52 w=1 l=0.15
X716 a_11273_3436# a_11098_3510# a_11452_3498# VGND sky130_fd_pr__nfet_01v8 ad=0.1092 pd=1.36 as=0.06405 ps=0.725 w=0.42 l=0.15
X717 a_5183_1322# a_5139_930# a_5017_1334# VGND sky130_fd_pr__nfet_01v8 ad=0.0441 pd=0.63 as=0.1401 ps=1.1 w=0.42 l=0.15
X718 a_12106_2404# digital_0._069_.A a_12034_2404# VGND sky130_fd_pr__nfet_01v8 ad=0.05355 pd=0.675 as=0.0441 ps=0.63 w=0.42 l=0.15
X719 VDPWR VGND VDPWR VDPWR sky130_fd_pr__pfet_01v8_hvt ad=0.2262 pd=2.26 as=0 ps=0 w=0.87 l=0.59
X720 digital_0._109_.D digital_0._069_.B VGND VGND sky130_fd_pr__nfet_01v8 ad=0.08775 pd=0.92 as=0.169 ps=1.82 w=0.65 l=0.15
X721 VGND digital_0._063_.A digital_0._112_.D VGND sky130_fd_pr__nfet_01v8 ad=0.08775 pd=0.92 as=0.08775 ps=0.92 w=0.65 l=0.15
X722 a_4093_3510# a_3577_3138# a_3998_3498# VGND sky130_fd_pr__special_nfet_01v8 ad=0.0594 pd=0.69 as=0.066 ps=0.745 w=0.36 l=0.15
X723 digital_0.output13.A a_5661_1260# VGND VGND sky130_fd_pr__nfet_01v8 ad=0.08775 pd=0.92 as=0.2087 ps=2.02 w=0.65 l=0.15
X724 VGND digital_0.load_slew15.X digital_0._117_.RESET_B VGND sky130_fd_pr__nfet_01v8 ad=0.169 pd=1.82 as=0.08775 ps=0.92 w=0.65 l=0.15
X725 a_6918_n132# a_6397_n158# VDPWR VDPWR sky130_fd_pr__pfet_01v8_hvt ad=0.0567 pd=0.69 as=0.0819 ps=0.81 w=0.42 l=0.15
X726 VGND a_14673_3650# a_14415_3650# VGND sky130_fd_pr__nfet_01v8 ad=0.0567 pd=0.69 as=0.1092 ps=1.36 w=0.42 l=0.5
X727 a_14990_386# digital_0.rst VGND VGND sky130_fd_pr__nfet_01v8 ad=0.1134 pd=1.38 as=0.1228 ps=1.065 w=0.42 l=0.15
X728 VGND VDPWR VGND VGND sky130_fd_pr__nfet_01v8 ad=0.143 pd=1.62 as=0 ps=0 w=0.55 l=0.59
X729 a_12849_1866# digital_0._113_.RESET_B VDPWR VDPWR sky130_fd_pr__pfet_01v8_hvt ad=0.1092 pd=1.36 as=0.07035 ps=0.755 w=0.42 l=0.15
X730 a_11949_3132# digital_0._067_.B digital_0._110_.D VDPWR sky130_fd_pr__pfet_01v8_hvt ad=0.26 pd=2.52 as=0.135 ps=1.27 w=1 l=0.15
X731 VDPWR VGND VDPWR VDPWR sky130_fd_pr__pfet_01v8_hvt ad=0.2262 pd=2.26 as=0 ps=0 w=0.87 l=0.59
X732 LELO_GR01_0.x7.x15.I2 LELO_GR01_0.x7.x18.G VDPWR VDPWR sky130_fd_pr__pfet_01v8_lvt ad=0.3168 pd=1.62 as=0.5088 ps=2.98 w=0.96 l=0.94
X733 a_6687_n676# a_6451_n676# VDPWR VDPWR sky130_fd_pr__pfet_01v8_hvt ad=0.1092 pd=1.36 as=0.0567 ps=0.69 w=0.42 l=0.5
X734 VDPWR VGND VDPWR VDPWR sky130_fd_pr__pfet_01v8_hvt ad=0.2262 pd=2.26 as=0 ps=0 w=0.87 l=0.59
X735 VDPWR VGND VDPWR VDPWR sky130_fd_pr__pfet_01v8_hvt ad=0.2262 pd=2.26 as=0 ps=0 w=0.87 l=0.59
X736 a_4327_234# a_4292_0# a_4005_n158# VGND sky130_fd_pr__nfet_01v8 ad=0.06405 pd=0.725 as=0.1092 ps=1.36 w=0.42 l=0.15
X737 a_4828_412# a_4610_386# a_4746_412# VGND sky130_fd_pr__nfet_01v8 ad=0.0441 pd=0.63 as=0.1092 ps=1.36 w=0.42 l=0.15
X738 VGND a_5109_2348# digital_0.output6.A VGND sky130_fd_pr__nfet_01v8 ad=0.169 pd=1.82 as=0.08775 ps=0.92 w=0.65 l=0.15
X739 a_4726_2954# a_4512_2954# VDPWR VDPWR sky130_fd_pr__pfet_01v8_hvt ad=0.1155 pd=0.97 as=0.07035 ps=0.755 w=0.42 l=0.15
X740 LELO_GR01_0.x7.x15.I2 LELO_GR01_0.x7.x18.G VDPWR VDPWR sky130_fd_pr__pfet_01v8_lvt ad=0.3168 pd=1.62 as=0.5088 ps=2.98 w=0.96 l=0.94
X741 VDPWR a_4587_2018# a_4477_2044# VDPWR sky130_fd_pr__pfet_01v8_hvt ad=0.07035 pd=0.755 as=0.1155 ps=0.97 w=0.42 l=0.15
X742 a_5012_3498# digital_0._117_.RESET_B VGND VGND sky130_fd_pr__nfet_01v8 ad=0.06405 pd=0.725 as=0.12495 ps=1.015 w=0.42 l=0.15
X743 a_14319_3828# a_14415_3650# VDPWR VDPWR sky130_fd_pr__pfet_01v8_hvt ad=0.1092 pd=1.36 as=0.14075 ps=1.325 w=0.42 l=0.5
X744 VDPWR a_13306_1500# a_13481_1474# VDPWR sky130_fd_pr__pfet_01v8_hvt ad=0.1134 pd=1.38 as=0.0567 ps=0.69 w=0.42 l=0.15
X745 digital_0._115_.D a_7155_930# a_7099_956# VDPWR sky130_fd_pr__pfet_01v8_hvt ad=0.135 pd=1.27 as=0.28 ps=2.56 w=1 l=0.15
X746 VGND LELO_GR01_0.x7.x18.G LELO_GR01_0.x7.x18.D VGND sky130_fd_pr__nfet_01v8_lvt ad=0.5088 pd=2.98 as=0.3168 ps=1.62 w=0.96 l=0.94
X747 VGND a_8996_1500# digital_0.clkbuf_1_1__f_clk.A VGND sky130_fd_pr__nfet_01v8 ad=0.0588 pd=0.7 as=0.0588 ps=0.7 w=0.42 l=0.15
X748 a_7126_412# digital_0._115_.D VGND VGND sky130_fd_pr__nfet_01v8 ad=0.066 pd=0.745 as=0.2205 ps=1.89 w=0.42 l=0.15
X749 VDPWR VGND VDPWR VDPWR sky130_fd_pr__pfet_01v8_hvt ad=0.2262 pd=2.26 as=0 ps=0 w=0.87 l=0.59
X750 VDPWR digital_0.clkbuf_1_1__f_clk.A a_6315_1474# VDPWR sky130_fd_pr__pfet_01v8_hvt ad=0.14 pd=1.28 as=0.14 ps=1.28 w=1 l=0.15
X751 VGND VDPWR VGND VGND sky130_fd_pr__nfet_01v8 ad=0.143 pd=1.62 as=0 ps=0 w=0.55 l=0.59
X752 digital_0._106_.RESET_B digital_0.load_slew17.X VDPWR VDPWR sky130_fd_pr__pfet_01v8_hvt ad=0.135 pd=1.27 as=0.26 ps=2.52 w=1 l=0.15
X753 a_9353_778# a_8729_412# a_9245_412# VDPWR sky130_fd_pr__pfet_01v8_hvt ad=0.1155 pd=0.97 as=0.07245 ps=0.765 w=0.42 l=0.15
X754 VDPWR a_7439_654# a_7329_778# VDPWR sky130_fd_pr__pfet_01v8_hvt ad=0.07035 pd=0.755 as=0.1155 ps=0.97 w=0.42 l=0.15
X755 a_12646_1500# digital_0._113_.D VDPWR VDPWR sky130_fd_pr__pfet_01v8_hvt ad=0.0651 pd=0.73 as=0.1092 ps=1.36 w=0.42 l=0.15
X756 a_9507_412# a_9463_654# a_9341_412# VGND sky130_fd_pr__nfet_01v8 ad=0.0441 pd=0.63 as=0.1401 ps=1.1 w=0.42 l=0.15
X757 VGND a_11388_956# digital_0.clkload0.A VGND sky130_fd_pr__nfet_01v8 ad=0.0588 pd=0.7 as=0.0588 ps=0.7 w=0.42 l=0.15
X758 LELO_GR01_0.x7.x6<3>.G LELO_GR01_0.x7.x18.D LELO_GR01_0.x7.x18.G VGND sky130_fd_pr__nfet_01v8_lvt ad=0.5088 pd=2.98 as=0.3168 ps=1.62 w=0.96 l=0.94
X759 VGND a_3858_3650# a_3618_3834# VGND sky130_fd_pr__nfet_01v8 ad=0.1228 pd=1.065 as=0.17225 ps=1.83 w=0.65 l=0.25
X760 a_11415_3650# digital_0.hold28.A VDPWR VDPWR sky130_fd_pr__pfet_01v8_hvt ad=0.1176 pd=1.4 as=0.0693 ps=0.75 w=0.42 l=0.15
X761 a_12646_412# digital_0._112_.D VGND VGND sky130_fd_pr__nfet_01v8 ad=0.066 pd=0.745 as=0.2205 ps=1.89 w=0.42 l=0.15
X762 VDPWR VGND VDPWR VDPWR sky130_fd_pr__pfet_01v8_hvt ad=0.2262 pd=2.26 as=0 ps=0 w=0.87 l=0.59
X763 VGND VDPWR VGND VGND sky130_fd_pr__nfet_01v8 ad=0.143 pd=1.62 as=0 ps=0 w=0.55 l=0.59
X764 a_14935_1322# a_14891_930# a_14769_1334# VGND sky130_fd_pr__nfet_01v8 ad=0.0441 pd=0.63 as=0.1401 ps=1.1 w=0.42 l=0.15
X765 VDPWR a_12138_n702# a_11898_n518# VDPWR sky130_fd_pr__pfet_01v8_hvt ad=0.19265 pd=1.415 as=0.2173 ps=2.17 w=0.82 l=0.25
X766 digital_0.clkload0.A a_11388_956# VDPWR VDPWR sky130_fd_pr__pfet_01v8_hvt ad=0.14 pd=1.28 as=0.14 ps=1.28 w=1 l=0.15
X767 a_8996_1500# clk VGND VGND sky130_fd_pr__nfet_01v8 ad=0.0588 pd=0.7 as=0.1113 ps=1.37 w=0.42 l=0.15
X768 VGND VGND LELO_GR01_0.x7.x15.I1 sky130_fd_pr__pnp_05v5_W3p40L3p40
**devattr s=462400,2720
X769 a_4292_0# a_4609_110# a_4567_234# VGND sky130_fd_pr__special_nfet_01v8 ad=0.0711 pd=0.755 as=0.0669 ps=0.75 w=0.36 l=0.15
X770 VGND digital_0._107_.RESET_B a_6719_234# VGND sky130_fd_pr__nfet_01v8 ad=0.12495 pd=1.015 as=0.06405 ps=0.725 w=0.42 l=0.15
X771 VDPWR digital_0.input1.X a_6705_412# VDPWR sky130_fd_pr__pfet_01v8_hvt ad=0.0864 pd=0.91 as=0.1664 ps=1.8 w=0.64 l=0.15
X772 VGND VDPWR VGND VGND sky130_fd_pr__nfet_01v8 ad=0.143 pd=1.62 as=0 ps=0 w=0.55 l=0.59
X773 a_10089_n132# a_9465_n126# a_9981_246# VDPWR sky130_fd_pr__pfet_01v8_hvt ad=0.1155 pd=0.97 as=0.07245 ps=0.765 w=0.42 l=0.15
X774 VDPWR a_15225_n702# a_14967_n702# VDPWR sky130_fd_pr__pfet_01v8_hvt ad=0.0567 pd=0.69 as=0.1092 ps=1.36 w=0.42 l=0.5
X775 a_15537_n132# digital_0._116_.Q VDPWR VDPWR sky130_fd_pr__pfet_01v8_hvt ad=0.135 pd=1.27 as=0.135 ps=1.27 w=1 l=0.15
X776 a_12116_188# digital_0._063_.A digital_0._113_.D VGND sky130_fd_pr__nfet_01v8 ad=0.169 pd=1.82 as=0.10563 ps=0.975 w=0.65 l=0.15
X777 VGND VDPWR VGND VGND sky130_fd_pr__nfet_01v8 ad=0.143 pd=1.62 as=0 ps=0 w=0.55 l=0.59
X778 VDPWR LELO_GR01_0.x7.x18.G LELO_GR01_0.x7.x15.I2 VDPWR sky130_fd_pr__pfet_01v8_lvt ad=0.5088 pd=2.98 as=0.3168 ps=1.62 w=0.96 l=0.94
X779 a_14578_1322# digital_0._104_.D VGND VGND sky130_fd_pr__nfet_01v8 ad=0.066 pd=0.745 as=0.2205 ps=1.89 w=0.42 l=0.15
X780 a_5029_956# a_4405_962# a_4921_1334# VDPWR sky130_fd_pr__pfet_01v8_hvt ad=0.1155 pd=0.97 as=0.07245 ps=0.765 w=0.42 l=0.15
X781 a_15400_956# a_14323_962# a_15238_1334# VDPWR sky130_fd_pr__pfet_01v8_hvt ad=0.0567 pd=0.69 as=0.0588 ps=0.7 w=0.42 l=0.15
X782 VGND VDPWR VGND VGND sky130_fd_pr__nfet_01v8 ad=0.143 pd=1.62 as=0 ps=0 w=0.55 l=0.59
X783 a_3471_1474# digital_0.input2.X VDPWR VDPWR sky130_fd_pr__pfet_01v8_hvt ad=0.0567 pd=0.69 as=0.16655 ps=1.39 w=0.42 l=0.15
X784 VDPWR digital_0.input1.X a_6889_2588# VDPWR sky130_fd_pr__pfet_01v8_hvt ad=0.0864 pd=0.91 as=0.1664 ps=1.8 w=0.64 l=0.15
X785 VGND a_7961_386# digital_0._115_.Q VGND sky130_fd_pr__nfet_01v8 ad=0.169 pd=1.82 as=0.08775 ps=0.92 w=0.65 l=0.15
X786 VGND digital_0.input1.X a_8729_412# VGND sky130_fd_pr__nfet_01v8 ad=0.0567 pd=0.69 as=0.1092 ps=1.36 w=0.42 l=0.15
X787 VGND a_11415_3650# a_11349_3676# VGND sky130_fd_pr__nfet_01v8 ad=0.1449 pd=1.11 as=0.0693 ps=0.75 w=0.42 l=0.15
X788 LELO_GR01_0.x7.x21.D LELO_GR01_0.x8.PWRUP_N_1V8 LELO_GR01_0.x7.x20.D VDPWR sky130_fd_pr__pfet_01v8_lvt ad=0.5088 pd=2.98 as=0.3168 ps=1.62 w=0.96 l=0.94
X789 VGND VDPWR VGND VGND sky130_fd_pr__nfet_01v8 ad=0.143 pd=1.62 as=0 ps=0 w=0.55 l=0.59
X790 VDPWR digital_0.output13.A a_6906_3132# VDPWR sky130_fd_pr__pfet_01v8_hvt ad=0.135 pd=1.27 as=0.135 ps=1.27 w=1 l=0.15
X791 VDPWR digital_0._107_.RESET_B a_7302_n132# VDPWR sky130_fd_pr__pfet_01v8_hvt ad=0.07035 pd=0.755 as=0.1092 ps=1.36 w=0.42 l=0.15
X792 LELO_GR01_0.x7.x18.D LELO_GR01_0.x8.PWRUP_N_1V8 LELO_GR01_0.x7.x19.D VDPWR sky130_fd_pr__pfet_01v8_lvt ad=0.3168 pd=1.62 as=0.5088 ps=2.98 w=0.96 l=0.94
X793 a_7099_956# digital_0._060_.A_N VDPWR VDPWR sky130_fd_pr__pfet_01v8_hvt ad=0.135 pd=1.27 as=0.1625 ps=1.325 w=1 l=0.15
X794 VDPWR VGND VDPWR VDPWR sky130_fd_pr__pfet_01v8_hvt ad=0.2262 pd=2.26 as=0 ps=0 w=0.87 l=0.59
X795 VDPWR digital_0.load_slew15.X digital_0._118_.RESET_B VDPWR sky130_fd_pr__pfet_01v8_hvt ad=0.26 pd=2.52 as=0.135 ps=1.27 w=1 l=0.15
X796 a_12189_3650# digital_0.output8.A VDPWR VDPWR sky130_fd_pr__pfet_01v8_hvt ad=0.1092 pd=1.36 as=0.0567 ps=0.69 w=0.42 l=0.15
X797 a_9981_246# a_9465_n126# a_9886_234# VGND sky130_fd_pr__special_nfet_01v8 ad=0.0594 pd=0.69 as=0.066 ps=0.745 w=0.36 l=0.15
X798 a_6961_2044# digital_0._108_.RESET_B VDPWR VDPWR sky130_fd_pr__pfet_01v8_hvt ad=0.1092 pd=1.36 as=0.07035 ps=0.755 w=0.42 l=0.15
X799 a_15413_1260# digital_0._104_.RESET_B VDPWR VDPWR sky130_fd_pr__pfet_01v8_hvt ad=0.0567 pd=0.69 as=0.0819 ps=0.81 w=0.42 l=0.15
X800 VDPWR VGND VDPWR VDPWR sky130_fd_pr__pfet_01v8_hvt ad=0.2262 pd=2.26 as=0 ps=0 w=0.87 l=0.59
X801 a_3471_1474# digital_0._116_.Q a_3717_1528# VGND sky130_fd_pr__nfet_01v8 ad=0.1176 pd=1.4 as=0.0567 ps=0.69 w=0.42 l=0.15
X802 VGND a_8145_2562# a_8079_2588# VGND sky130_fd_pr__nfet_01v8 ad=0.12495 pd=1.015 as=0.0669 ps=0.75 w=0.42 l=0.15
X803 VGND VDPWR VGND VGND sky130_fd_pr__nfet_01v8 ad=0.143 pd=1.62 as=0 ps=0 w=0.55 l=0.59
X804 a_3743_3138# a_3577_3138# VDPWR VDPWR sky130_fd_pr__pfet_01v8_hvt ad=0.1664 pd=1.8 as=0.0864 ps=0.91 w=0.64 l=0.15
X805 VDPWR digital_0._116_.Q a_7717_3926# VDPWR sky130_fd_pr__pfet_01v8_hvt ad=0.135 pd=1.27 as=0.28 ps=2.56 w=1 l=0.15
X806 VDPWR digital_0.hold28.X a_5328_n132# VDPWR sky130_fd_pr__pfet_01v8_hvt ad=0.1092 pd=1.36 as=0.0651 ps=0.73 w=0.42 l=0.15
X807 LELO_GR01_0.x7.x1.x5.IBN LELO_GR01_0.x7.x1.x5.x9<2>.G VGND VGND sky130_fd_pr__nfet_01v8_lvt ad=0.3168 pd=1.62 as=0.5088 ps=2.98 w=0.96 l=0.94
X808 VGND a_11951_2146# digital_0._063_.A VGND sky130_fd_pr__nfet_01v8 ad=0.17875 pd=1.85 as=0.08775 ps=0.92 w=0.65 l=0.15
X809 digital_0._118_.RESET_B digital_0.load_slew15.X VGND VGND sky130_fd_pr__nfet_01v8 ad=0.08775 pd=0.92 as=0.169 ps=1.82 w=0.65 l=0.15
X810 a_13003_412# a_12959_654# a_12837_412# VGND sky130_fd_pr__nfet_01v8 ad=0.0441 pd=0.63 as=0.1401 ps=1.1 w=0.42 l=0.15
X811 VDPWR clk a_8996_1500# VDPWR sky130_fd_pr__pfet_01v8_hvt ad=0.14 pd=1.28 as=0.14 ps=1.28 w=1 l=0.15
X812 VGND a_8578_n132# a_8689_n132# VGND sky130_fd_pr__nfet_01v8 ad=0.1856 pd=1.26 as=0.17225 ps=1.83 w=0.65 l=0.25
X813 a_5661_1260# a_5486_1334# a_5840_1322# VGND sky130_fd_pr__nfet_01v8 ad=0.1092 pd=1.36 as=0.06405 ps=0.725 w=0.42 l=0.15
X814 VDPWR a_7418_2422# a_7593_2348# VDPWR sky130_fd_pr__pfet_01v8_hvt ad=0.1134 pd=1.38 as=0.0567 ps=0.69 w=0.42 l=0.15
X815 a_4488_778# a_4118_412# VDPWR VDPWR sky130_fd_pr__pfet_01v8_hvt ad=0.0441 pd=0.63 as=0.1092 ps=1.36 w=0.42 l=0.15
X816 a_14298_1652# digital_0._112_.Q a_14440_1500# VGND sky130_fd_pr__nfet_01v8 ad=0.09975 pd=0.895 as=0.0693 ps=0.75 w=0.42 l=0.15
X817 a_14769_3436# digital_0._102_.RESET_B VDPWR VDPWR sky130_fd_pr__pfet_01v8_hvt ad=0.0567 pd=0.69 as=0.0819 ps=0.81 w=0.42 l=0.15
X818 VGND digital_0._108_.Q a_7607_3452# VGND sky130_fd_pr__nfet_01v8 ad=0.10725 pd=0.98 as=0.06825 ps=0.86 w=0.65 l=0.15
X819 VGND VDPWR VGND VGND sky130_fd_pr__nfet_01v8 ad=0.143 pd=1.62 as=0 ps=0 w=0.55 l=0.59
X820 digital_0._114_.Q a_9985_386# VGND VGND sky130_fd_pr__nfet_01v8 ad=0.08775 pd=0.92 as=0.2087 ps=2.02 w=0.65 l=0.15
X821 a_9631_n126# a_9465_n126# VDPWR VDPWR sky130_fd_pr__pfet_01v8_hvt ad=0.1664 pd=1.8 as=0.0864 ps=0.91 w=0.64 l=0.15
X822 a_14229_n132# digital_0._105_.RESET_B VDPWR VDPWR sky130_fd_pr__pfet_01v8_hvt ad=0.1092 pd=1.36 as=0.07035 ps=0.755 w=0.42 l=0.15
X823 VDPWR digital_0._065_.A2_N a_11951_2146# VDPWR sky130_fd_pr__pfet_01v8_hvt ad=0.15075 pd=1.345 as=0.07438 ps=0.815 w=0.42 l=0.15
X824 a_11839_2588# a_11673_2588# VGND VGND sky130_fd_pr__nfet_01v8 ad=0.1092 pd=1.36 as=0.0567 ps=0.69 w=0.42 l=0.15
X825 VDPWR a_6315_1474# digital_0.clkbuf_1_0__f_clk.X VDPWR sky130_fd_pr__pfet_01v8_hvt ad=0.14 pd=1.28 as=0.14 ps=1.28 w=1 l=0.15
X826 a_4934_2422# a_4019_2050# a_4587_2018# VGND sky130_fd_pr__special_nfet_01v8 ad=0.0711 pd=0.755 as=0.0999 ps=0.985 w=0.36 l=0.15
X827 VGND digital_0._111_.Q a_10571_2588# VGND sky130_fd_pr__nfet_01v8 ad=0.0567 pd=0.69 as=0.0567 ps=0.69 w=0.42 l=0.15
X828 digital_0.hold28.A a_4833_3436# VGND VGND sky130_fd_pr__nfet_01v8 ad=0.08775 pd=0.92 as=0.2087 ps=2.02 w=0.65 l=0.15
X829 LELO_GR01_0.x7.x25.D LELO_GR01_0.x8.PWRUP_N_1V8 LELO_GR01_0.x7.x24.D VDPWR sky130_fd_pr__pfet_01v8_lvt ad=0.5088 pd=2.98 as=0.3168 ps=1.62 w=0.96 l=0.94
X830 VDPWR VGND VDPWR VDPWR sky130_fd_pr__pfet_01v8_hvt ad=0.2262 pd=2.26 as=0 ps=0 w=0.87 l=0.59
X831 LELO_GR01_0.x8.VREF_BG LELO_GR01_0.x7.x18.G VDPWR VDPWR sky130_fd_pr__pfet_01v8_lvt ad=0.3168 pd=1.62 as=0.5088 ps=2.98 w=0.96 l=0.94
X832 LELO_GR01_0.x7.x22.D LELO_GR01_0.x8.PWRUP_N_1V8 LELO_GR01_0.x7.x23.D VDPWR sky130_fd_pr__pfet_01v8_lvt ad=0.3168 pd=1.62 as=0.5088 ps=2.98 w=0.96 l=0.94
X833 a_8578_n676# a_8361_n676# VGND VGND sky130_fd_pr__nfet_01v8 ad=0.17225 pd=1.83 as=0.1228 ps=1.065 w=0.65 l=0.25
X834 a_7157_n158# a_6962_n16# a_7467_234# VGND sky130_fd_pr__special_nfet_01v8 ad=0.0594 pd=0.69 as=0.1401 ps=1.1 w=0.36 l=0.15
X835 a_13771_n126# a_13605_n126# VDPWR VDPWR sky130_fd_pr__pfet_01v8_hvt ad=0.1664 pd=1.8 as=0.0864 ps=0.91 w=0.64 l=0.15
X836 a_10723_1276# digital_0._069_.A a_10639_1276# VGND sky130_fd_pr__nfet_01v8 ad=0.13975 pd=1.08 as=0.08775 ps=0.92 w=0.65 l=0.15
X837 LELO_GR01_0.x7.x1.x5.x8.G LELO_GR01_0.x7.x1.x5.x8.G LELO_GR01_0.x7.x1.x5.x9<2>.G VGND sky130_fd_pr__nfet_01v8_lvt ad=0.3168 pd=1.62 as=0.5088 ps=2.98 w=0.96 l=0.94
X838 VDPWR digital_0._065_.A2_N a_10997_386# VDPWR sky130_fd_pr__pfet_01v8_hvt ad=0.0777 pd=0.79 as=0.0588 ps=0.7 w=0.42 l=0.15
X839 a_5855_564# a_5951_386# VDPWR VDPWR sky130_fd_pr__pfet_01v8_hvt ad=0.1092 pd=1.36 as=0.14075 ps=1.325 w=0.42 l=0.5
X840 VDPWR digital_0._119_.RESET_B a_4910_n132# VDPWR sky130_fd_pr__pfet_01v8_hvt ad=0.07035 pd=0.755 as=0.1092 ps=1.36 w=0.42 l=0.15
X841 VGND digital_0._108_.RESET_B a_7115_2410# VGND sky130_fd_pr__nfet_01v8 ad=0.1346 pd=1.15 as=0.0441 ps=0.63 w=0.42 l=0.15
X842 a_13306_412# a_12225_412# a_12959_654# VDPWR sky130_fd_pr__pfet_01v8_hvt ad=0.0588 pd=0.7 as=0.12915 ps=1.185 w=0.42 l=0.15
X843 VGND a_4015_1652# digital_0.hold19.X VGND sky130_fd_pr__nfet_01v8 ad=0.097 pd=0.975 as=0.169 ps=1.82 w=0.65 l=0.15
X844 a_10708_2044# a_9631_2050# a_10546_2422# VDPWR sky130_fd_pr__pfet_01v8_hvt ad=0.0567 pd=0.69 as=0.0588 ps=0.7 w=0.42 l=0.15
X845 digital_0.clkbuf_1_0__f_clk.X a_6315_1474# VGND VGND sky130_fd_pr__nfet_01v8 ad=0.0588 pd=0.7 as=0.0588 ps=0.7 w=0.42 l=0.15
X846 VDPWR VGND VDPWR VDPWR sky130_fd_pr__pfet_01v8_hvt ad=0.2262 pd=2.26 as=0 ps=0 w=0.87 l=0.59
X847 VDPWR VGND VDPWR VDPWR sky130_fd_pr__pfet_01v8_hvt ad=0.2262 pd=2.26 as=0 ps=0 w=0.87 l=0.59
X848 a_14861_172# digital_0._105_.RESET_B VDPWR VDPWR sky130_fd_pr__pfet_01v8_hvt ad=0.0567 pd=0.69 as=0.0819 ps=0.81 w=0.42 l=0.15
X849 a_10199_n158# a_9981_246# VGND VGND sky130_fd_pr__nfet_01v8 ad=0.0999 pd=0.985 as=0.1346 ps=1.15 w=0.64 l=0.15
X850 a_11949_3132# digital_0._067_.A VDPWR VDPWR sky130_fd_pr__pfet_01v8_hvt ad=0.135 pd=1.27 as=0.135 ps=1.27 w=1 l=0.15
X851 VGND a_5974_n676# digital_0._116_.D VGND sky130_fd_pr__nfet_01v8 ad=0.17225 pd=1.83 as=0.091 ps=0.93 w=0.65 l=0.15
X852 a_5014_778# a_4746_412# VDPWR VDPWR sky130_fd_pr__pfet_01v8_hvt ad=0.0945 pd=0.87 as=0.0798 ps=0.8 w=0.42 l=0.15
X853 VGND a_4369_1474# a_4111_1474# VGND sky130_fd_pr__nfet_01v8 ad=0.0567 pd=0.69 as=0.1092 ps=1.36 w=0.42 l=0.5
X854 a_4019_2050# a_3853_2050# VGND VGND sky130_fd_pr__nfet_01v8 ad=0.1092 pd=1.36 as=0.0567 ps=0.69 w=0.42 l=0.15
X855 VGND a_13978_3650# a_13738_3834# VGND sky130_fd_pr__nfet_01v8 ad=0.1228 pd=1.065 as=0.17225 ps=1.83 w=0.65 l=0.25
X856 VDPWR LELO_GR01_0.x7.x18.G LELO_GR01_0.x8.IBP_BG VDPWR sky130_fd_pr__pfet_01v8_lvt ad=0.5088 pd=2.98 as=0.3168 ps=1.62 w=0.96 l=0.94
X857 a_7329_778# a_6705_412# a_7221_412# VDPWR sky130_fd_pr__pfet_01v8_hvt ad=0.1155 pd=0.97 as=0.07245 ps=0.765 w=0.42 l=0.15
X858 VDPWR a_10074_2562# digital_0._111_.D VDPWR sky130_fd_pr__pfet_01v8_hvt ad=0.154 pd=1.335 as=0.135 ps=1.27 w=1 l=0.15
X859 VGND a_13746_n524# digital_0._105_.D VGND sky130_fd_pr__nfet_01v8 ad=0.11285 pd=1.045 as=0.169 ps=1.82 w=0.65 l=0.15
X860 a_4093_3510# a_3743_3138# a_3998_3498# VDPWR sky130_fd_pr__pfet_01v8_hvt ad=0.07245 pd=0.765 as=0.0651 ps=0.73 w=0.42 l=0.15
X861 a_12718_3676# a_12501_3676# VDPWR VDPWR sky130_fd_pr__pfet_01v8_hvt ad=0.2173 pd=2.17 as=0.19265 ps=1.415 w=0.82 l=0.25
X862 digital_0.clkbuf_1_1__f_clk.A a_8996_1500# VDPWR VDPWR sky130_fd_pr__pfet_01v8_hvt ad=0.14 pd=1.28 as=0.14 ps=1.28 w=1 l=0.15
X863 VDPWR VGND VDPWR VDPWR sky130_fd_pr__pfet_01v8_hvt ad=0.2262 pd=2.26 as=0 ps=0 w=0.87 l=0.59
X864 digital_0._115_.D digital_0._060_.A_N a_7375_1276# VGND sky130_fd_pr__nfet_01v8 ad=0.10563 pd=0.975 as=0.169 ps=1.82 w=0.65 l=0.15
X865 VDPWR a_7970_2588# a_8145_2562# VDPWR sky130_fd_pr__pfet_01v8_hvt ad=0.1134 pd=1.38 as=0.0567 ps=0.69 w=0.42 l=0.15
X866 a_12977_2044# digital_0.load_slew17.A digital_0._110_.RESET_B VDPWR sky130_fd_pr__pfet_01v8_hvt ad=0.135 pd=1.27 as=0.135 ps=1.27 w=1 l=0.15
X867 VDPWR VGND VDPWR VDPWR sky130_fd_pr__pfet_01v8_hvt ad=0.2262 pd=2.26 as=0 ps=0 w=0.87 l=0.59
X868 a_12849_778# a_12225_412# a_12741_412# VDPWR sky130_fd_pr__pfet_01v8_hvt ad=0.1155 pd=0.97 as=0.07245 ps=0.765 w=0.42 l=0.15
X869 VGND digital_0._065_.A2_N a_12106_2404# VGND sky130_fd_pr__nfet_01v8 ad=0.1304 pd=1.105 as=0.05355 ps=0.675 w=0.42 l=0.15
X870 VDPWR digital_0._112_.Q a_11951_2146# VDPWR sky130_fd_pr__pfet_01v8_hvt ad=0.0567 pd=0.69 as=0.1092 ps=1.36 w=0.42 l=0.15
X871 digital_0._110_.D digital_0._067_.A VGND VGND sky130_fd_pr__nfet_01v8 ad=0.08775 pd=0.92 as=0.182 ps=1.86 w=0.65 l=0.15
X872 a_6315_1474# digital_0.clkbuf_1_1__f_clk.A VDPWR VDPWR sky130_fd_pr__pfet_01v8_hvt ad=0.14 pd=1.28 as=0.14 ps=1.28 w=1 l=0.15
X873 digital_0._109_.Q a_8145_2562# VGND VGND sky130_fd_pr__nfet_01v8 ad=0.08775 pd=0.92 as=0.2087 ps=2.02 w=0.65 l=0.15
X874 VGND VDPWR VGND VGND sky130_fd_pr__nfet_01v8 ad=0.143 pd=1.62 as=0 ps=0 w=0.55 l=0.59
X875 VDPWR a_13746_n524# digital_0._105_.D VDPWR sky130_fd_pr__pfet_01v8_hvt ad=0.15835 pd=1.395 as=0.26 ps=2.52 w=1 l=0.15
X876 a_9463_654# a_9245_412# VGND VGND sky130_fd_pr__nfet_01v8 ad=0.0999 pd=0.985 as=0.1346 ps=1.15 w=0.64 l=0.15
X877 digital_0._069_.B digital_0.output13.A a_7436_3452# VGND sky130_fd_pr__nfet_01v8 ad=0.091 pd=0.93 as=0.08937 ps=0.925 w=0.65 l=0.15
X878 VDPWR a_3471_1474# digital_0._118_.D VDPWR sky130_fd_pr__pfet_01v8_hvt ad=0.16655 pd=1.39 as=0.195 ps=1.39 w=1 l=0.15
X879 a_4921_1334# a_4405_962# a_4826_1322# VGND sky130_fd_pr__special_nfet_01v8 ad=0.0594 pd=0.69 as=0.066 ps=0.745 w=0.36 l=0.15
X880 digital_0._110_.RESET_B digital_0.load_slew17.A VGND VGND sky130_fd_pr__nfet_01v8 ad=0.08775 pd=0.92 as=0.169 ps=1.82 w=0.65 l=0.15
X881 a_4201_3132# a_3577_3138# a_4093_3510# VDPWR sky130_fd_pr__pfet_01v8_hvt ad=0.1155 pd=0.97 as=0.07245 ps=0.765 w=0.42 l=0.15
X882 LELO_GR01_0.x7.x7.G LELO_GR01_0.x7.x18.G VDPWR VDPWR sky130_fd_pr__pfet_01v8_lvt ad=0.3168 pd=1.62 as=0.5088 ps=2.98 w=0.96 l=0.94
X883 VGND digital_0._060_.A_N a_9417_n702# VGND sky130_fd_pr__nfet_01v8 ad=0.1092 pd=1.36 as=0.1092 ps=1.36 w=0.42 l=0.15
X884 VDPWR a_15268_1474# digital_0.load_slew17.A VDPWR sky130_fd_pr__pfet_01v8_hvt ad=0.2726 pd=1.61 as=0.495 ps=2.99 w=1 l=0.15
X885 a_10900_2410# digital_0._111_.RESET_B VGND VGND sky130_fd_pr__nfet_01v8 ad=0.06405 pd=0.725 as=0.12495 ps=1.015 w=0.42 l=0.15
X886 VGND digital_0.load_slew15.X digital_0._107_.RESET_B VGND sky130_fd_pr__nfet_01v8 ad=0.169 pd=1.82 as=0.08775 ps=0.92 w=0.65 l=0.15
X887 digital_0._116_.D a_5974_n676# VDPWR VDPWR sky130_fd_pr__pfet_01v8_hvt ad=0.14 pd=1.28 as=0.265 ps=2.53 w=1 l=0.15
X888 VDPWR digital_0._110_.Q a_12517_2044# VDPWR sky130_fd_pr__pfet_01v8_hvt ad=0.135 pd=1.27 as=0.135 ps=1.27 w=1 l=0.15
X889 VGND a_9564_930# digital_0.load_slew15.A VGND sky130_fd_pr__nfet_01v8 ad=0.1856 pd=1.26 as=0.2079 ps=1.83 w=0.42 l=0.15
X890 digital_0._108_.D digital_0._108_.Q a_6455_3452# VGND sky130_fd_pr__nfet_01v8 ad=0.10563 pd=0.975 as=0.169 ps=1.82 w=0.65 l=0.15
X891 VGND a_12929_2562# digital_0._110_.Q VGND sky130_fd_pr__nfet_01v8 ad=0.169 pd=1.82 as=0.08775 ps=0.92 w=0.65 l=0.15
X892 a_9463_654# a_9245_412# VDPWR VDPWR sky130_fd_pr__pfet_01v8_hvt ad=0.12915 pd=1.185 as=0.2184 ps=2.2 w=0.84 l=0.15
X893 VGND VDPWR VGND VGND sky130_fd_pr__nfet_01v8 ad=0.143 pd=1.62 as=0 ps=0 w=0.55 l=0.59
X894 VDPWR LELO_GR01_0.PWRUP_1V8 LELO_GR01_0.x8.x1.x7.D VDPWR sky130_fd_pr__pfet_01v8_lvt ad=0.5088 pd=2.98 as=0.3168 ps=1.62 w=0.96 l=0.94
X895 VDPWR a_8996_1500# digital_0.clkbuf_1_1__f_clk.A VDPWR sky130_fd_pr__pfet_01v8_hvt ad=0.14 pd=1.28 as=0.14 ps=1.28 w=1 l=0.15
X896 a_4015_1652# a_4111_1474# VGND VGND sky130_fd_pr__nfet_01v8 ad=0.1092 pd=1.36 as=0.097 ps=0.975 w=0.42 l=0.5
X897 VDPWR VGND VDPWR VDPWR sky130_fd_pr__pfet_01v8_hvt ad=0.2262 pd=2.26 as=0 ps=0 w=0.87 l=0.59
X898 a_7623_2830# a_7405_2588# VDPWR VDPWR sky130_fd_pr__pfet_01v8_hvt ad=0.12915 pd=1.185 as=0.2184 ps=2.2 w=0.84 l=0.15
R4 uio_oe<6> li_28516_19376# sky130_fd_pr__res_generic_m4 w=0.3 l=0.3
X899 VGND digital_0.input1.X a_9465_2050# VGND sky130_fd_pr__nfet_01v8 ad=0.0567 pd=0.69 as=0.1092 ps=1.36 w=0.42 l=0.15
X900 digital_0.clkload0.A a_11388_956# VDPWR VDPWR sky130_fd_pr__pfet_01v8_hvt ad=0.14 pd=1.28 as=0.1375 ps=1.275 w=1 l=0.15
X901 VDPWR a_11098_3510# a_11273_3436# VDPWR sky130_fd_pr__pfet_01v8_hvt ad=0.1134 pd=1.38 as=0.0567 ps=0.69 w=0.42 l=0.15
X902 digital_0._107_.RESET_B digital_0.load_slew15.X VDPWR VDPWR sky130_fd_pr__pfet_01v8_hvt ad=0.135 pd=1.27 as=0.26 ps=2.52 w=1 l=0.15
X903 a_13468_1866# a_12391_1500# a_13306_1500# VDPWR sky130_fd_pr__pfet_01v8_hvt ad=0.0567 pd=0.69 as=0.0588 ps=0.7 w=0.42 l=0.15
X904 VGND a_14769_3436# digital_0.output7.A VGND sky130_fd_pr__nfet_01v8 ad=0.169 pd=1.82 as=0.08775 ps=0.92 w=0.65 l=0.15
X905 a_10089_n132# digital_0._106_.RESET_B VDPWR VDPWR sky130_fd_pr__pfet_01v8_hvt ad=0.1092 pd=1.36 as=0.07035 ps=0.755 w=0.42 l=0.15
X906 a_5043_2422# a_3853_2050# a_4934_2422# VGND sky130_fd_pr__special_nfet_01v8 ad=0.0669 pd=0.75 as=0.0711 ps=0.755 w=0.36 l=0.15
X907 VGND a_5422_n702# a_5182_n518# VGND sky130_fd_pr__nfet_01v8 ad=0.1228 pd=1.065 as=0.17225 ps=1.83 w=0.65 l=0.25
X908 VDPWR a_14247_3106# a_14137_3132# VDPWR sky130_fd_pr__pfet_01v8_hvt ad=0.07035 pd=0.755 as=0.1155 ps=0.97 w=0.42 l=0.15
X909 digital_0.load_slew15.X a_8085_1500# VGND VGND sky130_fd_pr__nfet_01v8 ad=0.08775 pd=0.92 as=0.08775 ps=0.92 w=0.65 l=0.15
X910 VDPWR VGND VDPWR VDPWR sky130_fd_pr__pfet_01v8_hvt ad=0.2262 pd=2.26 as=0 ps=0 w=0.87 l=0.59
X911 digital_0._115_.Q a_7961_386# VDPWR VDPWR sky130_fd_pr__pfet_01v8_hvt ad=0.135 pd=1.27 as=0.3012 ps=2.66 w=1 l=0.15
X912 a_10655_2910# digital_0._111_.Q a_10074_2562# VDPWR sky130_fd_pr__pfet_01v8_hvt ad=0.0864 pd=0.91 as=0.0928 ps=0.93 w=0.64 l=0.15
X913 VDPWR digital_0.output13.A a_6179_3132# VDPWR sky130_fd_pr__pfet_01v8_hvt ad=0.135 pd=1.27 as=0.135 ps=1.27 w=1 l=0.15
X914 a_10721_172# a_10546_246# a_10900_234# VGND sky130_fd_pr__nfet_01v8 ad=0.1092 pd=1.36 as=0.06405 ps=0.725 w=0.42 l=0.15
X915 VDPWR VGND VDPWR VDPWR sky130_fd_pr__pfet_01v8_hvt ad=0.2262 pd=2.26 as=0 ps=0 w=0.87 l=0.59
X916 a_6197_2588# digital_0.hold25.X a_5834_2740# VGND sky130_fd_pr__nfet_01v8 ad=0.0693 pd=0.75 as=0.09975 ps=0.895 w=0.42 l=0.15
X917 digital_0.clkbuf_1_0__f_clk.X a_6315_1474# VGND VGND sky130_fd_pr__nfet_01v8 ad=0.0588 pd=0.7 as=0.05775 ps=0.695 w=0.42 l=0.15
X918 VDPWR a_10546_246# a_10721_172# VDPWR sky130_fd_pr__pfet_01v8_hvt ad=0.1134 pd=1.38 as=0.0567 ps=0.69 w=0.42 l=0.15
X919 digital_0._102_.D a_12889_3171# VGND VGND sky130_fd_pr__nfet_01v8 ad=0.169 pd=1.82 as=0.11285 ps=1.045 w=0.65 l=0.15
X920 a_5976_2588# digital_0.hold28.A VGND VGND sky130_fd_pr__nfet_01v8 ad=0.0693 pd=0.75 as=0.11285 ps=1.045 w=0.42 l=0.15
X921 VGND ui_in<0> a_8361_n132# VGND sky130_fd_pr__nfet_01v8 ad=0.1228 pd=1.065 as=0.1134 ps=1.38 w=0.42 l=0.15
X922 a_7375_1276# digital_0._060_.A_N digital_0._115_.D VGND sky130_fd_pr__nfet_01v8 ad=0.08775 pd=0.92 as=0.10563 ps=0.975 w=0.65 l=0.15
X923 a_4465_2422# a_4019_2050# a_4369_2422# VGND sky130_fd_pr__special_nfet_01v8 ad=0.1401 pd=1.1 as=0.0594 ps=0.69 w=0.36 l=0.15
X924 VDPWR a_12929_2562# a_12916_2954# VDPWR sky130_fd_pr__pfet_01v8_hvt ad=0.0819 pd=0.81 as=0.0567 ps=0.69 w=0.42 l=0.15
X925 a_7970_2588# a_6889_2588# a_7623_2830# VDPWR sky130_fd_pr__pfet_01v8_hvt ad=0.0588 pd=0.7 as=0.12915 ps=1.185 w=0.42 l=0.15
X926 VDPWR digital_0.output4.A a_4243_n676# VDPWR sky130_fd_pr__pfet_01v8_hvt ad=0.0567 pd=0.69 as=0.1092 ps=1.36 w=0.42 l=0.15
X927 digital_0.clkload0.A a_11388_956# VDPWR VDPWR sky130_fd_pr__pfet_01v8_hvt ad=0.14 pd=1.28 as=0.14 ps=1.28 w=1 l=0.15
X928 VGND digital_0.output12.A a_6451_n676# VGND sky130_fd_pr__nfet_01v8 ad=0.0567 pd=0.69 as=0.1092 ps=1.36 w=0.42 l=0.15
X929 a_9981_246# a_9631_n126# a_9886_234# VDPWR sky130_fd_pr__pfet_01v8_hvt ad=0.07245 pd=0.765 as=0.0651 ps=0.73 w=0.42 l=0.15
X930 VGND a_11388_956# digital_0.clkload0.A VGND sky130_fd_pr__nfet_01v8 ad=0.0588 pd=0.7 as=0.0588 ps=0.7 w=0.42 l=0.15
X931 LELO_GR01_0.x8.x1.x5.x8.G LELO_GR01_0.x8.x1.x5.x8.G LELO_GR01_0.x8.x1.x5.x9<2>.G VGND sky130_fd_pr__nfet_01v8_lvt ad=0.3168 pd=1.62 as=0.5088 ps=2.98 w=0.96 l=0.94
X932 a_7157_n158# a_7001_110# a_7302_n132# VDPWR sky130_fd_pr__pfet_01v8_hvt ad=0.07245 pd=0.765 as=0.1155 ps=0.97 w=0.42 l=0.15
X933 a_5785_n426# digital_0._116_.Q VDPWR VDPWR sky130_fd_pr__pfet_01v8_hvt ad=0.14 pd=1.28 as=0.1575 ps=1.315 w=1 l=0.15
X934 digital_0.clkbuf_1_0__f_clk.X a_6315_1474# VDPWR VDPWR sky130_fd_pr__pfet_01v8_hvt ad=0.14 pd=1.28 as=0.265 ps=2.53 w=1 l=0.15
X935 VGND a_12929_2562# a_12863_2588# VGND sky130_fd_pr__nfet_01v8 ad=0.12495 pd=1.015 as=0.0669 ps=0.75 w=0.42 l=0.15
X936 VGND a_5855_564# digital_0.hold22.X VGND sky130_fd_pr__nfet_01v8 ad=0.097 pd=0.975 as=0.169 ps=1.82 w=0.65 l=0.15
X937 VDPWR LELO_GR01_0.x8.x1.x7.D LELO_GR01_0.x8.x1.x7.D VDPWR sky130_fd_pr__pfet_01v8_lvt ad=0.5088 pd=2.98 as=0.3168 ps=1.62 w=0.96 l=0.94
X938 VGND digital_0._115_.RESET_B a_7483_412# VGND sky130_fd_pr__nfet_01v8 ad=0.1346 pd=1.15 as=0.0441 ps=0.63 w=0.42 l=0.15
X939 digital_0._108_.RESET_B digital_0.load_slew15.A VGND VGND sky130_fd_pr__nfet_01v8 ad=0.08775 pd=0.92 as=0.169 ps=1.82 w=0.65 l=0.15
X940 VDPWR digital_0._116_.Q a_5785_1750# VDPWR sky130_fd_pr__pfet_01v8_hvt ad=0.135 pd=1.27 as=0.28 ps=2.56 w=1 l=0.15
X941 a_9557_2838# digital_0.load_slew17.A digital_0._111_.RESET_B VDPWR sky130_fd_pr__pfet_01v8_hvt ad=0.26 pd=2.52 as=0.135 ps=1.27 w=1 l=0.15
X942 VGND LELO_GR01_0.x8.x1.x5.x9<2>.G LELO_GR01_0.x8.x1.x5.x8.G VGND sky130_fd_pr__nfet_01v8_lvt ad=0.5088 pd=2.98 as=0.3168 ps=1.62 w=0.96 l=0.94
X943 LELO_GR01_0.x8.x7.D LELO_GR01_0.x8.x1.x7.D VDPWR VDPWR sky130_fd_pr__pfet_01v8_lvt ad=0.3168 pd=1.62 as=0.5088 ps=2.98 w=0.96 l=0.94
X944 VDPWR VGND VDPWR VDPWR sky130_fd_pr__pfet_01v8_hvt ad=0.2262 pd=2.26 as=0 ps=0 w=0.87 l=0.59
X945 digital_0._116_.SET_B digital_0.load_slew15.X VDPWR VDPWR sky130_fd_pr__pfet_01v8_hvt ad=0.135 pd=1.27 as=0.26 ps=2.52 w=1 l=0.15
X946 digital_0._115_.RESET_B digital_0.load_slew17.X a_5785_1750# VDPWR sky130_fd_pr__pfet_01v8_hvt ad=0.135 pd=1.27 as=0.135 ps=1.27 w=1 l=0.15
X947 a_5787_2146# digital_0._109_.Q VDPWR VDPWR sky130_fd_pr__pfet_01v8_hvt ad=0.07438 pd=0.815 as=0.0567 ps=0.69 w=0.42 l=0.15
X948 digital_0.clkbuf_1_1__f_clk.A a_8996_1500# VDPWR VDPWR sky130_fd_pr__pfet_01v8_hvt ad=0.14 pd=1.28 as=0.14 ps=1.28 w=1 l=0.15
X949 VDPWR digital_0.input1.X a_6337_2050# VDPWR sky130_fd_pr__pfet_01v8_hvt ad=0.0864 pd=0.91 as=0.1664 ps=1.8 w=0.64 l=0.15
X950 a_13679_3138# a_13513_3138# VGND VGND sky130_fd_pr__nfet_01v8 ad=0.1092 pd=1.36 as=0.0567 ps=0.69 w=0.42 l=0.15
X951 VGND a_11673_412# digital_0.clkload0.X VGND sky130_fd_pr__nfet_01v8 ad=0.1218 pd=1.42 as=0.0588 ps=0.7 w=0.42 l=0.15
X952 VGND digital_0._118_.RESET_B a_5183_1322# VGND sky130_fd_pr__nfet_01v8 ad=0.1346 pd=1.15 as=0.0441 ps=0.63 w=0.42 l=0.15
X953 a_3492_930# a_3618_1194# VGND VGND sky130_fd_pr__nfet_01v8 ad=0.17225 pd=1.83 as=0.1856 ps=1.26 w=0.65 l=0.25
X954 a_14762_2018# digital_0.load_slew17.A VGND VGND sky130_fd_pr__nfet_01v8 ad=0.1092 pd=1.36 as=0.097 ps=0.975 w=0.42 l=0.15
X955 a_10164_412# digital_0._114_.RESET_B VGND VGND sky130_fd_pr__nfet_01v8 ad=0.06405 pd=0.725 as=0.12495 ps=1.015 w=0.42 l=0.15
X956 VDPWR a_12959_1742# a_12849_1866# VDPWR sky130_fd_pr__pfet_01v8_hvt ad=0.07035 pd=0.755 as=0.1155 ps=0.97 w=0.42 l=0.15
X957 a_4568_412# a_4530_626# a_3982_386# VGND sky130_fd_pr__nfet_01v8 ad=0.0441 pd=0.63 as=0.0735 ps=0.77 w=0.42 l=0.15
X958 a_6455_3452# digital_0._108_.Q digital_0._108_.D VGND sky130_fd_pr__nfet_01v8 ad=0.08775 pd=0.92 as=0.10563 ps=0.975 w=0.65 l=0.15
X959 a_4765_n158# a_4570_n16# a_5075_234# VGND sky130_fd_pr__special_nfet_01v8 ad=0.0594 pd=0.69 as=0.1401 ps=1.1 w=0.36 l=0.15
X960 a_4891_2588# a_4512_2954# a_4819_2588# VGND sky130_fd_pr__nfet_01v8 ad=0.1401 pd=1.1 as=0.0441 ps=0.63 w=0.42 l=0.15
X961 a_14703_3510# a_13513_3138# a_14594_3510# VGND sky130_fd_pr__special_nfet_01v8 ad=0.0669 pd=0.75 as=0.0711 ps=0.755 w=0.36 l=0.15
X962 VGND digital_0._119_.RESET_B a_4327_234# VGND sky130_fd_pr__nfet_01v8 ad=0.12495 pd=1.015 as=0.06405 ps=0.725 w=0.42 l=0.15
X963 VGND digital_0._065_.A2_N a_11655_1500# VGND sky130_fd_pr__nfet_01v8 ad=0.10725 pd=0.98 as=0.06825 ps=0.86 w=0.65 l=0.15
X964 VDPWR a_15662_2044# a_15773_2044# VDPWR sky130_fd_pr__pfet_01v8_hvt ad=0.2726 pd=1.61 as=0.2173 ps=2.17 w=0.82 l=0.25
X965 VGND a_13612_3650# uio_out<2> VGND sky130_fd_pr__nfet_01v8 ad=0.1856 pd=1.26 as=0.2079 ps=1.83 w=0.42 l=0.15
X966 a_7720_n132# a_6962_n16# a_7157_n158# VDPWR sky130_fd_pr__pfet_01v8_hvt ad=0.0651 pd=0.73 as=0.07245 ps=0.765 w=0.42 l=0.15
X967 a_15634_1474# digital_0.input3.X VDPWR VDPWR sky130_fd_pr__pfet_01v8_hvt ad=0.27 pd=2.54 as=0.19265 ps=1.415 w=1 l=0.15
X968 a_4383_2588# a_3821_2562# VGND VGND sky130_fd_pr__nfet_01v8 ad=0.0669 pd=0.75 as=0.12495 ps=1.015 w=0.42 l=0.15
X969 VGND VDPWR VGND VGND sky130_fd_pr__nfet_01v8 ad=0.143 pd=1.62 as=0 ps=0 w=0.55 l=0.59
X970 digital_0.clkload0.X a_11673_412# VGND VGND sky130_fd_pr__nfet_01v8 ad=0.0588 pd=0.7 as=0.0588 ps=0.7 w=0.42 l=0.15
X971 VGND a_4479_n676# a_4585_n676# VGND sky130_fd_pr__nfet_01v8 ad=0.097 pd=0.975 as=0.1092 ps=1.36 w=0.42 l=0.5
X972 a_4833_3436# a_4658_3510# a_5012_3498# VGND sky130_fd_pr__nfet_01v8 ad=0.1092 pd=1.36 as=0.06405 ps=0.725 w=0.42 l=0.15
X973 a_10066_n524# digital_0.hold21.X a_10208_n349# VDPWR sky130_fd_pr__pfet_01v8_hvt ad=0.1932 pd=1.34 as=0.07665 ps=0.785 w=0.42 l=0.15
X974 a_15268_1474# a_15394_1658# VGND VGND sky130_fd_pr__nfet_01v8 ad=0.17225 pd=1.83 as=0.1856 ps=1.26 w=0.65 l=0.25
X975 VGND LELO_GR01_0.x7.x1.x5.x9<2>.G LELO_GR01_0.x7.x1.x5.x8.G VGND sky130_fd_pr__nfet_01v8_lvt ad=0.5088 pd=2.98 as=0.3168 ps=1.62 w=0.96 l=0.94
X976 VGND VDPWR VGND VGND sky130_fd_pr__nfet_01v8 ad=0.143 pd=1.62 as=0 ps=0 w=0.55 l=0.59
X977 VDPWR digital_0._112_.Q a_10555_956# VDPWR sky130_fd_pr__pfet_01v8_hvt ad=0.135 pd=1.27 as=0.215 ps=1.43 w=1 l=0.15
X978 LELO_GR01_0.x7.x6<3>.G LELO_GR01_0.x7.x6<3>.G LELO_GR01_0.x7.x7.S VGND sky130_fd_pr__nfet_01v8_lvt ad=0.3168 pd=1.62 as=0.5088 ps=2.98 w=0.96 l=0.94
X979 VGND a_6315_1474# digital_0.clkbuf_1_0__f_clk.X VGND sky130_fd_pr__nfet_01v8 ad=0.0588 pd=0.7 as=0.0588 ps=0.7 w=0.42 l=0.15
X980 a_7001_110# digital_0.clkload0.A VGND VGND sky130_fd_pr__nfet_01v8 ad=0.1092 pd=1.36 as=0.0567 ps=0.69 w=0.42 l=0.15
X981 VDPWR digital_0.load_slew15.X digital_0._101_.RESET_B VDPWR sky130_fd_pr__pfet_01v8_hvt ad=0.26 pd=2.52 as=0.135 ps=1.27 w=1 l=0.15
X982 a_12116_n132# digital_0._113_.Q VDPWR VDPWR sky130_fd_pr__pfet_01v8_hvt ad=0.135 pd=1.27 as=0.135 ps=1.27 w=1 l=0.15
X983 digital_0._111_.RESET_B digital_0._116_.Q VGND VGND sky130_fd_pr__nfet_01v8 ad=0.08775 pd=0.92 as=0.182 ps=1.86 w=0.65 l=0.15
X984 VDPWR clk a_8996_1500# VDPWR sky130_fd_pr__pfet_01v8_hvt ad=0.14 pd=1.28 as=0.14 ps=1.28 w=1 l=0.15
X985 a_7356_n676# digital_0.hold28.A VGND VGND sky130_fd_pr__nfet_01v8 ad=0.0693 pd=0.75 as=0.11285 ps=1.045 w=0.42 l=0.15
X986 LELO_GR01_0.x8.x1.x5.x3.S LELO_GR01_0.x8.x1.x5.x8.G LELO_GR01_0.x8.x1.x5.x9<2>.G LELO_GR01_0.x8.x1.x5.x3.S sky130_fd_pr__pfet_01v8_lvt ad=0.5088 pd=2.98 as=0.3168 ps=1.62 w=0.96 l=0.94
X987 a_10655_246# a_9465_n126# a_10546_246# VGND sky130_fd_pr__special_nfet_01v8 ad=0.0669 pd=0.75 as=0.0711 ps=0.755 w=0.36 l=0.15
X988 VDPWR VGND VDPWR VDPWR sky130_fd_pr__pfet_01v8_hvt ad=0.2262 pd=2.26 as=0 ps=0 w=0.87 l=0.59
X989 VGND LELO_GR01_0.x7.x7.G LELO_GR01_0.x7.x7.S VDPWR sky130_fd_pr__pfet_01v8_lvt ad=0.3168 pd=1.62 as=0.5088 ps=2.98 w=0.96 l=0.94
X990 a_5218_778# a_4438_386# a_4610_386# VGND sky130_fd_pr__special_nfet_01v8 ad=0.0935 pd=0.965 as=0.072 ps=0.76 w=0.36 l=0.15
X991 a_11673_n132# digital_0._063_.A a_11758_188# VDPWR sky130_fd_pr__pfet_01v8_hvt ad=0.26 pd=2.52 as=0.135 ps=1.27 w=1 l=0.15
X992 VGND VDPWR VGND VGND sky130_fd_pr__nfet_01v8 ad=0.143 pd=1.62 as=0 ps=0 w=0.55 l=0.59
X993 VGND a_11772_n702# uio_out<5> VGND sky130_fd_pr__nfet_01v8 ad=0.1856 pd=1.26 as=0.2079 ps=1.83 w=0.42 l=0.15
X994 VDPWR a_6315_1474# digital_0.clkbuf_1_0__f_clk.X VDPWR sky130_fd_pr__pfet_01v8_hvt ad=0.1375 pd=1.275 as=0.14 ps=1.28 w=1 l=0.15
X995 VGND a_11673_412# digital_0.clkload0.X VGND sky130_fd_pr__nfet_01v8 ad=0.0588 pd=0.7 as=0.0588 ps=0.7 w=0.42 l=0.15
X996 a_4631_2410# a_4587_2018# a_4465_2422# VGND sky130_fd_pr__nfet_01v8 ad=0.0441 pd=0.63 as=0.1401 ps=1.1 w=0.42 l=0.15
X997 digital_0._112_.Q a_13481_386# VGND VGND sky130_fd_pr__nfet_01v8 ad=0.08775 pd=0.92 as=0.2087 ps=2.02 w=0.65 l=0.15
X998 a_3998_3498# digital_0.hold19.X VGND VGND sky130_fd_pr__nfet_01v8 ad=0.066 pd=0.745 as=0.2205 ps=1.89 w=0.42 l=0.15
X999 VGND VGND LELO_GR01_0.x7.x15.I1 sky130_fd_pr__pnp_05v5_W3p40L3p40
**devattr s=462400,2720
X1000 LELO_GR01_0.x7.x1.x5.IBN LELO_GR01_0.x7.x1.x5.x9<2>.G VGND VGND sky130_fd_pr__nfet_01v8_lvt ad=0.3168 pd=1.62 as=0.5088 ps=2.98 w=0.96 l=0.94
X1001 VGND VDPWR VGND VGND sky130_fd_pr__nfet_01v8 ad=0.143 pd=1.62 as=0 ps=0 w=0.55 l=0.59
X1002 LELO_GR01_0.x7.x24.D LELO_GR01_0.x8.PWRUP_N_1V8 LELO_GR01_0.x7.x25.D VDPWR sky130_fd_pr__pfet_01v8_lvt ad=0.3168 pd=1.62 as=0.5088 ps=2.98 w=0.96 l=0.94
X1003 VDPWR a_8996_1500# digital_0.clkbuf_1_1__f_clk.A VDPWR sky130_fd_pr__pfet_01v8_hvt ad=0.1375 pd=1.275 as=0.14 ps=1.28 w=1 l=0.15
X1004 a_5328_n132# a_4609_110# a_4765_n158# VGND sky130_fd_pr__special_nfet_01v8 ad=0.066 pd=0.745 as=0.0594 ps=0.69 w=0.36 l=0.15
X1005 a_4479_n676# a_4243_n676# VGND VGND sky130_fd_pr__nfet_01v8 ad=0.1092 pd=1.36 as=0.0567 ps=0.69 w=0.42 l=0.5
X1006 VDPWR a_15634_1474# a_15394_1658# VDPWR sky130_fd_pr__pfet_01v8_hvt ad=0.19265 pd=1.415 as=0.2173 ps=2.17 w=0.82 l=0.25
X1007 a_9886_2410# digital_0._111_.D VDPWR VDPWR sky130_fd_pr__pfet_01v8_hvt ad=0.0651 pd=0.73 as=0.1092 ps=1.36 w=0.42 l=0.15
X1008 VDPWR digital_0._108_.Q a_7349_3132# VDPWR sky130_fd_pr__pfet_01v8_hvt ad=0.14 pd=1.28 as=0.28 ps=2.56 w=1 l=0.15
X1009 VGND VGND LELO_GR01_0.x7.x15.I1 sky130_fd_pr__pnp_05v5_W3p40L3p40
**devattr s=462400,2720
X1010 digital_0.hold25.X a_5321_3676# VGND VGND sky130_fd_pr__nfet_01v8 ad=0.169 pd=1.82 as=0.097 ps=0.975 w=0.65 l=0.15
X1011 VGND VDPWR VGND VGND sky130_fd_pr__nfet_01v8 ad=0.143 pd=1.62 as=0 ps=0 w=0.55 l=0.59
X1012 a_4274_2410# digital_0._101_.D VGND VGND sky130_fd_pr__nfet_01v8 ad=0.066 pd=0.745 as=0.2205 ps=1.89 w=0.42 l=0.15
X1013 a_12297_2954# digital_0._110_.RESET_B VDPWR VDPWR sky130_fd_pr__pfet_01v8_hvt ad=0.1092 pd=1.36 as=0.07035 ps=0.755 w=0.42 l=0.15
X1014 a_4767_3510# a_3577_3138# a_4658_3510# VGND sky130_fd_pr__special_nfet_01v8 ad=0.0669 pd=0.75 as=0.0711 ps=0.755 w=0.36 l=0.15
X1015 VDPWR a_6407_1188# digital_0.hold28.X VDPWR sky130_fd_pr__pfet_01v8_hvt ad=0.14075 pd=1.325 as=0.26 ps=2.52 w=1 l=0.15
X1016 VGND a_5056_n702# digital_0.input1.X VGND sky130_fd_pr__nfet_01v8 ad=0.1856 pd=1.26 as=0.2079 ps=1.83 w=0.42 l=0.15
X1017 digital_0.output12.A a_6397_n158# VDPWR VDPWR sky130_fd_pr__pfet_01v8_hvt ad=0.135 pd=1.27 as=0.26 ps=2.52 w=1 l=0.15
X1018 VDPWR LELO_GR01_0.PWRUP_1V8 LELO_GR01_0.x7.x18.G VDPWR sky130_fd_pr__pfet_01v8_lvt ad=0.5088 pd=2.98 as=0.3168 ps=1.62 w=0.96 l=0.94
X1019 VDPWR a_11772_n702# uio_out<5> VDPWR sky130_fd_pr__pfet_01v8_hvt ad=0.2726 pd=1.61 as=0.495 ps=2.99 w=1 l=0.15
X1020 VGND digital_0.load_slew17.X digital_0._105_.RESET_B VGND sky130_fd_pr__nfet_01v8 ad=0.169 pd=1.82 as=0.08775 ps=0.92 w=0.65 l=0.15
X1021 VGND digital_0._109_.Q digital_0._069_.B VGND sky130_fd_pr__nfet_01v8 ad=0.26 pd=2.1 as=0.08775 ps=0.92 w=0.65 l=0.15
X1022 VGND LELO_GR01_0.x8.PWRUP_N_1V8 LELO_GR01_0.x7.x1.x5.x9<2>.G VGND sky130_fd_pr__nfet_01v8_lvt ad=0.5088 pd=2.98 as=0.3168 ps=1.62 w=0.96 l=0.94
X1023 a_10208_n676# digital_0.hold28.A VGND VGND sky130_fd_pr__nfet_01v8 ad=0.0693 pd=0.75 as=0.11285 ps=1.045 w=0.42 l=0.15
X1024 VDPWR VGND VDPWR VDPWR sky130_fd_pr__pfet_01v8_hvt ad=0.2262 pd=2.26 as=0 ps=0 w=0.87 l=0.59
X1025 VGND digital_0.output5.A a_4979_3676# VGND sky130_fd_pr__nfet_01v8 ad=0.0567 pd=0.69 as=0.1092 ps=1.36 w=0.42 l=0.15
X1026 VGND a_9151_n702# digital_0._114_.D VGND sky130_fd_pr__nfet_01v8 ad=0.10187 pd=0.99 as=0.08775 ps=0.92 w=0.65 l=0.15
X1027 digital_0.clkbuf_1_0__f_clk.X a_6315_1474# VGND VGND sky130_fd_pr__nfet_01v8 ad=0.0588 pd=0.7 as=0.0588 ps=0.7 w=0.42 l=0.15
X1028 a_12929_2562# digital_0._110_.RESET_B VDPWR VDPWR sky130_fd_pr__pfet_01v8_hvt ad=0.0567 pd=0.69 as=0.0819 ps=0.81 w=0.42 l=0.15
X1029 digital_0._107_.RESET_B digital_0.load_slew15.X VGND VGND sky130_fd_pr__nfet_01v8 ad=0.08775 pd=0.92 as=0.169 ps=1.82 w=0.65 l=0.15
X1030 digital_0._057_.D a_12903_206# VGND VGND sky130_fd_pr__nfet_01v8 ad=0.12675 pd=1.04 as=0.1118 ps=1.04 w=0.65 l=0.15
X1031 VGND digital_0.load_slew15.A digital_0._109_.RESET_B VGND sky130_fd_pr__nfet_01v8 ad=0.169 pd=1.82 as=0.08775 ps=0.92 w=0.65 l=0.15
X1032 a_14848_n132# a_13771_n126# a_14686_246# VDPWR sky130_fd_pr__pfet_01v8_hvt ad=0.0567 pd=0.69 as=0.0588 ps=0.7 w=0.42 l=0.15
X1033 VDPWR VGND VDPWR VDPWR sky130_fd_pr__pfet_01v8_hvt ad=0.2262 pd=2.26 as=0 ps=0 w=0.87 l=0.59
X1034 digital_0._067_.B digital_0._069_.A a_12517_2044# VDPWR sky130_fd_pr__pfet_01v8_hvt ad=0.135 pd=1.27 as=0.26 ps=2.52 w=1 l=0.15
X1035 a_6179_3132# a_6235_3106# digital_0._108_.D VDPWR sky130_fd_pr__pfet_01v8_hvt ad=0.26 pd=2.52 as=0.135 ps=1.27 w=1 l=0.15
X1036 a_4228_3650# a_4354_3834# VDPWR VDPWR sky130_fd_pr__pfet_01v8_hvt ad=0.2173 pd=2.17 as=0.2726 ps=1.61 w=0.82 l=0.25
X1037 digital_0.clkbuf_1_0__f_clk.X a_6315_1474# VDPWR VDPWR sky130_fd_pr__pfet_01v8_hvt ad=0.14 pd=1.28 as=0.14 ps=1.28 w=1 l=0.15
X1038 a_12116_n132# a_11758_188# digital_0._113_.D VDPWR sky130_fd_pr__pfet_01v8_hvt ad=0.28 pd=2.56 as=0.135 ps=1.27 w=1 l=0.15
X1039 VDPWR a_9985_386# a_9972_778# VDPWR sky130_fd_pr__pfet_01v8_hvt ad=0.0819 pd=0.81 as=0.0567 ps=0.69 w=0.42 l=0.15
R5 uio_oe<3> li_28516_19376# sky130_fd_pr__res_generic_m4 w=0.3 l=0.3
X1040 a_9150_412# digital_0._114_.D VDPWR VDPWR sky130_fd_pr__pfet_01v8_hvt ad=0.0651 pd=0.73 as=0.1092 ps=1.36 w=0.42 l=0.15
X1041 VDPWR a_5056_n702# digital_0.input1.X VDPWR sky130_fd_pr__pfet_01v8_hvt ad=0.2726 pd=1.61 as=0.495 ps=2.99 w=1 l=0.15
X1042 digital_0._100_.RESET_B digital_0.load_slew15.X VGND VGND sky130_fd_pr__nfet_01v8 ad=0.08775 pd=0.92 as=0.169 ps=1.82 w=0.65 l=0.15
X1043 VGND a_9930_930# a_9690_1194# VGND sky130_fd_pr__nfet_01v8 ad=0.1228 pd=1.065 as=0.17225 ps=1.83 w=0.65 l=0.25
X1044 VDPWR digital_0.load_slew17.X digital_0._105_.RESET_B VDPWR sky130_fd_pr__pfet_01v8_hvt ad=0.26 pd=2.52 as=0.135 ps=1.27 w=1 l=0.15
X1045 a_7329_778# digital_0._115_.RESET_B VDPWR VDPWR sky130_fd_pr__pfet_01v8_hvt ad=0.1092 pd=1.36 as=0.07035 ps=0.755 w=0.42 l=0.15
X1046 VDPWR a_14861_172# digital_0.output10.A VDPWR sky130_fd_pr__pfet_01v8_hvt ad=0.26 pd=2.52 as=0.135 ps=1.27 w=1 l=0.15
X1047 digital_0.clkbuf_1_1__f_clk.A a_8996_1500# VDPWR VDPWR sky130_fd_pr__pfet_01v8_hvt ad=0.14 pd=1.28 as=0.14 ps=1.28 w=1 l=0.15
X1048 VDPWR a_9151_n702# digital_0._114_.D VDPWR sky130_fd_pr__pfet_01v8_hvt ad=0.22895 pd=1.745 as=0.135 ps=1.27 w=1 l=0.15
X1049 VGND a_12138_n702# a_11898_n518# VGND sky130_fd_pr__nfet_01v8 ad=0.1228 pd=1.065 as=0.17225 ps=1.83 w=0.65 l=0.25
X1050 VDPWR a_10997_386# digital_0._060_.A_N VDPWR sky130_fd_pr__pfet_01v8_hvt ad=0.27995 pd=1.615 as=0.165 ps=1.33 w=1 l=0.15
X1051 VDPWR digital_0.clkbuf_1_1__f_clk.A a_11388_956# VDPWR sky130_fd_pr__pfet_01v8_hvt ad=0.14 pd=1.28 as=0.14 ps=1.28 w=1 l=0.15
X1052 digital_0._108_.Q a_7593_2348# VGND VGND sky130_fd_pr__nfet_01v8 ad=0.08775 pd=0.92 as=0.2087 ps=2.02 w=0.65 l=0.15
X1053 VGND digital_0.load_slew17.A digital_0._103_.RESET_B VGND sky130_fd_pr__nfet_01v8 ad=0.169 pd=1.82 as=0.08775 ps=0.92 w=0.65 l=0.15
X1054 LELO_GR01_0.x7.x15.I2 LELO_GR01_0.x7.x18.G VDPWR VDPWR sky130_fd_pr__pfet_01v8_lvt ad=0.3168 pd=1.62 as=0.5088 ps=2.98 w=0.96 l=0.94
X1055 a_8837_2838# digital_0.load_slew15.A digital_0._108_.RESET_B VDPWR sky130_fd_pr__pfet_01v8_hvt ad=0.135 pd=1.27 as=0.135 ps=1.27 w=1 l=0.15
X1056 a_7772_2410# digital_0._108_.RESET_B VGND VGND sky130_fd_pr__nfet_01v8 ad=0.06405 pd=0.725 as=0.12495 ps=1.015 w=0.42 l=0.15
X1057 a_11452_3498# digital_0._103_.RESET_B VGND VGND sky130_fd_pr__nfet_01v8 ad=0.06405 pd=0.725 as=0.12495 ps=1.015 w=0.42 l=0.15
X1058 LELO_GR01_0.x7.x7.S LELO_GR01_0.x7.x6<3>.G LELO_GR01_0.x7.x6<3>.G VGND sky130_fd_pr__nfet_01v8_lvt ad=0.5088 pd=2.98 as=0.3168 ps=1.62 w=0.96 l=0.94
X1059 VDPWR a_9810_412# a_9985_386# VDPWR sky130_fd_pr__pfet_01v8_hvt ad=0.1134 pd=1.38 as=0.0567 ps=0.69 w=0.42 l=0.15
X1060 VGND a_6315_1474# digital_0.clkbuf_1_0__f_clk.X VGND sky130_fd_pr__nfet_01v8 ad=0.0588 pd=0.7 as=0.0588 ps=0.7 w=0.42 l=0.15
X1061 a_6315_1474# digital_0.clkbuf_1_1__f_clk.A VDPWR VDPWR sky130_fd_pr__pfet_01v8_hvt ad=0.14 pd=1.28 as=0.14 ps=1.28 w=1 l=0.15
X1062 VGND a_7961_386# a_7895_412# VGND sky130_fd_pr__nfet_01v8 ad=0.12495 pd=1.015 as=0.0669 ps=0.75 w=0.42 l=0.15
X1063 a_10285_2910# digital_0._069_.A VDPWR VDPWR sky130_fd_pr__pfet_01v8_hvt ad=0.173 pd=1.4 as=0.154 ps=1.335 w=0.64 l=0.15
X1064 a_13660_412# digital_0._112_.RESET_B VGND VGND sky130_fd_pr__nfet_01v8 ad=0.06405 pd=0.725 as=0.12495 ps=1.015 w=0.42 l=0.15
X1065 a_14661_1500# digital_0.hold23.X a_14298_1652# VGND sky130_fd_pr__nfet_01v8 ad=0.0693 pd=0.75 as=0.09975 ps=0.895 w=0.42 l=0.15
X1066 VDPWR a_5486_1334# a_5661_1260# VDPWR sky130_fd_pr__pfet_01v8_hvt ad=0.1134 pd=1.38 as=0.0567 ps=0.69 w=0.42 l=0.15
X1067 VGND VDPWR VGND VGND sky130_fd_pr__nfet_01v8 ad=0.143 pd=1.62 as=0 ps=0 w=0.55 l=0.59
X1068 a_12718_3676# a_12501_3676# VGND VGND sky130_fd_pr__nfet_01v8 ad=0.17225 pd=1.83 as=0.1228 ps=1.065 w=0.65 l=0.25
X1069 LELO_GR01_0.x7.x15.I2 LELO_GR01_0.x7.x18.G VDPWR VDPWR sky130_fd_pr__pfet_01v8_lvt ad=0.3168 pd=1.62 as=0.5088 ps=2.98 w=0.96 l=0.94
X1070 a_3998_3498# digital_0.hold19.X VDPWR VDPWR sky130_fd_pr__pfet_01v8_hvt ad=0.0651 pd=0.73 as=0.1092 ps=1.36 w=0.42 l=0.15
X1071 VGND a_14769_3436# a_14703_3510# VGND sky130_fd_pr__nfet_01v8 ad=0.12495 pd=1.015 as=0.0669 ps=0.75 w=0.42 l=0.15
X1072 a_12189_2588# a_11673_2588# a_12094_2588# VGND sky130_fd_pr__special_nfet_01v8 ad=0.0594 pd=0.69 as=0.066 ps=0.745 w=0.36 l=0.15
X1073 digital_0.load_slew15.X a_8085_1500# VGND VGND sky130_fd_pr__nfet_01v8 ad=0.08775 pd=0.92 as=0.08775 ps=0.92 w=0.65 l=0.15
X1074 a_10655_2422# a_9465_2050# a_10546_2422# VGND sky130_fd_pr__special_nfet_01v8 ad=0.0669 pd=0.75 as=0.0711 ps=0.755 w=0.36 l=0.15
X1075 VGND digital_0.clkbuf_1_1__f_clk.A a_6315_1474# VGND sky130_fd_pr__nfet_01v8 ad=0.1113 pd=1.37 as=0.0588 ps=0.7 w=0.42 l=0.15
X1076 a_8132_2954# a_7055_2588# a_7970_2588# VDPWR sky130_fd_pr__pfet_01v8_hvt ad=0.0567 pd=0.69 as=0.0588 ps=0.7 w=0.42 l=0.15
X1077 VGND a_3492_n702# digital_0.pwr VGND sky130_fd_pr__nfet_01v8 ad=0.1856 pd=1.26 as=0.2079 ps=1.83 w=0.42 l=0.15
X1078 a_4438_386# digital_0.clkbuf_1_0__f_clk.X VGND VGND sky130_fd_pr__nfet_01v8 ad=0.1092 pd=1.36 as=0.0567 ps=0.69 w=0.42 l=0.15
X1079 VDPWR a_8996_1500# digital_0.clkbuf_1_1__f_clk.A VDPWR sky130_fd_pr__pfet_01v8_hvt ad=0.14 pd=1.28 as=0.14 ps=1.28 w=1 l=0.15
X1080 VDPWR VGND VDPWR VDPWR sky130_fd_pr__pfet_01v8_hvt ad=0.2262 pd=2.26 as=0 ps=0 w=0.87 l=0.59
X1081 VGND a_7157_n158# a_7088_n132# VGND sky130_fd_pr__nfet_01v8 ad=0.1346 pd=1.15 as=0.0999 ps=0.985 w=0.64 l=0.15
X1082 VDPWR VGND VDPWR VDPWR sky130_fd_pr__pfet_01v8_hvt ad=0.2262 pd=2.26 as=0 ps=0 w=0.87 l=0.59
X1083 a_9557_2838# digital_0._116_.Q VDPWR VDPWR sky130_fd_pr__pfet_01v8_hvt ad=0.135 pd=1.27 as=0.135 ps=1.27 w=1 l=0.15
X1084 VDPWR VGND VDPWR VDPWR sky130_fd_pr__pfet_01v8_hvt ad=0.2262 pd=2.26 as=0 ps=0 w=0.87 l=0.59
X1085 digital_0.clkload0.A a_11388_956# VGND VGND sky130_fd_pr__nfet_01v8 ad=0.0588 pd=0.7 as=0.0588 ps=0.7 w=0.42 l=0.15
X1086 VDPWR a_6315_1474# digital_0.clkbuf_1_0__f_clk.X VDPWR sky130_fd_pr__pfet_01v8_hvt ad=0.14 pd=1.28 as=0.14 ps=1.28 w=1 l=0.15
X1087 VGND a_4425_2730# a_4386_2856# VGND sky130_fd_pr__nfet_01v8 ad=0.0567 pd=0.69 as=0.1092 ps=1.36 w=0.42 l=0.15
X1088 a_5834_2740# digital_0.hold25.X a_5976_2915# VDPWR sky130_fd_pr__pfet_01v8_hvt ad=0.1932 pd=1.34 as=0.07665 ps=0.785 w=0.42 l=0.15
X1089 a_5422_n702# uo_out<0> VGND VGND sky130_fd_pr__nfet_01v8 ad=0.1134 pd=1.38 as=0.1228 ps=1.065 w=0.42 l=0.15
X1090 a_12391_1500# a_12225_1500# VGND VGND sky130_fd_pr__nfet_01v8 ad=0.1092 pd=1.36 as=0.0567 ps=0.69 w=0.42 l=0.15
X1091 VGND digital_0._100_.D a_5144_2954# VGND sky130_fd_pr__nfet_01v8 ad=0.2205 pd=1.89 as=0.066 ps=0.745 w=0.42 l=0.15
X1092 VDPWR digital_0._100_.D a_5144_2954# VDPWR sky130_fd_pr__pfet_01v8_hvt ad=0.1092 pd=1.36 as=0.0651 ps=0.73 w=0.42 l=0.15
X1093 a_7467_234# a_7088_n132# a_7395_234# VGND sky130_fd_pr__nfet_01v8 ad=0.1401 pd=1.1 as=0.0441 ps=0.63 w=0.42 l=0.15
X1094 VDPWR a_4369_1474# a_4111_1474# VDPWR sky130_fd_pr__pfet_01v8_hvt ad=0.0567 pd=0.69 as=0.1092 ps=1.36 w=0.42 l=0.5
X1095 VGND a_11835_3828# digital_0.hold20.X VGND sky130_fd_pr__nfet_01v8 ad=0.097 pd=0.975 as=0.169 ps=1.82 w=0.65 l=0.15
X1096 a_11415_3650# digital_0.hold28.A VGND VGND sky130_fd_pr__nfet_01v8 ad=0.1092 pd=1.36 as=0.1449 ps=1.11 w=0.42 l=0.15
X1097 VDPWR VGND VDPWR VDPWR sky130_fd_pr__pfet_01v8_hvt ad=0.2262 pd=2.26 as=0 ps=0 w=0.87 l=0.59
X1098 VDPWR VGND VDPWR VDPWR sky130_fd_pr__pfet_01v8_hvt ad=0.2262 pd=2.26 as=0 ps=0 w=0.87 l=0.59
X1099 digital_0._114_.RESET_B digital_0._116_.Q VGND VGND sky130_fd_pr__nfet_01v8 ad=0.08775 pd=0.92 as=0.182 ps=1.86 w=0.65 l=0.15
X1100 VGND digital_0._115_.Q a_7155_930# VGND sky130_fd_pr__nfet_01v8 ad=0.17875 pd=1.85 as=0.08775 ps=0.92 w=0.65 l=0.15
X1101 VDPWR a_3492_n702# digital_0.pwr VDPWR sky130_fd_pr__pfet_01v8_hvt ad=0.2726 pd=1.61 as=0.495 ps=2.99 w=1 l=0.15
X1102 VGND digital_0.hold28.A a_13110_3498# VGND sky130_fd_pr__nfet_01v8 ad=0.11285 pd=1.045 as=0.0693 ps=0.75 w=0.42 l=0.15
X1103 a_12889_3171# digital_0.hold24.X a_12889_3498# VGND sky130_fd_pr__nfet_01v8 ad=0.09975 pd=0.895 as=0.0693 ps=0.75 w=0.42 l=0.15
X1104 a_5422_n702# uo_out<0> VDPWR VDPWR sky130_fd_pr__pfet_01v8_hvt ad=0.27 pd=2.54 as=0.19265 ps=1.415 w=1 l=0.15
X1105 VGND ui_in<1> sky130_fd_pr__diode_pw2nd_05v5 perim=1.8e+06 area=2.025e+11
X1106 a_14121_246# a_13771_n126# a_14026_234# VDPWR sky130_fd_pr__pfet_01v8_hvt ad=0.07245 pd=0.765 as=0.0651 ps=0.73 w=0.42 l=0.15
X1107 digital_0._113_.D digital_0._063_.A a_12116_188# VGND sky130_fd_pr__nfet_01v8 ad=0.10563 pd=0.975 as=0.08775 ps=0.92 w=0.65 l=0.15
X1108 VDPWR VGND VDPWR VDPWR sky130_fd_pr__pfet_01v8_hvt ad=0.2262 pd=2.26 as=0 ps=0 w=0.87 l=0.59
X1109 digital_0.clkload0.A a_11388_956# VDPWR VDPWR sky130_fd_pr__pfet_01v8_hvt ad=0.14 pd=1.28 as=0.14 ps=1.28 w=1 l=0.15
X1110 a_14673_3650# digital_0.output7.A VDPWR VDPWR sky130_fd_pr__pfet_01v8_hvt ad=0.1092 pd=1.36 as=0.0567 ps=0.69 w=0.42 l=0.15
X1111 a_14175_n702# digital_0.hold28.A VDPWR VDPWR sky130_fd_pr__pfet_01v8_hvt ad=0.1176 pd=1.4 as=0.0693 ps=0.75 w=0.42 l=0.15
X1112 a_14298_1652# digital_0.hold23.X a_14440_1827# VDPWR sky130_fd_pr__pfet_01v8_hvt ad=0.1932 pd=1.34 as=0.07665 ps=0.785 w=0.42 l=0.15
X1113 VDPWR a_7623_2830# a_7513_2954# VDPWR sky130_fd_pr__pfet_01v8_hvt ad=0.07035 pd=0.755 as=0.1155 ps=0.97 w=0.42 l=0.15
X1114 a_14229_n132# a_13605_n126# a_14121_246# VDPWR sky130_fd_pr__pfet_01v8_hvt ad=0.1155 pd=0.97 as=0.07245 ps=0.765 w=0.42 l=0.15
X1115 VGND a_11388_956# digital_0.clkload0.A VGND sky130_fd_pr__nfet_01v8 ad=0.0588 pd=0.7 as=0.0588 ps=0.7 w=0.42 l=0.15
X1116 a_10639_1276# digital_0._065_.A2_N VGND VGND sky130_fd_pr__nfet_01v8 ad=0.08775 pd=0.92 as=0.08775 ps=0.92 w=0.65 l=0.15
X1117 VDPWR a_3821_2562# digital_0.output5.A VDPWR sky130_fd_pr__pfet_01v8_hvt ad=0.3012 pd=2.66 as=0.135 ps=1.27 w=1 l=0.15
X1118 a_7071_2018# a_6853_2422# VGND VGND sky130_fd_pr__nfet_01v8 ad=0.0999 pd=0.985 as=0.1346 ps=1.15 w=0.64 l=0.15
X1119 a_10708_n132# a_9631_n126# a_10546_246# VDPWR sky130_fd_pr__pfet_01v8_hvt ad=0.0567 pd=0.69 as=0.0588 ps=0.7 w=0.42 l=0.15
X1120 VGND LELO_GR01_0.x8.PWRUP_N_1V8 LELO_GR01_0.x8.IBP_BG VGND sky130_fd_pr__nfet_01v8_lvt ad=0.5088 pd=2.98 as=0.3168 ps=1.62 w=0.96 l=0.94
X1121 a_10997_386# digital_0._112_.Q a_11478_412# VGND sky130_fd_pr__nfet_01v8 ad=0.1092 pd=1.36 as=0.06195 ps=0.715 w=0.42 l=0.15
X1122 VGND a_14762_2018# digital_0.load_slew17.X VGND sky130_fd_pr__nfet_01v8 ad=0.097 pd=0.975 as=0.08775 ps=0.92 w=0.65 l=0.15
X1123 VGND digital_0.output13.A a_6235_3106# VGND sky130_fd_pr__nfet_01v8 ad=0.17875 pd=1.85 as=0.08775 ps=0.92 w=0.65 l=0.15
X1124 digital_0._102_.RESET_B digital_0.load_slew17.A VDPWR VDPWR sky130_fd_pr__pfet_01v8_hvt ad=0.135 pd=1.27 as=0.26 ps=2.52 w=1 l=0.15
X1125 a_4765_n158# a_4609_110# a_4910_n132# VDPWR sky130_fd_pr__pfet_01v8_hvt ad=0.07245 pd=0.765 as=0.1155 ps=0.97 w=0.42 l=0.15
X1126 VDPWR digital_0._060_.A_N a_7099_956# VDPWR sky130_fd_pr__pfet_01v8_hvt ad=0.1625 pd=1.325 as=0.26 ps=2.52 w=1 l=0.15
X1127 a_7895_412# a_6705_412# a_7786_412# VGND sky130_fd_pr__special_nfet_01v8 ad=0.0669 pd=0.75 as=0.0711 ps=0.755 w=0.36 l=0.15
X1128 a_14440_1827# digital_0.hold28.A VDPWR VDPWR sky130_fd_pr__pfet_01v8_hvt ad=0.07665 pd=0.785 as=0.15835 ps=1.395 w=0.42 l=0.15
X1129 a_8578_n132# a_8361_n132# VGND VGND sky130_fd_pr__nfet_01v8 ad=0.17225 pd=1.83 as=0.1228 ps=1.065 w=0.65 l=0.25
X1130 VGND a_5109_2348# a_5043_2422# VGND sky130_fd_pr__nfet_01v8 ad=0.12495 pd=1.015 as=0.0669 ps=0.75 w=0.42 l=0.15
X1131 digital_0._060_.B a_10253_930# VGND VGND sky130_fd_pr__nfet_01v8 ad=0.08775 pd=0.92 as=0.169 ps=1.82 w=0.65 l=0.15
X1132 VDPWR a_14673_3650# a_14415_3650# VDPWR sky130_fd_pr__pfet_01v8_hvt ad=0.0567 pd=0.69 as=0.1092 ps=1.36 w=0.42 l=0.5
X1133 VGND a_6397_n158# digital_0.output12.A VGND sky130_fd_pr__nfet_01v8 ad=0.2087 pd=2.02 as=0.08775 ps=0.92 w=0.65 l=0.15
X1134 a_10199_2018# a_9981_2422# VDPWR VDPWR sky130_fd_pr__pfet_01v8_hvt ad=0.12915 pd=1.185 as=0.2184 ps=2.2 w=0.84 l=0.15
X1135 digital_0._111_.Q a_10721_2348# VDPWR VDPWR sky130_fd_pr__pfet_01v8_hvt ad=0.135 pd=1.27 as=0.3012 ps=2.66 w=1 l=0.15
X1136 digital_0._069_.B digital_0._109_.Q a_7349_3132# VDPWR sky130_fd_pr__pfet_01v8_hvt ad=0.135 pd=1.27 as=0.135 ps=1.27 w=1 l=0.15
X1137 VGND a_11273_3436# digital_0.output8.A VGND sky130_fd_pr__nfet_01v8 ad=0.169 pd=1.82 as=0.08775 ps=0.92 w=0.65 l=0.15
X1138 VDPWR a_13481_386# a_13468_778# VDPWR sky130_fd_pr__pfet_01v8_hvt ad=0.0819 pd=0.81 as=0.0567 ps=0.69 w=0.42 l=0.15
X1139 a_4015_1652# a_4111_1474# VDPWR VDPWR sky130_fd_pr__pfet_01v8_hvt ad=0.1092 pd=1.36 as=0.14075 ps=1.325 w=0.42 l=0.5
X1140 VDPWR a_11415_3650# a_11445_4003# VDPWR sky130_fd_pr__pfet_01v8_hvt ad=0.0693 pd=0.75 as=0.0441 ps=0.63 w=0.42 l=0.15
X1141 a_5834_2740# digital_0._108_.Q a_5976_2588# VGND sky130_fd_pr__nfet_01v8 ad=0.09975 pd=0.895 as=0.0693 ps=0.75 w=0.42 l=0.15
X1142 VDPWR digital_0.load_slew15.X digital_0._100_.RESET_B VDPWR sky130_fd_pr__pfet_01v8_hvt ad=0.26 pd=2.52 as=0.135 ps=1.27 w=1 l=0.15
X1143 VGND LELO_GR01_0.x8.PWRUP_N_1V8 LELO_GR01_0.x8.x1.x5.x9<2>.G VGND sky130_fd_pr__nfet_01v8_lvt ad=0.5088 pd=2.98 as=0.3168 ps=1.62 w=0.96 l=0.94
X1144 VGND a_11107_2562# digital_0._067_.A VGND sky130_fd_pr__nfet_01v8 ad=0.1118 pd=1.04 as=0.12675 ps=1.04 w=0.65 l=0.15
X1145 VDPWR digital_0.hold28.A a_13103_3171# VDPWR sky130_fd_pr__pfet_01v8_hvt ad=0.15835 pd=1.395 as=0.07665 ps=0.785 w=0.42 l=0.15
X1146 digital_0.output13.A a_5661_1260# VDPWR VDPWR sky130_fd_pr__pfet_01v8_hvt ad=0.135 pd=1.27 as=0.3012 ps=2.66 w=1 l=0.15
X1147 VGND VDPWR VGND VGND sky130_fd_pr__nfet_01v8 ad=0.143 pd=1.62 as=0 ps=0 w=0.55 l=0.59
X1148 VGND digital_0._107_.D a_7720_n132# VGND sky130_fd_pr__nfet_01v8 ad=0.2205 pd=1.89 as=0.066 ps=0.745 w=0.42 l=0.15
X1149 VDPWR a_3982_386# a_4118_412# VDPWR sky130_fd_pr__pfet_01v8_hvt ad=0.12075 pd=1.165 as=0.2226 ps=2.21 w=0.84 l=0.15
X1150 a_7643_n702# digital_0.hold28.A VDPWR VDPWR sky130_fd_pr__pfet_01v8_hvt ad=0.1176 pd=1.4 as=0.0693 ps=0.75 w=0.42 l=0.15
X1151 VDPWR a_8085_1500# digital_0.load_slew15.X VDPWR sky130_fd_pr__pfet_01v8_hvt ad=0.135 pd=1.27 as=0.135 ps=1.27 w=1 l=0.15
X1152 a_3858_n702# digital_0.output13.A VGND VGND sky130_fd_pr__nfet_01v8 ad=0.1134 pd=1.38 as=0.1228 ps=1.065 w=0.42 l=0.15
X1153 VDPWR a_7786_412# a_7961_386# VDPWR sky130_fd_pr__pfet_01v8_hvt ad=0.1134 pd=1.38 as=0.0567 ps=0.69 w=0.42 l=0.15
X1154 VGND VDPWR VGND VGND sky130_fd_pr__nfet_01v8 ad=0.143 pd=1.62 as=0 ps=0 w=0.55 l=0.59
X1155 a_5328_n132# a_4570_n16# a_4765_n158# VDPWR sky130_fd_pr__pfet_01v8_hvt ad=0.0651 pd=0.73 as=0.07245 ps=0.765 w=0.42 l=0.15
X1156 digital_0.clkload0.A a_11388_956# VGND VGND sky130_fd_pr__nfet_01v8 ad=0.0588 pd=0.7 as=0.05775 ps=0.695 w=0.42 l=0.15
X1157 a_14673_1334# a_14323_962# a_14578_1322# VDPWR sky130_fd_pr__pfet_01v8_hvt ad=0.07245 pd=0.765 as=0.0651 ps=0.73 w=0.42 l=0.15
X1158 a_6871_412# a_6705_412# VGND VGND sky130_fd_pr__nfet_01v8 ad=0.1092 pd=1.36 as=0.0567 ps=0.69 w=0.42 l=0.15
X1159 VDPWR digital_0.output9.A a_15445_2044# VDPWR sky130_fd_pr__pfet_01v8_hvt ad=0.19265 pd=1.415 as=0.27 ps=2.54 w=1 l=0.15
X1160 a_11835_3828# a_11931_3650# VGND VGND sky130_fd_pr__nfet_01v8 ad=0.1092 pd=1.36 as=0.097 ps=0.975 w=0.42 l=0.5
X1161 VDPWR a_4730_1652# digital_0._101_.D VDPWR sky130_fd_pr__pfet_01v8_hvt ad=0.15835 pd=1.395 as=0.26 ps=2.52 w=1 l=0.15
X1162 VGND digital_0._112_.Q digital_0._063_.B VGND sky130_fd_pr__nfet_01v8 ad=0.26 pd=2.1 as=0.08775 ps=0.92 w=0.65 l=0.15
X1163 a_10546_2422# a_9465_2050# a_10199_2018# VDPWR sky130_fd_pr__pfet_01v8_hvt ad=0.0588 pd=0.7 as=0.12915 ps=1.185 w=0.42 l=0.15
X1164 VGND a_6315_1474# digital_0.clkbuf_1_0__f_clk.X VGND sky130_fd_pr__nfet_01v8 ad=0.0588 pd=0.7 as=0.0588 ps=0.7 w=0.42 l=0.15
X1165 a_5093_1500# digital_0.hold22.X a_4730_1652# VGND sky130_fd_pr__nfet_01v8 ad=0.0693 pd=0.75 as=0.09975 ps=0.895 w=0.42 l=0.15
X1166 a_13103_3171# digital_0.hold24.X a_12889_3171# VDPWR sky130_fd_pr__pfet_01v8_hvt ad=0.07665 pd=0.785 as=0.1932 ps=1.34 w=0.42 l=0.15
X1167 a_4872_1500# digital_0.hold28.A VGND VGND sky130_fd_pr__nfet_01v8 ad=0.0693 pd=0.75 as=0.11285 ps=1.045 w=0.42 l=0.15
X1168 VGND VDPWR VGND VGND sky130_fd_pr__nfet_01v8 ad=0.143 pd=1.62 as=0 ps=0 w=0.55 l=0.59
X1169 VDPWR a_13306_412# a_13481_386# VDPWR sky130_fd_pr__pfet_01v8_hvt ad=0.1134 pd=1.38 as=0.0567 ps=0.69 w=0.42 l=0.15
X1170 a_12646_412# digital_0._112_.D VDPWR VDPWR sky130_fd_pr__pfet_01v8_hvt ad=0.0651 pd=0.73 as=0.1092 ps=1.36 w=0.42 l=0.15
X1171 a_5840_1322# digital_0._118_.RESET_B VGND VGND sky130_fd_pr__nfet_01v8 ad=0.06405 pd=0.725 as=0.12495 ps=1.015 w=0.42 l=0.15
X1172 VDPWR a_6315_1474# digital_0.clkbuf_1_0__f_clk.X VDPWR sky130_fd_pr__pfet_01v8_hvt ad=0.14 pd=1.28 as=0.14 ps=1.28 w=1 l=0.15
X1173 digital_0._069_.A a_5787_2146# VGND VGND sky130_fd_pr__nfet_01v8 ad=0.08775 pd=0.92 as=0.1304 ps=1.105 w=0.65 l=0.15
X1174 VDPWR VGND VDPWR VDPWR sky130_fd_pr__pfet_01v8_hvt ad=0.2262 pd=2.26 as=0 ps=0 w=0.87 l=0.59
X1175 VGND a_11758_188# digital_0._113_.D VGND sky130_fd_pr__nfet_01v8 ad=0.169 pd=1.82 as=0.08775 ps=0.92 w=0.65 l=0.15
X1176 a_3858_n702# digital_0.output13.A VDPWR VDPWR sky130_fd_pr__pfet_01v8_hvt ad=0.27 pd=2.54 as=0.19265 ps=1.415 w=1 l=0.15
X1177 digital_0._116_.D a_5974_n676# VGND VGND sky130_fd_pr__nfet_01v8 ad=0.091 pd=0.93 as=0.1105 ps=0.99 w=0.65 l=0.15
X1178 a_11349_3676# digital_0.hold20.X a_10986_3828# VGND sky130_fd_pr__nfet_01v8 ad=0.0693 pd=0.75 as=0.09975 ps=0.895 w=0.42 l=0.15
X1179 LELO_GR01_0.x8.x1.x5.x8.G LELO_GR01_0.x8.x1.x5.x8.G LELO_GR01_0.x8.x1.x5.x8.S LELO_GR01_0.x8.x1.x5.x8.S sky130_fd_pr__pfet_01v8_lvt ad=0.3168 pd=1.62 as=0.5088 ps=2.98 w=0.96 l=0.94
X1180 a_10495_n702# digital_0.hold28.A VDPWR VDPWR sky130_fd_pr__pfet_01v8_hvt ad=0.1176 pd=1.4 as=0.0693 ps=0.75 w=0.42 l=0.15
X1181 a_12977_2044# digital_0._116_.Q VDPWR VDPWR sky130_fd_pr__pfet_01v8_hvt ad=0.28 pd=2.56 as=0.135 ps=1.27 w=1 l=0.15
X1182 a_4425_2730# digital_0.clkbuf_1_0__f_clk.X VDPWR VDPWR sky130_fd_pr__pfet_01v8_hvt ad=0.1664 pd=1.8 as=0.0864 ps=0.91 w=0.64 l=0.15
X1183 digital_0._116_.SET_B digital_0.load_slew15.X VGND VGND sky130_fd_pr__nfet_01v8 ad=0.08775 pd=0.92 as=0.169 ps=1.82 w=0.65 l=0.15
X1184 VDPWR a_8996_1500# digital_0.clkbuf_1_1__f_clk.A VDPWR sky130_fd_pr__pfet_01v8_hvt ad=0.14 pd=1.28 as=0.14 ps=1.28 w=1 l=0.15
X1185 VGND digital_0.load_slew17.X digital_0._115_.RESET_B VGND sky130_fd_pr__nfet_01v8 ad=0.169 pd=1.82 as=0.08775 ps=0.92 w=0.65 l=0.15
X1186 a_8996_1500# clk VGND VGND sky130_fd_pr__nfet_01v8 ad=0.0588 pd=0.7 as=0.0588 ps=0.7 w=0.42 l=0.15
X1187 VGND digital_0.input1.X a_6337_2050# VGND sky130_fd_pr__nfet_01v8 ad=0.0567 pd=0.69 as=0.1092 ps=1.36 w=0.42 l=0.15
X1188 VGND digital_0.clkload0.A a_10017_3138# VGND sky130_fd_pr__nfet_01v8 ad=0.0567 pd=0.69 as=0.1092 ps=1.36 w=0.42 l=0.15
X1189 VGND a_7001_110# a_6962_n16# VGND sky130_fd_pr__nfet_01v8 ad=0.0567 pd=0.69 as=0.1092 ps=1.36 w=0.42 l=0.15
X1190 a_15238_1334# a_14323_962# a_14891_930# VGND sky130_fd_pr__special_nfet_01v8 ad=0.0711 pd=0.755 as=0.0999 ps=0.985 w=0.36 l=0.15
X1191 digital_0._110_.D digital_0._067_.B VGND VGND sky130_fd_pr__nfet_01v8 ad=0.08775 pd=0.92 as=0.08775 ps=0.92 w=0.65 l=0.15
X1192 a_9985_386# digital_0._114_.RESET_B VDPWR VDPWR sky130_fd_pr__pfet_01v8_hvt ad=0.0567 pd=0.69 as=0.0819 ps=0.81 w=0.42 l=0.15
X1193 a_15225_n702# digital_0.output10.A VDPWR VDPWR sky130_fd_pr__pfet_01v8_hvt ad=0.1092 pd=1.36 as=0.0567 ps=0.69 w=0.42 l=0.15
X1194 VDPWR a_11388_956# digital_0.clkload0.A VDPWR sky130_fd_pr__pfet_01v8_hvt ad=0.1375 pd=1.275 as=0.14 ps=1.28 w=1 l=0.15
X1195 VDPWR a_4658_3510# a_4833_3436# VDPWR sky130_fd_pr__pfet_01v8_hvt ad=0.1134 pd=1.38 as=0.0567 ps=0.69 w=0.42 l=0.15
X1196 VDPWR a_10986_3828# digital_0._103_.D VDPWR sky130_fd_pr__pfet_01v8_hvt ad=0.15835 pd=1.395 as=0.26 ps=2.52 w=1 l=0.15
X1197 a_14891_930# a_14673_1334# VDPWR VDPWR sky130_fd_pr__pfet_01v8_hvt ad=0.12915 pd=1.185 as=0.2184 ps=2.2 w=0.84 l=0.15
X1198 a_9985_386# a_9810_412# a_10164_412# VGND sky130_fd_pr__nfet_01v8 ad=0.1092 pd=1.36 as=0.06405 ps=0.725 w=0.42 l=0.15
X1199 digital_0._110_.RESET_B digital_0._116_.Q VGND VGND sky130_fd_pr__nfet_01v8 ad=0.08775 pd=0.92 as=0.08775 ps=0.92 w=0.65 l=0.15
X1200 VDPWR a_12903_206# digital_0._057_.D VDPWR sky130_fd_pr__pfet_01v8_hvt ad=0.38 pd=2.76 as=0.195 ps=1.39 w=1 l=0.15
X1201 VGND VDPWR VGND VGND sky130_fd_pr__nfet_01v8 ad=0.143 pd=1.62 as=0 ps=0 w=0.55 l=0.59
X1202 LELO_GR01_0.x7.x1.x5.x8.G LELO_GR01_0.x7.x1.x5.x8.G LELO_GR01_0.x7.x1.x5.x8.S LELO_GR01_0.x7.x1.x5.x8.S sky130_fd_pr__pfet_01v8_lvt ad=0.3168 pd=1.62 as=0.5088 ps=2.98 w=0.96 l=0.94
X1203 digital_0.clkbuf_1_0__f_clk.X a_6315_1474# VGND VGND sky130_fd_pr__nfet_01v8 ad=0.0588 pd=0.7 as=0.0588 ps=0.7 w=0.42 l=0.15
X1204 digital_0._067_.A a_11107_2562# VGND VGND sky130_fd_pr__nfet_01v8 ad=0.12675 pd=1.04 as=0.247 ps=2.06 w=0.65 l=0.15
X1205 a_5486_1334# a_4405_962# a_5139_930# VDPWR sky130_fd_pr__pfet_01v8_hvt ad=0.0588 pd=0.7 as=0.12915 ps=1.185 w=0.42 l=0.15
X1206 LELO_GR01_0.x8.x7.D LELO_GR01_0.x8.PWRUP_N_1V8 VGND VGND sky130_fd_pr__nfet_01v8_lvt ad=0.3168 pd=1.62 as=0.5088 ps=2.98 w=0.96 l=0.94
R6 uio_oe<2> li_28516_19376# sky130_fd_pr__res_generic_m4 w=0.3 l=0.3
X1207 a_4610_386# a_4438_386# a_5014_778# VDPWR sky130_fd_pr__pfet_01v8_hvt ad=0.0567 pd=0.69 as=0.0945 ps=0.87 w=0.42 l=0.15
X1208 VGND a_13481_1474# a_13415_1500# VGND sky130_fd_pr__nfet_01v8 ad=0.12495 pd=1.015 as=0.0669 ps=0.75 w=0.42 l=0.15
X1209 VGND a_4438_386# a_4530_626# VGND sky130_fd_pr__nfet_01v8 ad=0.0567 pd=0.69 as=0.1092 ps=1.36 w=0.42 l=0.15
X1210 digital_0.clkbuf_1_0__f_clk.X a_6315_1474# VDPWR VDPWR sky130_fd_pr__pfet_01v8_hvt ad=0.14 pd=1.28 as=0.14 ps=1.28 w=1 l=0.15
X1211 digital_0._111_.D a_10074_2562# VGND VGND sky130_fd_pr__nfet_01v8 ad=0.08775 pd=0.92 as=0.18525 ps=1.87 w=0.65 l=0.15
X1212 digital_0._116_.Q a_3814_386# VGND VGND sky130_fd_pr__nfet_01v8 ad=0.08775 pd=0.92 as=0.169 ps=1.82 w=0.65 l=0.15
X1213 a_5075_234# a_4696_n132# a_5003_234# VGND sky130_fd_pr__nfet_01v8 ad=0.1401 pd=1.1 as=0.0441 ps=0.63 w=0.42 l=0.15
X1214 VDPWR digital_0._110_.Q a_11107_2562# VDPWR sky130_fd_pr__pfet_01v8_hvt ad=0.1176 pd=1.4 as=0.0567 ps=0.69 w=0.42 l=0.15
X1215 VGND VDPWR VGND VGND sky130_fd_pr__nfet_01v8 ad=0.143 pd=1.62 as=0 ps=0 w=0.55 l=0.59
X1216 VGND VDPWR VGND VGND sky130_fd_pr__nfet_01v8 ad=0.143 pd=1.62 as=0 ps=0 w=0.55 l=0.59
X1217 a_12837_1500# a_12391_1500# a_12741_1500# VGND sky130_fd_pr__special_nfet_01v8 ad=0.1401 pd=1.1 as=0.0594 ps=0.69 w=0.36 l=0.15
X1218 VGND VDPWR VGND VGND sky130_fd_pr__nfet_01v8 ad=0.143 pd=1.62 as=0 ps=0 w=0.55 l=0.59
X1219 digital_0.output4.A a_4005_n158# VDPWR VDPWR sky130_fd_pr__pfet_01v8_hvt ad=0.135 pd=1.27 as=0.26 ps=2.52 w=1 l=0.15
X1220 VDPWR digital_0.input1.X a_12225_1500# VDPWR sky130_fd_pr__pfet_01v8_hvt ad=0.0864 pd=0.91 as=0.1664 ps=1.8 w=0.64 l=0.15
X1221 digital_0.clkbuf_1_1__f_clk.A a_8996_1500# VDPWR VDPWR sky130_fd_pr__pfet_01v8_hvt ad=0.14 pd=1.28 as=0.14 ps=1.28 w=1 l=0.15
X1222 VGND a_4228_3650# uo_out<1> VGND sky130_fd_pr__nfet_01v8 ad=0.1856 pd=1.26 as=0.2079 ps=1.83 w=0.42 l=0.15
X1223 LELO_GR01_0.x7.x1.x7.D LELO_GR01_0.PWRUP_1V8 VDPWR VDPWR sky130_fd_pr__pfet_01v8_lvt ad=0.3168 pd=1.62 as=0.5088 ps=2.98 w=0.96 l=0.94
X1224 a_5974_n676# digital_0.hold18.X a_5785_n426# VDPWR sky130_fd_pr__pfet_01v8_hvt ad=0.265 pd=2.53 as=0.14 ps=1.28 w=1 l=0.15
R7 uio_oe<4> li_28516_19376# sky130_fd_pr__res_generic_m4 w=0.3 l=0.3
X1225 a_5109_2348# digital_0._101_.RESET_B VDPWR VDPWR sky130_fd_pr__pfet_01v8_hvt ad=0.0567 pd=0.69 as=0.0819 ps=0.81 w=0.42 l=0.15
X1226 VDPWR digital_0._107_.RESET_B a_6397_n158# VDPWR sky130_fd_pr__pfet_01v8_hvt ad=0.0819 pd=0.81 as=0.0567 ps=0.69 w=0.42 l=0.15
X1227 VDPWR VGND VDPWR VDPWR sky130_fd_pr__pfet_01v8_hvt ad=0.2262 pd=2.26 as=0 ps=0 w=0.87 l=0.59
X1228 a_9810_412# a_8729_412# a_9463_654# VDPWR sky130_fd_pr__pfet_01v8_hvt ad=0.0588 pd=0.7 as=0.12915 ps=1.185 w=0.42 l=0.15
X1229 VGND VDPWR VGND VGND sky130_fd_pr__nfet_01v8 ad=0.143 pd=1.62 as=0 ps=0 w=0.55 l=0.59
X1230 uio_out<4> a_15773_2044# VDPWR VDPWR sky130_fd_pr__pfet_01v8_hvt ad=0.495 pd=2.99 as=0.2726 ps=1.61 w=1 l=0.15
X1231 VGND digital_0._110_.Q digital_0._067_.B VGND sky130_fd_pr__nfet_01v8 ad=0.182 pd=1.86 as=0.08775 ps=0.92 w=0.65 l=0.15
X1232 a_9930_930# digital_0.load_slew17.X VGND VGND sky130_fd_pr__nfet_01v8 ad=0.1134 pd=1.38 as=0.1228 ps=1.065 w=0.42 l=0.15
X1233 a_5139_930# a_4921_1334# VGND VGND sky130_fd_pr__nfet_01v8 ad=0.0999 pd=0.985 as=0.1346 ps=1.15 w=0.64 l=0.15
X1234 VGND a_11431_2382# digital_0._065_.A2_N VGND sky130_fd_pr__nfet_01v8 ad=0.247 pd=2.06 as=0.12675 ps=1.04 w=0.65 l=0.15
X1235 a_4228_3650# a_4354_3834# VGND VGND sky130_fd_pr__nfet_01v8 ad=0.17225 pd=1.83 as=0.1856 ps=1.26 w=0.65 l=0.25
X1236 a_13306_1500# a_12225_1500# a_12959_1742# VDPWR sky130_fd_pr__pfet_01v8_hvt ad=0.0588 pd=0.7 as=0.12915 ps=1.185 w=0.42 l=0.15
X1237 a_4696_n132# a_4570_n16# a_4292_0# VGND sky130_fd_pr__special_nfet_01v8 ad=0.0999 pd=0.985 as=0.0711 ps=0.755 w=0.36 l=0.15
X1238 VGND digital_0.load_slew17.A digital_0._104_.RESET_B VGND sky130_fd_pr__nfet_01v8 ad=0.169 pd=1.82 as=0.08775 ps=0.92 w=0.65 l=0.15
X1239 a_4820_3132# a_3743_3138# a_4658_3510# VDPWR sky130_fd_pr__pfet_01v8_hvt ad=0.0567 pd=0.69 as=0.0588 ps=0.7 w=0.42 l=0.15
X1240 VDPWR VGND VDPWR VDPWR sky130_fd_pr__pfet_01v8_hvt ad=0.2262 pd=2.26 as=0 ps=0 w=0.87 l=0.59
X1241 LELO_GR01_0.x7.x6<3>.G LELO_GR01_0.x7.x6<3>.G LELO_GR01_0.x7.x7.S VGND sky130_fd_pr__nfet_01v8_lvt ad=0.3168 pd=1.62 as=0.5088 ps=2.98 w=0.96 l=0.94
X1242 a_12116_188# digital_0._113_.Q VGND VGND sky130_fd_pr__nfet_01v8 ad=0.08775 pd=0.92 as=0.08775 ps=0.92 w=0.65 l=0.15
X1243 a_8079_2588# a_6889_2588# a_7970_2588# VGND sky130_fd_pr__special_nfet_01v8 ad=0.0669 pd=0.75 as=0.0711 ps=0.755 w=0.36 l=0.15
X1244 a_7375_1276# digital_0._115_.Q VGND VGND sky130_fd_pr__nfet_01v8 ad=0.169 pd=1.82 as=0.08775 ps=0.92 w=0.65 l=0.15
X1245 digital_0.load_slew17.X a_14762_2018# VDPWR VDPWR sky130_fd_pr__pfet_01v8_hvt ad=0.135 pd=1.27 as=0.265 ps=2.53 w=1 l=0.15
X1246 LELO_GR01_0.x7.x1.x5.x9<2>.G LELO_GR01_0.x7.x1.x5.x9<2>.G VGND VGND sky130_fd_pr__nfet_01v8_lvt ad=0.3168 pd=1.62 as=0.5088 ps=2.98 w=0.96 l=0.94
X1247 a_14205_n349# digital_0._113_.Q a_13746_n524# VDPWR sky130_fd_pr__pfet_01v8_hvt ad=0.0441 pd=0.63 as=0.1932 ps=1.34 w=0.42 l=0.15
X1248 a_6949_2422# a_6503_2050# a_6853_2422# VGND sky130_fd_pr__special_nfet_01v8 ad=0.1401 pd=1.1 as=0.0594 ps=0.69 w=0.36 l=0.15
X1249 VGND a_12903_206# digital_0._057_.D VGND sky130_fd_pr__nfet_01v8 ad=0.247 pd=2.06 as=0.12675 ps=1.04 w=0.65 l=0.15
X1250 VGND digital_0.clkbuf_1_1__f_clk.A a_6315_1474# VGND sky130_fd_pr__nfet_01v8 ad=0.0588 pd=0.7 as=0.0588 ps=0.7 w=0.42 l=0.15
X1251 a_7483_412# a_7439_654# a_7317_412# VGND sky130_fd_pr__nfet_01v8 ad=0.0441 pd=0.63 as=0.1401 ps=1.1 w=0.42 l=0.15
X1252 digital_0.clkload0.A a_11388_956# VGND VGND sky130_fd_pr__nfet_01v8 ad=0.0588 pd=0.7 as=0.0588 ps=0.7 w=0.42 l=0.15
X1253 a_5870_2404# digital_0.output13.A a_5787_2146# VGND sky130_fd_pr__nfet_01v8 ad=0.0441 pd=0.63 as=0.1092 ps=1.36 w=0.42 l=0.15
X1254 VGND digital_0._108_.Q a_6235_3106# VGND sky130_fd_pr__nfet_01v8 ad=0.08775 pd=0.92 as=0.08775 ps=0.92 w=0.65 l=0.15
X1255 VDPWR digital_0.clkload0.A a_14157_962# VDPWR sky130_fd_pr__pfet_01v8_hvt ad=0.0864 pd=0.91 as=0.1664 ps=1.8 w=0.64 l=0.15
X1256 LELO_GR01_0.x7.x22.D LELO_GR01_0.x8.PWRUP_N_1V8 LELO_GR01_0.x7.x21.D VDPWR sky130_fd_pr__pfet_01v8_lvt ad=0.5088 pd=2.98 as=0.3168 ps=1.62 w=0.96 l=0.94
X1257 digital_0.output8.A a_11273_3436# VDPWR VDPWR sky130_fd_pr__pfet_01v8_hvt ad=0.135 pd=1.27 as=0.3012 ps=2.66 w=1 l=0.15
X1258 a_5868_n676# digital_0._080_.A2 VGND VGND sky130_fd_pr__nfet_01v8 ad=0.1235 pd=1.03 as=0.17225 ps=1.83 w=0.65 l=0.15
X1259 VGND digital_0.input1.X a_6889_2588# VGND sky130_fd_pr__nfet_01v8 ad=0.0567 pd=0.69 as=0.1092 ps=1.36 w=0.42 l=0.15
X1260 LELO_GR01_0.x7.x19.D LELO_GR01_0.x8.PWRUP_N_1V8 LELO_GR01_0.x7.x20.D VDPWR sky130_fd_pr__pfet_01v8_lvt ad=0.3168 pd=1.62 as=0.5088 ps=2.98 w=0.96 l=0.94
X1261 a_6455_3452# digital_0.output13.A VGND VGND sky130_fd_pr__nfet_01v8 ad=0.169 pd=1.82 as=0.08775 ps=0.92 w=0.65 l=0.15
X1262 LELO_GR01_0.x7.x6<3>.G LELO_GR01_0.x7.x6<3>.G LELO_GR01_0.x7.x7.S VGND sky130_fd_pr__nfet_01v8_lvt ad=0.3168 pd=1.62 as=0.5088 ps=2.98 w=0.96 l=0.94
X1263 VDPWR VGND VDPWR VDPWR sky130_fd_pr__pfet_01v8_hvt ad=0.2262 pd=2.26 as=0 ps=0 w=0.87 l=0.59
X1264 VGND VDPWR VGND VGND sky130_fd_pr__nfet_01v8 ad=0.143 pd=1.62 as=0 ps=0 w=0.55 l=0.59
X1265 LELO_GR01_0.x7.x1.x5.IBN LELO_GR01_0.x7.x1.x5.x9<2>.G VGND VGND sky130_fd_pr__nfet_01v8_lvt ad=0.3168 pd=1.62 as=0.5088 ps=2.98 w=0.96 l=0.94
X1266 VDPWR digital_0.output13.A a_7349_3132# VDPWR sky130_fd_pr__pfet_01v8_hvt ad=0.135 pd=1.27 as=0.14 ps=1.28 w=1 l=0.15
X1267 VDPWR LELO_GR01_0.x7.x18.G LELO_GR01_0.x7.x15.I2 VDPWR sky130_fd_pr__pfet_01v8_lvt ad=0.5088 pd=2.98 as=0.3168 ps=1.62 w=0.96 l=0.94
X1268 digital_0._080_.A2 digital_0.input2.X VGND VGND sky130_fd_pr__nfet_01v8 ad=0.08775 pd=0.92 as=0.169 ps=1.82 w=0.65 l=0.15
X1269 a_12189_2588# a_11839_2588# a_12094_2588# VDPWR sky130_fd_pr__pfet_01v8_hvt ad=0.07245 pd=0.765 as=0.0651 ps=0.73 w=0.42 l=0.15
X1270 a_12817_3171# a_12635_3171# VDPWR VDPWR sky130_fd_pr__pfet_01v8_hvt ad=0.0441 pd=0.63 as=0.0693 ps=0.75 w=0.42 l=0.15
X1271 VGND digital_0._063_.A a_11758_188# VGND sky130_fd_pr__nfet_01v8 ad=0.169 pd=1.82 as=0.08775 ps=0.92 w=0.65 l=0.15
X1272 a_7673_n349# digital_0._115_.Q a_7214_n524# VDPWR sky130_fd_pr__pfet_01v8_hvt ad=0.0441 pd=0.63 as=0.1932 ps=1.34 w=0.42 l=0.15
X1273 VDPWR digital_0.load_slew15.A a_8085_1500# VDPWR sky130_fd_pr__pfet_01v8_hvt ad=0.135 pd=1.27 as=0.26 ps=2.52 w=1 l=0.15
X1274 VGND digital_0._110_.Q a_11517_2382# VGND sky130_fd_pr__nfet_01v8 ad=0.1118 pd=1.04 as=0.0567 ps=0.69 w=0.42 l=0.15
X1275 a_9886_234# digital_0._106_.D VDPWR VDPWR sky130_fd_pr__pfet_01v8_hvt ad=0.0651 pd=0.73 as=0.1092 ps=1.36 w=0.42 l=0.15
X1276 VGND a_15685_386# a_15427_386# VGND sky130_fd_pr__nfet_01v8 ad=0.0567 pd=0.69 as=0.1092 ps=1.36 w=0.42 l=0.5
X1277 VGND digital_0._069_.B digital_0._109_.D VGND sky130_fd_pr__nfet_01v8 ad=0.08775 pd=0.92 as=0.08775 ps=0.92 w=0.65 l=0.15
X1278 digital_0._112_.D digital_0._063_.B VGND VGND sky130_fd_pr__nfet_01v8 ad=0.08775 pd=0.92 as=0.08775 ps=0.92 w=0.65 l=0.15
X1279 digital_0._065_.A2_N a_11431_2382# VGND VGND sky130_fd_pr__nfet_01v8 ad=0.12675 pd=1.04 as=0.1118 ps=1.04 w=0.65 l=0.15
X1280 a_4369_1474# digital_0.output13.A VGND VGND sky130_fd_pr__nfet_01v8 ad=0.1092 pd=1.36 as=0.0567 ps=0.69 w=0.42 l=0.15
X1281 VGND a_3858_930# a_3618_1194# VGND sky130_fd_pr__nfet_01v8 ad=0.1228 pd=1.065 as=0.17225 ps=1.83 w=0.65 l=0.25
X1282 a_4594_3650# digital_0.output4.A VGND VGND sky130_fd_pr__nfet_01v8 ad=0.1134 pd=1.38 as=0.1228 ps=1.065 w=0.42 l=0.15
X1283 VGND a_11388_956# digital_0.clkload0.A VGND sky130_fd_pr__nfet_01v8 ad=0.0588 pd=0.7 as=0.0588 ps=0.7 w=0.42 l=0.15
X1284 a_6758_2410# digital_0._108_.D VDPWR VDPWR sky130_fd_pr__pfet_01v8_hvt ad=0.0651 pd=0.73 as=0.1092 ps=1.36 w=0.42 l=0.15
X1285 LELO_GR01_0.x7.x15.I2 LELO_GR01_0.x7.x18.G VDPWR VDPWR sky130_fd_pr__pfet_01v8_lvt ad=0.3168 pd=1.62 as=0.5088 ps=2.98 w=0.96 l=0.94
X1286 digital_0._111_.RESET_B digital_0.load_slew17.A VGND VGND sky130_fd_pr__nfet_01v8 ad=0.08775 pd=0.92 as=0.08775 ps=0.92 w=0.65 l=0.15
X1287 digital_0._103_.RESET_B digital_0.load_slew17.A VDPWR VDPWR sky130_fd_pr__pfet_01v8_hvt ad=0.135 pd=1.27 as=0.26 ps=2.52 w=1 l=0.15
X1288 a_13481_386# digital_0._112_.RESET_B VDPWR VDPWR sky130_fd_pr__pfet_01v8_hvt ad=0.0567 pd=0.69 as=0.0819 ps=0.81 w=0.42 l=0.15
X1289 a_7071_2018# a_6853_2422# VDPWR VDPWR sky130_fd_pr__pfet_01v8_hvt ad=0.12915 pd=1.185 as=0.2184 ps=2.2 w=0.84 l=0.15
X1290 VGND digital_0.clkbuf_1_0__f_clk.X a_4405_962# VGND sky130_fd_pr__nfet_01v8 ad=0.0567 pd=0.69 as=0.1092 ps=1.36 w=0.42 l=0.15
X1291 VGND a_3492_3650# uio_out<0> VGND sky130_fd_pr__nfet_01v8 ad=0.1856 pd=1.26 as=0.2079 ps=1.83 w=0.42 l=0.15
X1292 a_13481_386# a_13306_412# a_13660_412# VGND sky130_fd_pr__nfet_01v8 ad=0.1092 pd=1.36 as=0.06405 ps=0.725 w=0.42 l=0.15
X1293 LELO_GR01_0.x7.x1.x7.D LELO_GR01_0.x7.x7.G LELO_GR01_0.x7.x1.x5.IBN VGND sky130_fd_pr__nfet_01v8_lvt ad=0.3168 pd=1.62 as=0.5088 ps=2.98 w=0.96 l=0.94
X1294 VDPWR VGND VDPWR VDPWR sky130_fd_pr__pfet_01v8_hvt ad=0.2262 pd=2.26 as=0 ps=0 w=0.87 l=0.59
X1295 a_12297_2954# a_11673_2588# a_12189_2588# VDPWR sky130_fd_pr__pfet_01v8_hvt ad=0.1155 pd=0.97 as=0.07245 ps=0.765 w=0.42 l=0.15
X1296 LELO_GR01_0.x7.x23.D LELO_GR01_0.x8.PWRUP_N_1V8 LELO_GR01_0.x7.x24.D VDPWR sky130_fd_pr__pfet_01v8_lvt ad=0.3168 pd=1.62 as=0.5088 ps=2.98 w=0.96 l=0.94
X1297 VGND LELO_GR01_0.x8.x4.G LELO_GR01_0.x8.IBP_BG VGND sky130_fd_pr__nfet_01v8_lvt ad=0.5088 pd=2.98 as=0.3168 ps=1.62 w=0.96 l=0.94
X1298 LELO_GR01_0.x8.x8.D LELO_GR01_0.x8.PWRUP_N_1V8 VDPWR VDPWR sky130_fd_pr__pfet_01v8_lvt ad=0.3168 pd=1.62 as=0.5088 ps=2.98 w=0.96 l=0.94
X1299 digital_0.clkbuf_1_0__f_clk.X a_6315_1474# VDPWR VDPWR sky130_fd_pr__pfet_01v8_hvt ad=0.14 pd=1.28 as=0.14 ps=1.28 w=1 l=0.15
X1300 a_10525_n349# digital_0._114_.Q a_10066_n524# VDPWR sky130_fd_pr__pfet_01v8_hvt ad=0.0441 pd=0.63 as=0.1932 ps=1.34 w=0.42 l=0.15
X1301 VGND a_15634_1474# a_15394_1658# VGND sky130_fd_pr__nfet_01v8 ad=0.1228 pd=1.065 as=0.17225 ps=1.83 w=0.65 l=0.25
X1302 VDPWR VGND VDPWR VDPWR sky130_fd_pr__pfet_01v8_hvt ad=0.2262 pd=2.26 as=0 ps=0 w=0.87 l=0.59
X1303 a_8578_n132# a_8361_n132# VDPWR VDPWR sky130_fd_pr__pfet_01v8_hvt ad=0.2173 pd=2.17 as=0.19265 ps=1.415 w=0.82 l=0.25
X1304 VGND VGND LELO_GR01_0.x7.x15.I1 sky130_fd_pr__pnp_05v5_W3p40L3p40
**devattr s=462400,2720
X1305 a_14339_n158# a_14121_246# VDPWR VDPWR sky130_fd_pr__pfet_01v8_hvt ad=0.12915 pd=1.185 as=0.2184 ps=2.2 w=0.84 l=0.15
X1306 VGND VGND LELO_GR01_0.x7.x15.I1 sky130_fd_pr__pnp_05v5_W3p40L3p40
**devattr s=462400,2720
X1307 digital_0.output10.A a_14861_172# VDPWR VDPWR sky130_fd_pr__pfet_01v8_hvt ad=0.135 pd=1.27 as=0.3012 ps=2.66 w=1 l=0.15
X1308 a_7418_2422# a_6337_2050# a_7071_2018# VDPWR sky130_fd_pr__pfet_01v8_hvt ad=0.0588 pd=0.7 as=0.12915 ps=1.185 w=0.42 l=0.15
X1309 a_13481_1474# a_13306_1500# a_13660_1500# VGND sky130_fd_pr__nfet_01v8 ad=0.1092 pd=1.36 as=0.06405 ps=0.725 w=0.42 l=0.15
X1310 a_4369_2422# a_3853_2050# a_4274_2410# VGND sky130_fd_pr__special_nfet_01v8 ad=0.0594 pd=0.69 as=0.066 ps=0.745 w=0.36 l=0.15
X1311 VGND clk a_8996_1500# VGND sky130_fd_pr__nfet_01v8 ad=0.0588 pd=0.7 as=0.0588 ps=0.7 w=0.42 l=0.15
X1312 a_6758_2410# digital_0._108_.D VGND VGND sky130_fd_pr__nfet_01v8 ad=0.066 pd=0.745 as=0.2205 ps=1.89 w=0.42 l=0.15
X1313 a_10438_3498# digital_0._103_.D VGND VGND sky130_fd_pr__nfet_01v8 ad=0.066 pd=0.745 as=0.2205 ps=1.89 w=0.42 l=0.15
X1314 VDPWR digital_0.load_slew17.X digital_0._106_.RESET_B VDPWR sky130_fd_pr__pfet_01v8_hvt ad=0.26 pd=2.52 as=0.135 ps=1.27 w=1 l=0.15
X1315 VGND a_4005_n158# digital_0.output4.A VGND sky130_fd_pr__nfet_01v8 ad=0.2087 pd=2.02 as=0.08775 ps=0.92 w=0.65 l=0.15
X1316 VDPWR a_14990_386# a_14750_570# VDPWR sky130_fd_pr__pfet_01v8_hvt ad=0.19265 pd=1.415 as=0.2173 ps=2.17 w=0.82 l=0.25
X1317 VDPWR a_14769_3436# a_14756_3132# VDPWR sky130_fd_pr__pfet_01v8_hvt ad=0.0819 pd=0.81 as=0.0567 ps=0.69 w=0.42 l=0.15
X1318 digital_0._112_.RESET_B digital_0.load_slew17.X VGND VGND sky130_fd_pr__nfet_01v8 ad=0.08775 pd=0.92 as=0.08775 ps=0.92 w=0.65 l=0.15
X1319 VDPWR digital_0._116_.SET_B a_4746_412# VDPWR sky130_fd_pr__pfet_01v8_hvt ad=0.0798 pd=0.8 as=0.0567 ps=0.69 w=0.42 l=0.15
X1320 digital_0.output12.A a_6397_n158# VGND VGND sky130_fd_pr__nfet_01v8 ad=0.08775 pd=0.92 as=0.169 ps=1.82 w=0.65 l=0.15
X1321 VGND a_6315_1474# digital_0.clkbuf_1_0__f_clk.X VGND sky130_fd_pr__nfet_01v8 ad=0.0588 pd=0.7 as=0.0588 ps=0.7 w=0.42 l=0.15
X1322 digital_0._063_.A a_11951_2146# VDPWR VDPWR sky130_fd_pr__pfet_01v8_hvt ad=0.135 pd=1.27 as=0.15075 ps=1.345 w=1 l=0.15
X1323 a_13468_778# a_12391_412# a_13306_412# VDPWR sky130_fd_pr__pfet_01v8_hvt ad=0.0567 pd=0.69 as=0.0588 ps=0.7 w=0.42 l=0.15
X1324 a_14686_246# a_13605_n126# a_14339_n158# VDPWR sky130_fd_pr__pfet_01v8_hvt ad=0.0588 pd=0.7 as=0.12915 ps=1.185 w=0.42 l=0.15
X1325 VDPWR a_8578_n676# a_8689_n676# VDPWR sky130_fd_pr__pfet_01v8_hvt ad=0.2726 pd=1.61 as=0.2173 ps=2.17 w=0.82 l=0.25
X1326 VDPWR a_11388_956# digital_0.clkload0.A VDPWR sky130_fd_pr__pfet_01v8_hvt ad=0.14 pd=1.28 as=0.14 ps=1.28 w=1 l=0.15
X1327 VDPWR VGND VDPWR VDPWR sky130_fd_pr__pfet_01v8_hvt ad=0.2262 pd=2.26 as=0 ps=0 w=0.87 l=0.59
X1328 VDPWR a_6315_1474# digital_0.clkbuf_1_0__f_clk.X VDPWR sky130_fd_pr__pfet_01v8_hvt ad=0.14 pd=1.28 as=0.14 ps=1.28 w=1 l=0.15
X1329 a_7310_2588# digital_0._109_.D VDPWR VDPWR sky130_fd_pr__pfet_01v8_hvt ad=0.0651 pd=0.73 as=0.1092 ps=1.36 w=0.42 l=0.15
X1330 uio_out<3> a_12829_3676# VDPWR VDPWR sky130_fd_pr__pfet_01v8_hvt ad=0.495 pd=2.99 as=0.2726 ps=1.61 w=1 l=0.15
X1331 LELO_GR01_0.x8.x7.D LELO_GR01_0.x8.VREF_BG LELO_GR01_0.x8.x1.x5.IBN VGND sky130_fd_pr__nfet_01v8_lvt ad=0.3168 pd=1.62 as=0.5088 ps=2.98 w=0.96 l=0.94
X1332 VGND a_15413_1260# a_15347_1334# VGND sky130_fd_pr__nfet_01v8 ad=0.12495 pd=1.015 as=0.0669 ps=0.75 w=0.42 l=0.15
X1333 digital_0._112_.RESET_B digital_0.load_slew17.X a_15537_n426# VDPWR sky130_fd_pr__pfet_01v8_hvt ad=0.135 pd=1.27 as=0.135 ps=1.27 w=1 l=0.15
X1334 VDPWR digital_0._112_.Q a_10997_386# VDPWR sky130_fd_pr__pfet_01v8_hvt ad=0.1092 pd=1.36 as=0.07455 ps=0.775 w=0.42 l=0.15
X1335 VGND digital_0.input1.X a_6705_412# VGND sky130_fd_pr__nfet_01v8 ad=0.0567 pd=0.69 as=0.1092 ps=1.36 w=0.42 l=0.15
X1336 a_4526_n132# a_4005_n158# VDPWR VDPWR sky130_fd_pr__pfet_01v8_hvt ad=0.0567 pd=0.69 as=0.0819 ps=0.81 w=0.42 l=0.15
X1337 a_7155_930# digital_0._060_.A_N VGND VGND sky130_fd_pr__nfet_01v8 ad=0.08775 pd=0.92 as=0.169 ps=1.82 w=0.65 l=0.15
X1338 digital_0._104_.RESET_B digital_0.load_slew17.A VDPWR VDPWR sky130_fd_pr__pfet_01v8_hvt ad=0.135 pd=1.27 as=0.26 ps=2.52 w=1 l=0.15
X1339 LELO_GR01_0.x7.x18.G LELO_GR01_0.x7.x18.D LELO_GR01_0.x7.x6<3>.G VGND sky130_fd_pr__nfet_01v8_lvt ad=0.3168 pd=1.62 as=0.5088 ps=2.98 w=0.96 l=0.94
X1340 VDPWR a_7001_110# a_6962_n16# VDPWR sky130_fd_pr__pfet_01v8_hvt ad=0.0864 pd=0.91 as=0.1664 ps=1.8 w=0.64 l=0.15
X1341 a_4108_2840# a_4386_2856# a_4342_2954# VDPWR sky130_fd_pr__pfet_01v8_hvt ad=0.0588 pd=0.7 as=0.0567 ps=0.69 w=0.42 l=0.15
X1342 VDPWR digital_0.clkbuf_1_0__f_clk.X a_3853_2050# VDPWR sky130_fd_pr__pfet_01v8_hvt ad=0.0864 pd=0.91 as=0.1664 ps=1.8 w=0.64 l=0.15
X1343 a_14029_3510# a_13513_3138# a_13934_3498# VGND sky130_fd_pr__special_nfet_01v8 ad=0.0594 pd=0.69 as=0.066 ps=0.745 w=0.36 l=0.15
X1344 VGND digital_0._069_.A digital_0._067_.B VGND sky130_fd_pr__nfet_01v8 ad=0.08775 pd=0.92 as=0.08775 ps=0.92 w=0.65 l=0.15
X1345 a_8145_2562# a_7970_2588# a_8324_2588# VGND sky130_fd_pr__nfet_01v8 ad=0.1092 pd=1.36 as=0.06405 ps=0.725 w=0.42 l=0.15
X1346 a_12626_n676# a_12409_n676# VDPWR VDPWR sky130_fd_pr__pfet_01v8_hvt ad=0.2173 pd=2.17 as=0.19265 ps=1.415 w=0.82 l=0.25
X1347 VDPWR LELO_GR01_0.x7.x18.G LELO_GR01_0.x7.x7.G VDPWR sky130_fd_pr__pfet_01v8_lvt ad=0.5088 pd=2.98 as=0.3168 ps=1.62 w=0.96 l=0.94
X1348 VDPWR a_4594_3650# a_4354_3834# VDPWR sky130_fd_pr__pfet_01v8_hvt ad=0.19265 pd=1.415 as=0.2173 ps=2.17 w=0.82 l=0.25
X1349 a_3858_3650# digital_0.output5.A VGND VGND sky130_fd_pr__nfet_01v8 ad=0.1134 pd=1.38 as=0.1228 ps=1.065 w=0.42 l=0.15
X1350 digital_0._113_.D a_11758_188# VGND VGND sky130_fd_pr__nfet_01v8 ad=0.08775 pd=0.92 as=0.169 ps=1.82 w=0.65 l=0.15
X1351 a_11353_2616# digital_0._069_.A VGND VGND sky130_fd_pr__nfet_01v8 ad=0.0567 pd=0.69 as=0.1118 ps=1.04 w=0.42 l=0.15
X1352 LELO_GR01_0.x7.x15.I2 LELO_GR01_0.x7.x18.G VDPWR VDPWR sky130_fd_pr__pfet_01v8_lvt ad=0.3168 pd=1.62 as=0.5088 ps=2.98 w=0.96 l=0.94
X1353 VGND VDPWR VGND VGND sky130_fd_pr__nfet_01v8 ad=0.143 pd=1.62 as=0 ps=0 w=0.55 l=0.59
X1354 LELO_GR01_0.x8.x1.x5.x8.S LELO_GR01_0.x8.PWRUP_N_1V8 VDPWR VDPWR sky130_fd_pr__pfet_01v8_lvt ad=0.3168 pd=1.62 as=0.5088 ps=2.98 w=0.96 l=0.94
X1355 digital_0.clkbuf_1_1__f_clk.A a_8996_1500# VGND VGND sky130_fd_pr__nfet_01v8 ad=0.0588 pd=0.7 as=0.0588 ps=0.7 w=0.42 l=0.15
X1356 a_10555_956# digital_0._069_.A VDPWR VDPWR sky130_fd_pr__pfet_01v8_hvt ad=0.215 pd=1.43 as=0.135 ps=1.27 w=1 l=0.15
X1357 VGND digital_0.output12.A a_8361_n676# VGND sky130_fd_pr__nfet_01v8 ad=0.1228 pd=1.065 as=0.1134 ps=1.38 w=0.42 l=0.15
X1358 a_11397_1750# digital_0._069_.A VDPWR VDPWR sky130_fd_pr__pfet_01v8_hvt ad=0.14 pd=1.28 as=0.14 ps=1.28 w=1 l=0.15
X1359 a_6235_3106# digital_0._108_.Q VGND VGND sky130_fd_pr__nfet_01v8 ad=0.08775 pd=0.92 as=0.169 ps=1.82 w=0.65 l=0.15
X1360 VGND LELO_GR01_0.x8.x1.x5.x9<2>.G LELO_GR01_0.x8.x1.x5.IBN VGND sky130_fd_pr__nfet_01v8_lvt ad=0.5088 pd=2.98 as=0.3168 ps=1.62 w=0.96 l=0.94
X1361 VGND VDPWR VGND VGND sky130_fd_pr__nfet_01v8 ad=0.143 pd=1.62 as=0 ps=0 w=0.55 l=0.59
X1362 VGND LELO_GR01_0.x7.x1.x5.x9<2>.G LELO_GR01_0.x7.x1.x5.IBN VGND sky130_fd_pr__nfet_01v8_lvt ad=0.5088 pd=2.98 as=0.3168 ps=1.62 w=0.96 l=0.94
X1363 a_7717_3926# digital_0._116_.Q VDPWR VDPWR sky130_fd_pr__pfet_01v8_hvt ad=0.135 pd=1.27 as=0.135 ps=1.27 w=1 l=0.15
X1364 VGND digital_0._105_.RESET_B a_14383_234# VGND sky130_fd_pr__nfet_01v8 ad=0.1346 pd=1.15 as=0.0441 ps=0.63 w=0.42 l=0.15
X1365 a_6315_1474# digital_0.clkbuf_1_1__f_clk.A VGND VGND sky130_fd_pr__nfet_01v8 ad=0.0588 pd=0.7 as=0.0588 ps=0.7 w=0.42 l=0.15
X1366 a_7826_956# digital_0._115_.Q VDPWR VDPWR sky130_fd_pr__pfet_01v8_hvt ad=0.275 pd=2.55 as=0.135 ps=1.27 w=1 l=0.15
X1367 a_10438_3498# digital_0._103_.D VDPWR VDPWR sky130_fd_pr__pfet_01v8_hvt ad=0.0651 pd=0.73 as=0.1092 ps=1.36 w=0.42 l=0.15
X1368 VGND a_3471_1474# digital_0._118_.D VGND sky130_fd_pr__nfet_01v8 ad=0.1118 pd=1.04 as=0.12675 ps=1.04 w=0.65 l=0.15
X1369 digital_0._118_.D a_3471_1474# VDPWR VDPWR sky130_fd_pr__pfet_01v8_hvt ad=0.195 pd=1.39 as=0.38 ps=2.76 w=1 l=0.15
X1370 VDPWR digital_0._069_.A a_7181_3926# VDPWR sky130_fd_pr__pfet_01v8_hvt ad=0.135 pd=1.27 as=0.135 ps=1.27 w=1 l=0.15
X1371 LELO_GR01_0.x7.x1.x5.x8.S LELO_GR01_0.x8.PWRUP_N_1V8 VDPWR VDPWR sky130_fd_pr__pfet_01v8_lvt ad=0.3168 pd=1.62 as=0.5088 ps=2.98 w=0.96 l=0.94
X1372 a_7395_234# digital_0._107_.RESET_B VGND VGND sky130_fd_pr__nfet_01v8 ad=0.0441 pd=0.63 as=0.1346 ps=1.15 w=0.42 l=0.15
X1373 a_7439_654# a_7221_412# VDPWR VDPWR sky130_fd_pr__pfet_01v8_hvt ad=0.12915 pd=1.185 as=0.2184 ps=2.2 w=0.84 l=0.15
X1374 VGND a_4581_2825# a_4512_2954# VGND sky130_fd_pr__nfet_01v8 ad=0.1346 pd=1.15 as=0.0999 ps=0.985 w=0.64 l=0.15
X1375 a_10751_3106# a_10533_3510# VDPWR VDPWR sky130_fd_pr__pfet_01v8_hvt ad=0.12915 pd=1.185 as=0.2184 ps=2.2 w=0.84 l=0.15
X1376 VDPWR digital_0.output12.A a_8361_n676# VDPWR sky130_fd_pr__pfet_01v8_hvt ad=0.19265 pd=1.415 as=0.27 ps=2.54 w=1 l=0.15
X1377 VGND VDPWR VGND VGND sky130_fd_pr__nfet_01v8 ad=0.143 pd=1.62 as=0 ps=0 w=0.55 l=0.59
X1378 VGND VGND LELO_GR01_0.x7.x15.I1 sky130_fd_pr__pnp_05v5_W3p40L3p40
**devattr s=462400,2720
X1379 VGND a_15268_1474# digital_0.load_slew17.A VGND sky130_fd_pr__nfet_01v8 ad=0.1856 pd=1.26 as=0.2079 ps=1.83 w=0.42 l=0.15
X1380 VGND VDPWR VGND VGND sky130_fd_pr__nfet_01v8 ad=0.143 pd=1.62 as=0 ps=0 w=0.55 l=0.59
X1381 a_12451_2588# a_12407_2830# a_12285_2588# VGND sky130_fd_pr__nfet_01v8 ad=0.0441 pd=0.63 as=0.1401 ps=1.1 w=0.42 l=0.15
X1382 VDPWR VGND VDPWR VDPWR sky130_fd_pr__pfet_01v8_hvt ad=0.2262 pd=2.26 as=0 ps=0 w=0.87 l=0.59
X1383 digital_0._108_.RESET_B digital_0._116_.Q VGND VGND sky130_fd_pr__nfet_01v8 ad=0.08775 pd=0.92 as=0.08775 ps=0.92 w=0.65 l=0.15
X1384 a_9417_n702# digital_0._060_.A_N VDPWR VDPWR sky130_fd_pr__pfet_01v8_hvt ad=0.1092 pd=1.36 as=0.07665 ps=0.785 w=0.42 l=0.15
X1385 VDPWR digital_0._113_.Q a_11673_n132# VDPWR sky130_fd_pr__pfet_01v8_hvt ad=0.135 pd=1.27 as=0.275 ps=2.55 w=1 l=0.15
X1386 a_10284_2588# digital_0._069_.A VGND VGND sky130_fd_pr__nfet_01v8 ad=0.06615 pd=0.735 as=0.09862 ps=0.98 w=0.42 l=0.15
X1387 VDPWR a_4609_110# a_4570_n16# VDPWR sky130_fd_pr__pfet_01v8_hvt ad=0.0864 pd=0.91 as=0.1664 ps=1.8 w=0.64 l=0.15
X1388 VGND ui_in<0> sky130_fd_pr__diode_pw2nd_05v5 perim=1.8e+06 area=2.025e+11
X1389 VDPWR digital_0._119_.RESET_B a_4005_n158# VDPWR sky130_fd_pr__pfet_01v8_hvt ad=0.0819 pd=0.81 as=0.0567 ps=0.69 w=0.42 l=0.15
X1390 a_10571_2588# digital_0._067_.A VGND VGND sky130_fd_pr__nfet_01v8 ad=0.1092 pd=1.36 as=0.0567 ps=0.69 w=0.42 l=0.15
X1391 VGND a_4833_3436# digital_0.hold28.A VGND sky130_fd_pr__nfet_01v8 ad=0.169 pd=1.82 as=0.08775 ps=0.92 w=0.65 l=0.15
X1392 VGND a_8996_1500# digital_0.clkbuf_1_1__f_clk.A VGND sky130_fd_pr__nfet_01v8 ad=0.0588 pd=0.7 as=0.0588 ps=0.7 w=0.42 l=0.15
X1393 a_10199_n158# a_9981_246# VDPWR VDPWR sky130_fd_pr__pfet_01v8_hvt ad=0.12915 pd=1.185 as=0.2184 ps=2.2 w=0.84 l=0.15
X1394 a_5159_1474# digital_0.hold28.A VDPWR VDPWR sky130_fd_pr__pfet_01v8_hvt ad=0.1176 pd=1.4 as=0.0693 ps=0.75 w=0.42 l=0.15
X1395 digital_0.output11.A a_10721_172# VDPWR VDPWR sky130_fd_pr__pfet_01v8_hvt ad=0.135 pd=1.27 as=0.3012 ps=2.66 w=1 l=0.15
X1396 a_12094_2588# digital_0._110_.D VGND VGND sky130_fd_pr__nfet_01v8 ad=0.066 pd=0.745 as=0.2205 ps=1.89 w=0.42 l=0.15
X1397 a_11098_3510# a_10017_3138# a_10751_3106# VDPWR sky130_fd_pr__pfet_01v8_hvt ad=0.0588 pd=0.7 as=0.12915 ps=1.185 w=0.42 l=0.15
X1398 digital_0._112_.D digital_0._063_.A VGND VGND sky130_fd_pr__nfet_01v8 ad=0.08775 pd=0.92 as=0.182 ps=1.86 w=0.65 l=0.15
X1399 VDPWR a_9417_n702# a_9151_n702# VDPWR sky130_fd_pr__pfet_01v8_hvt ad=0.07665 pd=0.785 as=0.0609 ps=0.71 w=0.42 l=0.15
X1400 a_4512_2954# a_4386_2856# a_4108_2840# VGND sky130_fd_pr__special_nfet_01v8 ad=0.0999 pd=0.985 as=0.0711 ps=0.755 w=0.36 l=0.15
X1401 VDPWR a_5109_2348# digital_0.output6.A VDPWR sky130_fd_pr__pfet_01v8_hvt ad=0.26 pd=2.52 as=0.135 ps=1.27 w=1 l=0.15
X1402 VDPWR a_4311_3106# a_4201_3132# VDPWR sky130_fd_pr__pfet_01v8_hvt ad=0.07035 pd=0.755 as=0.1155 ps=0.97 w=0.42 l=0.15
X1403 digital_0.clkload0.A a_11388_956# VGND VGND sky130_fd_pr__nfet_01v8 ad=0.0588 pd=0.7 as=0.0588 ps=0.7 w=0.42 l=0.15
X1404 digital_0.clkload0.X a_11673_412# VDPWR VDPWR sky130_fd_pr__pfet_01v8_hvt ad=0.14 pd=1.28 as=0.165 ps=1.33 w=1 l=0.15
X1405 VDPWR a_11388_956# digital_0.clkload0.A VDPWR sky130_fd_pr__pfet_01v8_hvt ad=0.14 pd=1.28 as=0.14 ps=1.28 w=1 l=0.15
X1406 VGND a_5834_2740# digital_0._100_.D VGND sky130_fd_pr__nfet_01v8 ad=0.11285 pd=1.045 as=0.169 ps=1.82 w=0.65 l=0.15
X1407 a_10546_246# a_9465_n126# a_10199_n158# VDPWR sky130_fd_pr__pfet_01v8_hvt ad=0.0588 pd=0.7 as=0.12915 ps=1.185 w=0.42 l=0.15
X1408 VGND digital_0._113_.Q a_12116_188# VGND sky130_fd_pr__nfet_01v8 ad=0.08775 pd=0.92 as=0.169 ps=1.82 w=0.65 l=0.15
X1409 digital_0._115_.Q a_7961_386# VGND VGND sky130_fd_pr__nfet_01v8 ad=0.08775 pd=0.92 as=0.2087 ps=2.02 w=0.65 l=0.15
X1410 VDPWR digital_0.output5.A a_4979_3676# VDPWR sky130_fd_pr__pfet_01v8_hvt ad=0.0567 pd=0.69 as=0.1092 ps=1.36 w=0.42 l=0.15
X1411 digital_0.output6.A a_5109_2348# VGND VGND sky130_fd_pr__nfet_01v8 ad=0.08775 pd=0.92 as=0.2087 ps=2.02 w=0.65 l=0.15
X1412 digital_0._117_.RESET_B digital_0.load_slew15.X VGND VGND sky130_fd_pr__nfet_01v8 ad=0.08775 pd=0.92 as=0.169 ps=1.82 w=0.65 l=0.15
X1413 a_12391_412# a_12225_412# VDPWR VDPWR sky130_fd_pr__pfet_01v8_hvt ad=0.1664 pd=1.8 as=0.0864 ps=0.91 w=0.64 l=0.15
X1414 a_14757_1827# digital_0._112_.Q a_14298_1652# VDPWR sky130_fd_pr__pfet_01v8_hvt ad=0.0441 pd=0.63 as=0.1932 ps=1.34 w=0.42 l=0.15
X1415 uio_out<7> a_8689_n676# VGND VGND sky130_fd_pr__nfet_01v8 ad=0.2079 pd=1.83 as=0.1856 ps=1.26 w=0.42 l=0.15
X1416 a_4571_962# a_4405_962# VDPWR VDPWR sky130_fd_pr__pfet_01v8_hvt ad=0.1664 pd=1.8 as=0.0864 ps=0.91 w=0.64 l=0.15
X1417 digital_0.clkbuf_1_0__f_clk.X a_6315_1474# VGND VGND sky130_fd_pr__nfet_01v8 ad=0.0588 pd=0.7 as=0.1113 ps=1.37 w=0.42 l=0.15
X1418 VGND digital_0._106_.RESET_B a_10243_234# VGND sky130_fd_pr__nfet_01v8 ad=0.1346 pd=1.15 as=0.0441 ps=0.63 w=0.42 l=0.15
X1419 VGND a_11007_n524# digital_0.hold21.X VGND sky130_fd_pr__nfet_01v8 ad=0.097 pd=0.975 as=0.169 ps=1.82 w=0.65 l=0.15
X1420 LELO_GR01_0.x7.x15.I2 LELO_GR01_0.x7.x18.G VDPWR VDPWR sky130_fd_pr__pfet_01v8_lvt ad=0.3168 pd=1.62 as=0.5088 ps=2.98 w=0.96 l=0.94
X1421 a_14026_234# digital_0._105_.D VDPWR VDPWR sky130_fd_pr__pfet_01v8_hvt ad=0.0651 pd=0.73 as=0.1092 ps=1.36 w=0.42 l=0.15
X1422 a_14871_n524# a_14967_n702# VGND VGND sky130_fd_pr__nfet_01v8 ad=0.1092 pd=1.36 as=0.097 ps=0.975 w=0.42 l=0.5
X1423 VGND digital_0._104_.RESET_B a_14935_1322# VGND sky130_fd_pr__nfet_01v8 ad=0.1346 pd=1.15 as=0.0441 ps=0.63 w=0.42 l=0.15
X1424 VGND VDPWR VGND VGND sky130_fd_pr__nfet_01v8 ad=0.143 pd=1.62 as=0 ps=0 w=0.55 l=0.59
X1425 VDPWR digital_0.output12.A a_6451_n676# VDPWR sky130_fd_pr__pfet_01v8_hvt ad=0.0567 pd=0.69 as=0.1092 ps=1.36 w=0.42 l=0.15
X1426 a_7439_654# a_7221_412# VGND VGND sky130_fd_pr__nfet_01v8 ad=0.0999 pd=0.985 as=0.1346 ps=1.15 w=0.64 l=0.15
X1427 digital_0._115_.RESET_B digital_0._116_.Q VGND VGND sky130_fd_pr__nfet_01v8 ad=0.08775 pd=0.92 as=0.182 ps=1.86 w=0.65 l=0.15
X1428 VDPWR a_8085_1500# digital_0.load_slew15.X VDPWR sky130_fd_pr__pfet_01v8_hvt ad=0.26 pd=2.52 as=0.135 ps=1.27 w=1 l=0.15
X1429 VDPWR digital_0.clkload0.A a_11673_412# VDPWR sky130_fd_pr__pfet_01v8_hvt ad=0.165 pd=1.33 as=0.265 ps=2.53 w=1 l=0.15
X1430 VDPWR a_3858_930# a_3618_1194# VDPWR sky130_fd_pr__pfet_01v8_hvt ad=0.19265 pd=1.415 as=0.2173 ps=2.17 w=0.82 l=0.25
X1431 digital_0._101_.RESET_B digital_0.load_slew15.X VGND VGND sky130_fd_pr__nfet_01v8 ad=0.08775 pd=0.92 as=0.169 ps=1.82 w=0.65 l=0.15
X1432 VDPWR LELO_GR01_0.x7.x18.G LELO_GR01_0.x7.x15.I2 VDPWR sky130_fd_pr__pfet_01v8_lvt ad=0.5088 pd=2.98 as=0.3168 ps=1.62 w=0.96 l=0.94
X1433 a_3743_3138# a_3577_3138# VGND VGND sky130_fd_pr__nfet_01v8 ad=0.1092 pd=1.36 as=0.0567 ps=0.69 w=0.42 l=0.15
X1434 a_4746_412# a_4610_386# VDPWR VDPWR sky130_fd_pr__pfet_01v8_hvt ad=0.0567 pd=0.69 as=0.0567 ps=0.69 w=0.42 l=0.15
X1435 VDPWR VGND VDPWR VDPWR sky130_fd_pr__pfet_01v8_hvt ad=0.2262 pd=2.26 as=0 ps=0 w=0.87 l=0.59
X1436 digital_0._115_.RESET_B digital_0.load_slew17.X VGND VGND sky130_fd_pr__nfet_01v8 ad=0.08775 pd=0.92 as=0.08775 ps=0.92 w=0.65 l=0.15
X1437 a_7580_2044# a_6503_2050# a_7418_2422# VDPWR sky130_fd_pr__pfet_01v8_hvt ad=0.0567 pd=0.69 as=0.0588 ps=0.7 w=0.42 l=0.15
X1438 VGND digital_0._113_.RESET_B a_13003_1500# VGND sky130_fd_pr__nfet_01v8 ad=0.1346 pd=1.15 as=0.0441 ps=0.63 w=0.42 l=0.15
X1439 VGND a_14861_172# digital_0.output10.A VGND sky130_fd_pr__nfet_01v8 ad=0.169 pd=1.82 as=0.08775 ps=0.92 w=0.65 l=0.15
X1440 digital_0.clkbuf_1_1__f_clk.A a_8996_1500# VGND VGND sky130_fd_pr__nfet_01v8 ad=0.0588 pd=0.7 as=0.0588 ps=0.7 w=0.42 l=0.15
X1441 a_14594_3510# a_13679_3138# a_14247_3106# VGND sky130_fd_pr__special_nfet_01v8 ad=0.0711 pd=0.755 as=0.0999 ps=0.985 w=0.36 l=0.15
X1442 a_6407_1188# a_6503_930# VGND VGND sky130_fd_pr__nfet_01v8 ad=0.1092 pd=1.36 as=0.097 ps=0.975 w=0.42 l=0.5
X1443 digital_0._112_.RESET_B digital_0._116_.Q VGND VGND sky130_fd_pr__nfet_01v8 ad=0.08775 pd=0.92 as=0.182 ps=1.86 w=0.65 l=0.15
X1444 digital_0.output5.A a_3821_2562# VGND VGND sky130_fd_pr__nfet_01v8 ad=0.08775 pd=0.92 as=0.169 ps=1.82 w=0.65 l=0.15
X1445 VGND VDPWR VGND VGND sky130_fd_pr__nfet_01v8 ad=0.143 pd=1.62 as=0 ps=0 w=0.55 l=0.59
X1446 LELO_GR01_0.x7.x1.x7.D LELO_GR01_0.x7.x1.x7.D VDPWR VDPWR sky130_fd_pr__pfet_01v8_lvt ad=0.3168 pd=1.62 as=0.5088 ps=2.98 w=0.96 l=0.94
X1447 VGND a_8145_2562# digital_0._109_.Q VGND sky130_fd_pr__nfet_01v8 ad=0.169 pd=1.82 as=0.08775 ps=0.92 w=0.65 l=0.15
X1448 uio_out<7> a_8689_n676# VDPWR VDPWR sky130_fd_pr__pfet_01v8_hvt ad=0.495 pd=2.99 as=0.2726 ps=1.61 w=1 l=0.15
X1449 VDPWR digital_0.clkload0.A a_13513_3138# VDPWR sky130_fd_pr__pfet_01v8_hvt ad=0.0864 pd=0.91 as=0.1664 ps=1.8 w=0.64 l=0.15
X1450 a_15634_1474# digital_0.input3.X VGND VGND sky130_fd_pr__nfet_01v8 ad=0.1134 pd=1.38 as=0.1228 ps=1.065 w=0.42 l=0.15
X1451 VGND a_10721_2348# digital_0._111_.Q VGND sky130_fd_pr__nfet_01v8 ad=0.169 pd=1.82 as=0.08775 ps=0.92 w=0.65 l=0.15
X1452 VDPWR a_5974_n676# digital_0._116_.D VDPWR sky130_fd_pr__pfet_01v8_hvt ad=0.265 pd=2.53 as=0.14 ps=1.28 w=1 l=0.15
X1453 VDPWR a_11007_n524# digital_0.hold21.X VDPWR sky130_fd_pr__pfet_01v8_hvt ad=0.14075 pd=1.325 as=0.26 ps=2.52 w=1 l=0.15
X1454 digital_0._115_.D a_7155_930# VGND VGND sky130_fd_pr__nfet_01v8 ad=0.08775 pd=0.92 as=0.169 ps=1.82 w=0.65 l=0.15
X1455 LELO_GR01_0.x7.x25.D LELO_GR01_0.x8.PWRUP_N_1V8 LELO_GR01_0.x7.x25.S VDPWR sky130_fd_pr__pfet_01v8_lvt ad=0.3168 pd=1.62 as=0.5088 ps=2.98 w=0.96 l=0.94
X1456 VGND VDPWR VGND VGND sky130_fd_pr__nfet_01v8 ad=0.143 pd=1.62 as=0 ps=0 w=0.55 l=0.59
X1457 a_11388_956# digital_0.clkbuf_1_1__f_clk.A VDPWR VDPWR sky130_fd_pr__pfet_01v8_hvt ad=0.14 pd=1.28 as=0.14 ps=1.28 w=1 l=0.15
X1458 LELO_GR01_0.x8.x1.x5.IBN LELO_GR01_0.x8.x1.x5.x9<2>.G VGND VGND sky130_fd_pr__nfet_01v8_lvt ad=0.3168 pd=1.62 as=0.5088 ps=2.98 w=0.96 l=0.94
X1459 VGND digital_0.load_slew17.A digital_0._102_.RESET_B VGND sky130_fd_pr__nfet_01v8 ad=0.169 pd=1.82 as=0.08775 ps=0.92 w=0.65 l=0.15
X1460 VDPWR a_10199_2018# a_10089_2044# VDPWR sky130_fd_pr__pfet_01v8_hvt ad=0.07035 pd=0.755 as=0.1155 ps=0.97 w=0.42 l=0.15
X1461 a_4369_2422# a_4019_2050# a_4274_2410# VDPWR sky130_fd_pr__pfet_01v8_hvt ad=0.07245 pd=0.765 as=0.0651 ps=0.73 w=0.42 l=0.15
X1462 a_11758_188# digital_0._063_.A VGND VGND sky130_fd_pr__nfet_01v8 ad=0.08775 pd=0.92 as=0.08775 ps=0.92 w=0.65 l=0.15
X1463 a_3982_386# a_4438_386# a_4396_412# VGND sky130_fd_pr__nfet_01v8 ad=0.0735 pd=0.77 as=0.0441 ps=0.63 w=0.42 l=0.15
X1464 VDPWR VGND VDPWR VDPWR sky130_fd_pr__pfet_01v8_hvt ad=0.2262 pd=2.26 as=0 ps=0 w=0.87 l=0.59
X1465 VDPWR a_4479_n676# a_4585_n676# VDPWR sky130_fd_pr__pfet_01v8_hvt ad=0.14075 pd=1.325 as=0.1092 ps=1.36 w=0.42 l=0.5
X1466 VDPWR VGND VDPWR VDPWR sky130_fd_pr__pfet_01v8_hvt ad=0.2262 pd=2.26 as=0 ps=0 w=0.87 l=0.59
X1467 VDPWR digital_0._116_.Q a_15537_n426# VDPWR sky130_fd_pr__pfet_01v8_hvt ad=0.135 pd=1.27 as=0.28 ps=2.56 w=1 l=0.15
X1468 a_12889_3498# a_12635_3171# VGND VGND sky130_fd_pr__nfet_01v8 ad=0.0693 pd=0.75 as=0.1449 ps=1.11 w=0.42 l=0.15
X1469 VDPWR VGND VDPWR VDPWR sky130_fd_pr__pfet_01v8_hvt ad=0.2262 pd=2.26 as=0 ps=0 w=0.87 l=0.59
X1470 VGND a_7214_n524# digital_0._107_.D VGND sky130_fd_pr__nfet_01v8 ad=0.11285 pd=1.045 as=0.169 ps=1.82 w=0.65 l=0.15
X1471 a_9363_n676# digital_0._060_.B VGND VGND sky130_fd_pr__nfet_01v8 ad=0.0567 pd=0.69 as=0.10187 ps=0.99 w=0.42 l=0.15
X1472 VDPWR a_5661_1260# a_5648_956# VDPWR sky130_fd_pr__pfet_01v8_hvt ad=0.0819 pd=0.81 as=0.0567 ps=0.69 w=0.42 l=0.15
X1473 a_9886_2410# digital_0._111_.D VGND VGND sky130_fd_pr__nfet_01v8 ad=0.066 pd=0.745 as=0.2205 ps=1.89 w=0.42 l=0.15
X1474 LELO_GR01_0.x8.x1.x5.x9<2>.G LELO_GR01_0.x8.x1.x5.x9<2>.G VGND VGND sky130_fd_pr__nfet_01v8_lvt ad=0.3168 pd=1.62 as=0.5088 ps=2.98 w=0.96 l=0.94
X1475 VDPWR a_14175_n702# a_14205_n349# VDPWR sky130_fd_pr__pfet_01v8_hvt ad=0.0693 pd=0.75 as=0.0441 ps=0.63 w=0.42 l=0.15
X1476 VGND clk a_8996_1500# VGND sky130_fd_pr__nfet_01v8 ad=0.0588 pd=0.7 as=0.0588 ps=0.7 w=0.42 l=0.15
X1477 digital_0._108_.D a_6235_3106# VGND VGND sky130_fd_pr__nfet_01v8 ad=0.08775 pd=0.92 as=0.169 ps=1.82 w=0.65 l=0.15
X1478 a_4512_2954# a_4425_2730# a_4108_2840# VDPWR sky130_fd_pr__pfet_01v8_hvt ad=0.12915 pd=1.185 as=0.0588 ps=0.7 w=0.42 l=0.15
X1479 VDPWR VGND VDPWR VDPWR sky130_fd_pr__pfet_01v8_hvt ad=0.2262 pd=2.26 as=0 ps=0 w=0.87 l=0.59
X1480 VDPWR digital_0.load_slew15.X digital_0._107_.RESET_B VDPWR sky130_fd_pr__pfet_01v8_hvt ad=0.26 pd=2.52 as=0.135 ps=1.27 w=1 l=0.15
X1481 VDPWR digital_0._116_.D a_5218_778# VDPWR sky130_fd_pr__pfet_01v8_hvt ad=0.2184 pd=2.2 as=0.12495 ps=1.175 w=0.84 l=0.15
X1482 a_4477_2044# a_3853_2050# a_4369_2422# VDPWR sky130_fd_pr__pfet_01v8_hvt ad=0.1155 pd=0.97 as=0.07245 ps=0.765 w=0.42 l=0.15
X1483 a_8140_412# digital_0._115_.RESET_B VGND VGND sky130_fd_pr__nfet_01v8 ad=0.06405 pd=0.725 as=0.12495 ps=1.015 w=0.42 l=0.15
X1484 LELO_GR01_0.x7.x18.G LELO_GR01_0.x7.x1.x7.D VDPWR VDPWR sky130_fd_pr__pfet_01v8_lvt ad=0.3168 pd=1.62 as=0.5088 ps=2.98 w=0.96 l=0.94
X1485 VGND a_6315_1474# digital_0.clkbuf_1_0__f_clk.X VGND sky130_fd_pr__nfet_01v8 ad=0.05775 pd=0.695 as=0.0588 ps=0.7 w=0.42 l=0.15
X1486 VDPWR a_14891_930# a_14781_956# VDPWR sky130_fd_pr__pfet_01v8_hvt ad=0.07035 pd=0.755 as=0.1155 ps=0.97 w=0.42 l=0.15
X1487 VGND a_14861_172# a_14795_246# VGND sky130_fd_pr__nfet_01v8 ad=0.12495 pd=1.015 as=0.0669 ps=0.75 w=0.42 l=0.15
X1488 digital_0.input2.X a_8689_n132# VGND VGND sky130_fd_pr__nfet_01v8 ad=0.2079 pd=1.83 as=0.1856 ps=1.26 w=0.42 l=0.15
X1489 a_5942_2404# digital_0._109_.Q a_5870_2404# VGND sky130_fd_pr__nfet_01v8 ad=0.05355 pd=0.675 as=0.0441 ps=0.63 w=0.42 l=0.15
X1490 VGND VDPWR VGND VGND sky130_fd_pr__nfet_01v8 ad=0.143 pd=1.62 as=0 ps=0 w=0.55 l=0.59
X1491 VDPWR a_13481_1474# digital_0._113_.Q VDPWR sky130_fd_pr__pfet_01v8_hvt ad=0.26 pd=2.52 as=0.135 ps=1.27 w=1 l=0.15
X1492 digital_0._060_.A_N a_10997_386# VDPWR VDPWR sky130_fd_pr__pfet_01v8_hvt ad=0.165 pd=1.33 as=0.3 ps=2.6 w=1 l=0.15
X1493 VDPWR digital_0.input1.X a_11673_2588# VDPWR sky130_fd_pr__pfet_01v8_hvt ad=0.0864 pd=0.91 as=0.1664 ps=1.8 w=0.64 l=0.15
X1494 a_8837_2838# digital_0._116_.Q VDPWR VDPWR sky130_fd_pr__pfet_01v8_hvt ad=0.28 pd=2.56 as=0.135 ps=1.27 w=1 l=0.15
X1495 a_11478_412# digital_0._069_.A a_11372_412# VGND sky130_fd_pr__nfet_01v8 ad=0.06195 pd=0.715 as=0.0798 ps=0.8 w=0.42 l=0.15
X1496 VDPWR digital_0._067_.A a_10655_2910# VDPWR sky130_fd_pr__pfet_01v8_hvt ad=0.1664 pd=1.8 as=0.0864 ps=0.91 w=0.64 l=0.15
X1497 a_4658_3510# a_3743_3138# a_4311_3106# VGND sky130_fd_pr__special_nfet_01v8 ad=0.0711 pd=0.755 as=0.0999 ps=0.985 w=0.36 l=0.15
X1498 VDPWR a_7214_n524# digital_0._107_.D VDPWR sky130_fd_pr__pfet_01v8_hvt ad=0.15835 pd=1.395 as=0.26 ps=2.52 w=1 l=0.15
X1499 a_11007_n524# a_11103_n702# VGND VGND sky130_fd_pr__nfet_01v8 ad=0.1092 pd=1.36 as=0.097 ps=0.975 w=0.42 l=0.5
X1500 VGND a_8996_1500# digital_0.clkbuf_1_1__f_clk.A VGND sky130_fd_pr__nfet_01v8 ad=0.05775 pd=0.695 as=0.0588 ps=0.7 w=0.42 l=0.15
X1501 digital_0._118_.RESET_B digital_0.load_slew15.X VDPWR VDPWR sky130_fd_pr__pfet_01v8_hvt ad=0.135 pd=1.27 as=0.26 ps=2.52 w=1 l=0.15
X1502 VDPWR a_15685_386# a_15427_386# VDPWR sky130_fd_pr__pfet_01v8_hvt ad=0.0567 pd=0.69 as=0.1092 ps=1.36 w=0.42 l=0.5
X1503 VGND digital_0._115_.Q a_7375_1276# VGND sky130_fd_pr__nfet_01v8 ad=0.08775 pd=0.92 as=0.08775 ps=0.92 w=0.65 l=0.15
X1504 VDPWR digital_0._069_.A a_11397_1750# VDPWR sky130_fd_pr__pfet_01v8_hvt ad=0.135 pd=1.27 as=0.14 ps=1.28 w=1 l=0.15
X1505 a_4826_1322# digital_0._118_.D VDPWR VDPWR sky130_fd_pr__pfet_01v8_hvt ad=0.0651 pd=0.73 as=0.1092 ps=1.36 w=0.42 l=0.15
X1506 a_4479_n676# a_4243_n676# VDPWR VDPWR sky130_fd_pr__pfet_01v8_hvt ad=0.1092 pd=1.36 as=0.0567 ps=0.69 w=0.42 l=0.5
X1507 VGND a_10066_n524# digital_0._106_.D VGND sky130_fd_pr__nfet_01v8 ad=0.11285 pd=1.045 as=0.169 ps=1.82 w=0.65 l=0.15
X1508 a_4369_1474# digital_0.output13.A VDPWR VDPWR sky130_fd_pr__pfet_01v8_hvt ad=0.1092 pd=1.36 as=0.0567 ps=0.69 w=0.42 l=0.15
X1509 a_3717_1528# digital_0.input2.X VGND VGND sky130_fd_pr__nfet_01v8 ad=0.0567 pd=0.69 as=0.1118 ps=1.04 w=0.42 l=0.15
X1510 VDPWR digital_0.clkbuf_1_0__f_clk.X a_3577_3138# VDPWR sky130_fd_pr__pfet_01v8_hvt ad=0.0864 pd=0.91 as=0.1664 ps=1.8 w=0.64 l=0.15
X1511 a_5144_2954# a_4425_2730# a_4581_2825# VGND sky130_fd_pr__special_nfet_01v8 ad=0.066 pd=0.745 as=0.0594 ps=0.69 w=0.36 l=0.15
X1512 VDPWR a_14319_3828# digital_0.hold24.X VDPWR sky130_fd_pr__pfet_01v8_hvt ad=0.14075 pd=1.325 as=0.26 ps=2.52 w=1 l=0.15
X1513 a_5785_1750# digital_0._116_.Q VDPWR VDPWR sky130_fd_pr__pfet_01v8_hvt ad=0.135 pd=1.27 as=0.135 ps=1.27 w=1 l=0.15
X1514 digital_0._063_.A a_11951_2146# VGND VGND sky130_fd_pr__nfet_01v8 ad=0.08775 pd=0.92 as=0.1304 ps=1.105 w=0.65 l=0.15
X1515 a_4587_2018# a_4369_2422# VGND VGND sky130_fd_pr__nfet_01v8 ad=0.0999 pd=0.985 as=0.1346 ps=1.15 w=0.64 l=0.15
X1516 a_12754_2588# a_11673_2588# a_12407_2830# VDPWR sky130_fd_pr__pfet_01v8_hvt ad=0.0588 pd=0.7 as=0.12915 ps=1.185 w=0.42 l=0.15
X1517 digital_0._109_.D digital_0._069_.B a_7181_3926# VDPWR sky130_fd_pr__pfet_01v8_hvt ad=0.135 pd=1.27 as=0.26 ps=2.52 w=1 l=0.15
X1518 a_7623_2830# a_7405_2588# VGND VGND sky130_fd_pr__nfet_01v8 ad=0.0999 pd=0.985 as=0.1346 ps=1.15 w=0.64 l=0.15
X1519 a_14291_3498# a_14247_3106# a_14125_3510# VGND sky130_fd_pr__nfet_01v8 ad=0.0441 pd=0.63 as=0.1401 ps=1.1 w=0.42 l=0.15
X1520 a_12889_3171# digital_0._110_.Q a_12817_3171# VDPWR sky130_fd_pr__pfet_01v8_hvt ad=0.1932 pd=1.34 as=0.0441 ps=0.63 w=0.42 l=0.15
X1521 digital_0.hold28.A a_4833_3436# VDPWR VDPWR sky130_fd_pr__pfet_01v8_hvt ad=0.135 pd=1.27 as=0.3012 ps=2.66 w=1 l=0.15
X1522 VDPWR a_7643_n702# a_7673_n349# VDPWR sky130_fd_pr__pfet_01v8_hvt ad=0.0693 pd=0.75 as=0.0441 ps=0.63 w=0.42 l=0.15
X1523 VDPWR digital_0.load_slew15.X digital_0._117_.RESET_B VDPWR sky130_fd_pr__pfet_01v8_hvt ad=0.26 pd=2.52 as=0.135 ps=1.27 w=1 l=0.15
X1524 VDPWR LELO_GR01_0.x7.x18.G LELO_GR01_0.x7.x15.I2 VDPWR sky130_fd_pr__pfet_01v8_lvt ad=0.5088 pd=2.98 as=0.3168 ps=1.62 w=0.96 l=0.94
X1525 VDPWR digital_0._110_.Q a_11431_2382# VDPWR sky130_fd_pr__pfet_01v8_hvt ad=0.16655 pd=1.39 as=0.0567 ps=0.69 w=0.42 l=0.15
X1526 VDPWR a_11388_956# digital_0.clkload0.A VDPWR sky130_fd_pr__pfet_01v8_hvt ad=0.14 pd=1.28 as=0.14 ps=1.28 w=1 l=0.15
X1527 a_14948_3498# digital_0._102_.RESET_B VGND VGND sky130_fd_pr__nfet_01v8 ad=0.06405 pd=0.725 as=0.12495 ps=1.015 w=0.42 l=0.15
X1528 a_13306_412# a_12391_412# a_12959_654# VGND sky130_fd_pr__special_nfet_01v8 ad=0.0711 pd=0.755 as=0.0999 ps=0.985 w=0.36 l=0.15
X1529 a_14673_1334# a_14157_962# a_14578_1322# VGND sky130_fd_pr__special_nfet_01v8 ad=0.0594 pd=0.69 as=0.066 ps=0.745 w=0.36 l=0.15
X1530 digital_0.clkbuf_1_0__f_clk.X a_6315_1474# VGND VGND sky130_fd_pr__nfet_01v8 ad=0.0588 pd=0.7 as=0.0588 ps=0.7 w=0.42 l=0.15
X1531 VDPWR digital_0.clkload0.A a_9465_n126# VDPWR sky130_fd_pr__pfet_01v8_hvt ad=0.0864 pd=0.91 as=0.1664 ps=1.8 w=0.64 l=0.15
X1532 VDPWR a_10066_n524# digital_0._106_.D VDPWR sky130_fd_pr__pfet_01v8_hvt ad=0.15835 pd=1.395 as=0.26 ps=2.52 w=1 l=0.15
X1533 VGND digital_0.clkbuf_1_1__f_clk.A a_11388_956# VGND sky130_fd_pr__nfet_01v8 ad=0.0588 pd=0.7 as=0.0588 ps=0.7 w=0.42 l=0.15
X1534 VGND digital_0.load_slew15.A digital_0._114_.RESET_B VGND sky130_fd_pr__nfet_01v8 ad=0.169 pd=1.82 as=0.08775 ps=0.92 w=0.65 l=0.15
X1535 a_5189_1827# digital_0._109_.Q a_4730_1652# VDPWR sky130_fd_pr__pfet_01v8_hvt ad=0.0441 pd=0.63 as=0.1932 ps=1.34 w=0.42 l=0.15
X1536 VDPWR VGND VDPWR VDPWR sky130_fd_pr__pfet_01v8_hvt ad=0.2262 pd=2.26 as=0 ps=0 w=0.87 l=0.59
X1537 a_4609_110# digital_0.clkbuf_1_0__f_clk.X VGND VGND sky130_fd_pr__nfet_01v8 ad=0.1092 pd=1.36 as=0.0567 ps=0.69 w=0.42 l=0.15
X1538 digital_0.clkbuf_1_1__f_clk.A a_8996_1500# VGND VGND sky130_fd_pr__nfet_01v8 ad=0.0588 pd=0.7 as=0.0588 ps=0.7 w=0.42 l=0.15
X1539 a_14121_246# a_13605_n126# a_14026_234# VGND sky130_fd_pr__special_nfet_01v8 ad=0.0594 pd=0.69 as=0.066 ps=0.745 w=0.36 l=0.15
X1540 VGND VDPWR VGND VGND sky130_fd_pr__nfet_01v8 ad=0.143 pd=1.62 as=0 ps=0 w=0.55 l=0.59
X1541 VDPWR VGND VDPWR VDPWR sky130_fd_pr__pfet_01v8_hvt ad=0.2262 pd=2.26 as=0 ps=0 w=0.87 l=0.59
X1542 VDPWR digital_0.clkload0.A a_13605_n126# VDPWR sky130_fd_pr__pfet_01v8_hvt ad=0.0864 pd=0.91 as=0.1664 ps=1.8 w=0.64 l=0.15
X1543 VGND VDPWR VGND VGND sky130_fd_pr__nfet_01v8 ad=0.143 pd=1.62 as=0 ps=0 w=0.55 l=0.59
X1544 VGND a_10997_386# digital_0._060_.A_N VGND sky130_fd_pr__nfet_01v8 ad=0.17515 pd=1.265 as=0.10725 ps=0.98 w=0.65 l=0.15
X1545 VDPWR digital_0._100_.RESET_B a_4726_2954# VDPWR sky130_fd_pr__pfet_01v8_hvt ad=0.07035 pd=0.755 as=0.1092 ps=1.36 w=0.42 l=0.15
X1546 VDPWR a_10495_n702# a_10525_n349# VDPWR sky130_fd_pr__pfet_01v8_hvt ad=0.0693 pd=0.75 as=0.0441 ps=0.63 w=0.42 l=0.15
X1547 a_11260_3132# a_10183_3138# a_11098_3510# VDPWR sky130_fd_pr__pfet_01v8_hvt ad=0.0567 pd=0.69 as=0.0588 ps=0.7 w=0.42 l=0.15
X1548 a_3821_2562# a_4108_2840# VDPWR VDPWR sky130_fd_pr__pfet_01v8_hvt ad=0.0567 pd=0.69 as=0.1134 ps=1.38 w=0.42 l=0.15
X1549 a_13513_956# digital_0._063_.B digital_0._112_.D VDPWR sky130_fd_pr__pfet_01v8_hvt ad=0.26 pd=2.52 as=0.135 ps=1.27 w=1 l=0.15
X1550 VDPWR a_5787_2146# digital_0._069_.A VDPWR sky130_fd_pr__pfet_01v8_hvt ad=0.26 pd=2.52 as=0.135 ps=1.27 w=1 l=0.15
X1551 a_6315_1474# digital_0.clkbuf_1_1__f_clk.A VGND VGND sky130_fd_pr__nfet_01v8 ad=0.0588 pd=0.7 as=0.0588 ps=0.7 w=0.42 l=0.15
X1552 a_10997_386# digital_0._069_.A VDPWR VDPWR sky130_fd_pr__pfet_01v8_hvt ad=0.07455 pd=0.775 as=0.0777 ps=0.79 w=0.42 l=0.15
X1553 VDPWR digital_0._063_.A a_12116_n132# VDPWR sky130_fd_pr__pfet_01v8_hvt ad=0.1625 pd=1.325 as=0.135 ps=1.27 w=1 l=0.15
X1554 VGND a_4594_3650# a_4354_3834# VGND sky130_fd_pr__nfet_01v8 ad=0.1228 pd=1.065 as=0.17225 ps=1.83 w=0.65 l=0.25
X1555 a_14125_3510# a_13679_3138# a_14029_3510# VGND sky130_fd_pr__special_nfet_01v8 ad=0.1401 pd=1.1 as=0.0594 ps=0.69 w=0.36 l=0.15
X1556 a_10183_3138# a_10017_3138# VDPWR VDPWR sky130_fd_pr__pfet_01v8_hvt ad=0.1664 pd=1.8 as=0.0864 ps=0.91 w=0.64 l=0.15
X1557 VDPWR a_6761_930# a_6503_930# VDPWR sky130_fd_pr__pfet_01v8_hvt ad=0.0567 pd=0.69 as=0.1092 ps=1.36 w=0.42 l=0.5
X1558 a_10546_2422# a_9631_2050# a_10199_2018# VGND sky130_fd_pr__special_nfet_01v8 ad=0.0711 pd=0.755 as=0.0999 ps=0.985 w=0.36 l=0.15
X1559 VGND a_4833_3436# a_4767_3510# VGND sky130_fd_pr__nfet_01v8 ad=0.12495 pd=1.015 as=0.0669 ps=0.75 w=0.42 l=0.15
X1560 a_11835_3828# a_11931_3650# VDPWR VDPWR sky130_fd_pr__pfet_01v8_hvt ad=0.1092 pd=1.36 as=0.14075 ps=1.325 w=0.42 l=0.5
X1561 VDPWR a_7961_386# a_7948_778# VDPWR sky130_fd_pr__pfet_01v8_hvt ad=0.0819 pd=0.81 as=0.0567 ps=0.69 w=0.42 l=0.15
X1562 digital_0.clkbuf_1_1__f_clk.A a_8996_1500# VDPWR VDPWR sky130_fd_pr__pfet_01v8_hvt ad=0.14 pd=1.28 as=0.1375 ps=1.275 w=1 l=0.15
X1563 a_11388_956# digital_0.clkbuf_1_1__f_clk.A VGND VGND sky130_fd_pr__nfet_01v8 ad=0.0588 pd=0.7 as=0.1113 ps=1.37 w=0.42 l=0.15
X1564 a_4355_3498# a_4311_3106# a_4189_3510# VGND sky130_fd_pr__nfet_01v8 ad=0.0441 pd=0.63 as=0.1401 ps=1.1 w=0.42 l=0.15
X1565 VDPWR digital_0._067_.A a_11949_3132# VDPWR sky130_fd_pr__pfet_01v8_hvt ad=0.135 pd=1.27 as=0.28 ps=2.56 w=1 l=0.15
X1566 a_11772_n702# a_11898_n518# VDPWR VDPWR sky130_fd_pr__pfet_01v8_hvt ad=0.2173 pd=2.17 as=0.2726 ps=1.61 w=0.82 l=0.25
X1567 a_9245_412# a_8895_412# a_9150_412# VDPWR sky130_fd_pr__pfet_01v8_hvt ad=0.07245 pd=0.765 as=0.0651 ps=0.73 w=0.42 l=0.15
X1568 VGND a_6209_386# a_5951_386# VGND sky130_fd_pr__nfet_01v8 ad=0.0567 pd=0.69 as=0.1092 ps=1.36 w=0.42 l=0.5
X1569 VGND a_8996_1500# digital_0.clkbuf_1_1__f_clk.A VGND sky130_fd_pr__nfet_01v8 ad=0.0588 pd=0.7 as=0.0588 ps=0.7 w=0.42 l=0.15
X1570 a_7349_3132# digital_0.output13.A VDPWR VDPWR sky130_fd_pr__pfet_01v8_hvt ad=0.14 pd=1.28 as=0.14 ps=1.28 w=1 l=0.15
X1571 VGND a_6315_1474# digital_0.clkbuf_1_0__f_clk.X VGND sky130_fd_pr__nfet_01v8 ad=0.0588 pd=0.7 as=0.0588 ps=0.7 w=0.42 l=0.15
X1572 digital_0._110_.RESET_B digital_0.load_slew17.A a_12977_2044# VDPWR sky130_fd_pr__pfet_01v8_hvt ad=0.135 pd=1.27 as=0.26 ps=2.52 w=1 l=0.15
X1573 VGND digital_0.clkbuf_1_0__f_clk.X a_3853_2050# VGND sky130_fd_pr__nfet_01v8 ad=0.0567 pd=0.69 as=0.1092 ps=1.36 w=0.42 l=0.15
X1574 a_14175_n702# digital_0.hold28.A VGND VGND sky130_fd_pr__nfet_01v8 ad=0.1092 pd=1.36 as=0.1449 ps=1.11 w=0.42 l=0.15
X1575 VDPWR digital_0._115_.Q a_7826_956# VDPWR sky130_fd_pr__pfet_01v8_hvt ad=0.135 pd=1.27 as=0.135 ps=1.27 w=1 l=0.15
X1576 VGND digital_0._069_.A digital_0._109_.D VGND sky130_fd_pr__nfet_01v8 ad=0.182 pd=1.86 as=0.08775 ps=0.92 w=0.65 l=0.15
X1577 digital_0.clkload0.A a_11388_956# VDPWR VDPWR sky130_fd_pr__pfet_01v8_hvt ad=0.14 pd=1.28 as=0.14 ps=1.28 w=1 l=0.15
X1578 LELO_GR01_0.x7.x1.x5.x9<2>.G LELO_GR01_0.x7.x1.x5.x8.G LELO_GR01_0.x7.x1.x5.x3.S LELO_GR01_0.x7.x1.x5.x3.S sky130_fd_pr__pfet_01v8_lvt ad=0.3168 pd=1.62 as=0.5088 ps=2.98 w=0.96 l=0.94
X1579 a_14217_246# a_13771_n126# a_14121_246# VGND sky130_fd_pr__special_nfet_01v8 ad=0.1401 pd=1.1 as=0.0594 ps=0.69 w=0.36 l=0.15
X1580 VDPWR a_10751_3106# a_10641_3132# VDPWR sky130_fd_pr__pfet_01v8_hvt ad=0.07035 pd=0.755 as=0.1155 ps=0.97 w=0.42 l=0.15
X1581 VDPWR digital_0._108_.Q a_6179_3132# VDPWR sky130_fd_pr__pfet_01v8_hvt ad=0.1625 pd=1.325 as=0.26 ps=2.52 w=1 l=0.15
X1582 a_13771_n126# a_13605_n126# VGND VGND sky130_fd_pr__nfet_01v8 ad=0.1092 pd=1.36 as=0.0567 ps=0.69 w=0.42 l=0.15
X1583 VGND a_3492_930# uio_out<1> VGND sky130_fd_pr__nfet_01v8 ad=0.1856 pd=1.26 as=0.2079 ps=1.83 w=0.42 l=0.15
X1584 a_7970_2588# a_7055_2588# a_7623_2830# VGND sky130_fd_pr__special_nfet_01v8 ad=0.0711 pd=0.755 as=0.0999 ps=0.985 w=0.36 l=0.15
X1585 digital_0._109_.RESET_B digital_0.load_slew15.A VGND VGND sky130_fd_pr__nfet_01v8 ad=0.08775 pd=0.92 as=0.08775 ps=0.92 w=0.65 l=0.15
X1586 a_5215_3676# a_4979_3676# VGND VGND sky130_fd_pr__nfet_01v8 ad=0.1092 pd=1.36 as=0.0567 ps=0.69 w=0.42 l=0.5
X1587 a_5056_n702# a_5182_n518# VDPWR VDPWR sky130_fd_pr__pfet_01v8_hvt ad=0.2173 pd=2.17 as=0.2726 ps=1.61 w=0.82 l=0.25
X1588 a_7126_412# digital_0._115_.D VDPWR VDPWR sky130_fd_pr__pfet_01v8_hvt ad=0.0651 pd=0.73 as=0.1092 ps=1.36 w=0.42 l=0.15
X1589 VDPWR a_13481_386# digital_0._112_.Q VDPWR sky130_fd_pr__pfet_01v8_hvt ad=0.26 pd=2.52 as=0.135 ps=1.27 w=1 l=0.15
X1590 VDPWR VGND VDPWR VDPWR sky130_fd_pr__pfet_01v8_hvt ad=0.2262 pd=2.26 as=0 ps=0 w=0.87 l=0.59
X1591 a_7436_3452# digital_0._108_.Q VGND VGND sky130_fd_pr__nfet_01v8 ad=0.08937 pd=0.925 as=0.18525 ps=1.87 w=0.65 l=0.15
X1592 VGND digital_0.output8.A a_12501_3676# VGND sky130_fd_pr__nfet_01v8 ad=0.1228 pd=1.065 as=0.1134 ps=1.38 w=0.42 l=0.15
X1593 digital_0._110_.Q a_12929_2562# VGND VGND sky130_fd_pr__nfet_01v8 ad=0.08775 pd=0.92 as=0.2087 ps=2.02 w=0.65 l=0.15
X1594 VGND LELO_GR01_0.x7.x1.x5.x9<2>.G LELO_GR01_0.x7.x1.x5.IBN VGND sky130_fd_pr__nfet_01v8_lvt ad=0.5088 pd=2.98 as=0.3168 ps=1.62 w=0.96 l=0.94
X1595 VDPWR LELO_GR01_0.x7.x18.G LELO_GR01_0.x7.x15.I2 VDPWR sky130_fd_pr__pfet_01v8_lvt ad=0.5088 pd=2.98 as=0.3168 ps=1.62 w=0.96 l=0.94
X1596 LELO_GR01_0.x7.x18.G LELO_GR01_0.x7.x18.D LELO_GR01_0.x7.x6<3>.G VGND sky130_fd_pr__nfet_01v8_lvt ad=0.3168 pd=1.62 as=0.5088 ps=2.98 w=0.96 l=0.94
X1597 a_4189_3510# a_3743_3138# a_4093_3510# VGND sky130_fd_pr__special_nfet_01v8 ad=0.1401 pd=1.1 as=0.0594 ps=0.69 w=0.36 l=0.15
X1598 VDPWR a_14769_3436# digital_0.output7.A VDPWR sky130_fd_pr__pfet_01v8_hvt ad=0.26 pd=2.52 as=0.135 ps=1.27 w=1 l=0.15
X1599 a_14026_234# digital_0._105_.D VGND VGND sky130_fd_pr__nfet_01v8 ad=0.066 pd=0.745 as=0.2205 ps=1.89 w=0.42 l=0.15
X1600 VGND a_8578_n676# a_8689_n676# VGND sky130_fd_pr__nfet_01v8 ad=0.1856 pd=1.26 as=0.17225 ps=1.83 w=0.65 l=0.25
X1601 a_7643_n702# digital_0.hold28.A VGND VGND sky130_fd_pr__nfet_01v8 ad=0.1092 pd=1.36 as=0.1449 ps=1.11 w=0.42 l=0.15
X1602 a_13978_3650# digital_0.output7.A VGND VGND sky130_fd_pr__nfet_01v8 ad=0.1134 pd=1.38 as=0.1228 ps=1.065 w=0.42 l=0.15
X1603 VDPWR a_8996_1500# digital_0.clkbuf_1_1__f_clk.A VDPWR sky130_fd_pr__pfet_01v8_hvt ad=0.14 pd=1.28 as=0.14 ps=1.28 w=1 l=0.15
X1604 VGND a_14990_386# a_14750_570# VGND sky130_fd_pr__nfet_01v8 ad=0.1228 pd=1.065 as=0.17225 ps=1.83 w=0.65 l=0.25
X1605 VGND a_6407_1188# digital_0.hold28.X VGND sky130_fd_pr__nfet_01v8 ad=0.097 pd=0.975 as=0.169 ps=1.82 w=0.65 l=0.15
X1606 digital_0._113_.Q a_13481_1474# VDPWR VDPWR sky130_fd_pr__pfet_01v8_hvt ad=0.135 pd=1.27 as=0.3012 ps=2.66 w=1 l=0.15
X1607 VGND a_7593_2348# digital_0._108_.Q VGND sky130_fd_pr__nfet_01v8 ad=0.169 pd=1.82 as=0.08775 ps=0.92 w=0.65 l=0.15
X1608 a_12116_n132# digital_0._063_.A VDPWR VDPWR sky130_fd_pr__pfet_01v8_hvt ad=0.26 pd=2.52 as=0.1625 ps=1.325 w=1 l=0.15
X1609 VDPWR digital_0._113_.Q a_12903_206# VDPWR sky130_fd_pr__pfet_01v8_hvt ad=0.16655 pd=1.39 as=0.0567 ps=0.69 w=0.42 l=0.15
X1610 a_13888_n349# digital_0.hold28.A VDPWR VDPWR sky130_fd_pr__pfet_01v8_hvt ad=0.07665 pd=0.785 as=0.15835 ps=1.395 w=0.42 l=0.15
X1611 VDPWR a_10253_930# digital_0._060_.B VDPWR sky130_fd_pr__pfet_01v8_hvt ad=0.26 pd=2.52 as=0.135 ps=1.27 w=1 l=0.15
X1612 VDPWR VGND VDPWR VDPWR sky130_fd_pr__pfet_01v8_hvt ad=0.2262 pd=2.26 as=0 ps=0 w=0.87 l=0.59
X1613 VDPWR a_3492_930# uio_out<1> VDPWR sky130_fd_pr__pfet_01v8_hvt ad=0.2726 pd=1.61 as=0.495 ps=2.99 w=1 l=0.15
X1614 digital_0.output7.A a_14769_3436# VGND VGND sky130_fd_pr__nfet_01v8 ad=0.08775 pd=0.92 as=0.2087 ps=2.02 w=0.65 l=0.15
X1615 digital_0._102_.D a_12889_3171# VDPWR VDPWR sky130_fd_pr__pfet_01v8_hvt ad=0.26 pd=2.52 as=0.15835 ps=1.395 w=1 l=0.15
X1616 VGND VDPWR VGND VGND sky130_fd_pr__nfet_01v8 ad=0.143 pd=1.62 as=0 ps=0 w=0.55 l=0.59
X1617 LELO_GR01_0.x8.x1.x7.D LELO_GR01_0.x8.IBP_BG LELO_GR01_0.x8.x1.x5.IBN VGND sky130_fd_pr__nfet_01v8_lvt ad=0.3168 pd=1.62 as=0.5088 ps=2.98 w=0.96 l=0.94
X1618 a_13415_1500# a_12225_1500# a_13306_1500# VGND sky130_fd_pr__special_nfet_01v8 ad=0.0669 pd=0.75 as=0.0711 ps=0.755 w=0.36 l=0.15
X1619 VDPWR LELO_GR01_0.x7.x18.G LELO_GR01_0.x8.VREF_BG VDPWR sky130_fd_pr__pfet_01v8_lvt ad=0.5088 pd=2.98 as=0.3168 ps=1.62 w=0.96 l=0.94
X1620 LELO_GR01_0.x7.x23.D LELO_GR01_0.x8.PWRUP_N_1V8 LELO_GR01_0.x7.x22.D VDPWR sky130_fd_pr__pfet_01v8_lvt ad=0.5088 pd=2.98 as=0.3168 ps=1.62 w=0.96 l=0.94
X1621 VGND a_4765_n158# a_4696_n132# VGND sky130_fd_pr__nfet_01v8 ad=0.1346 pd=1.15 as=0.0999 ps=0.985 w=0.64 l=0.15
X1622 a_12741_412# a_12391_412# a_12646_412# VDPWR sky130_fd_pr__pfet_01v8_hvt ad=0.07245 pd=0.765 as=0.0651 ps=0.73 w=0.42 l=0.15
X1623 VDPWR digital_0.input1.X a_12225_412# VDPWR sky130_fd_pr__pfet_01v8_hvt ad=0.0864 pd=0.91 as=0.1664 ps=1.8 w=0.64 l=0.15
X1624 a_14624_386# a_14750_570# VDPWR VDPWR sky130_fd_pr__pfet_01v8_hvt ad=0.2173 pd=2.17 as=0.2726 ps=1.61 w=0.82 l=0.25
X1625 a_12626_n676# a_12409_n676# VGND VGND sky130_fd_pr__nfet_01v8 ad=0.17225 pd=1.83 as=0.1228 ps=1.065 w=0.65 l=0.25
X1626 LELO_GR01_0.x7.x1.x5.x9<2>.G LELO_GR01_0.x7.x1.x5.x8.G LELO_GR01_0.x7.x1.x5.x8.G VGND sky130_fd_pr__nfet_01v8_lvt ad=0.5088 pd=2.98 as=0.3168 ps=1.62 w=0.96 l=0.94
X1627 a_5661_1260# digital_0._118_.RESET_B VDPWR VDPWR sky130_fd_pr__pfet_01v8_hvt ad=0.0567 pd=0.69 as=0.0819 ps=0.81 w=0.42 l=0.15
X1628 a_9972_778# a_8895_412# a_9810_412# VDPWR sky130_fd_pr__pfet_01v8_hvt ad=0.0567 pd=0.69 as=0.0588 ps=0.7 w=0.42 l=0.15
X1629 VDPWR digital_0.clkbuf_1_0__f_clk.X a_4405_962# VDPWR sky130_fd_pr__pfet_01v8_hvt ad=0.0864 pd=0.91 as=0.1664 ps=1.8 w=0.64 l=0.15
X1630 a_4477_2044# digital_0._101_.RESET_B VDPWR VDPWR sky130_fd_pr__pfet_01v8_hvt ad=0.1092 pd=1.36 as=0.07035 ps=0.755 w=0.42 l=0.15
X1631 a_12916_2954# a_11839_2588# a_12754_2588# VDPWR sky130_fd_pr__pfet_01v8_hvt ad=0.0567 pd=0.69 as=0.0588 ps=0.7 w=0.42 l=0.15
X1632 VDPWR a_14298_1652# digital_0._104_.D VDPWR sky130_fd_pr__pfet_01v8_hvt ad=0.15835 pd=1.395 as=0.26 ps=2.52 w=1 l=0.15
X1633 VDPWR VGND VDPWR VDPWR sky130_fd_pr__pfet_01v8_hvt ad=0.2262 pd=2.26 as=0 ps=0 w=0.87 l=0.59
X1634 a_10495_n702# digital_0.hold28.A VGND VGND sky130_fd_pr__nfet_01v8 ad=0.1092 pd=1.36 as=0.1449 ps=1.11 w=0.42 l=0.15
X1635 VGND a_8085_1500# digital_0.load_slew15.X VGND sky130_fd_pr__nfet_01v8 ad=0.08775 pd=0.92 as=0.08775 ps=0.92 w=0.65 l=0.15
X1636 VDPWR a_12718_3676# a_12829_3676# VDPWR sky130_fd_pr__pfet_01v8_hvt ad=0.2726 pd=1.61 as=0.2173 ps=2.17 w=0.82 l=0.25
X1637 VDPWR a_14339_n158# a_14229_n132# VDPWR sky130_fd_pr__pfet_01v8_hvt ad=0.07035 pd=0.755 as=0.1155 ps=0.97 w=0.42 l=0.15
X1638 digital_0.output9.A a_15413_1260# VGND VGND sky130_fd_pr__nfet_01v8 ad=0.08775 pd=0.92 as=0.2087 ps=2.02 w=0.65 l=0.15
X1639 VGND a_11388_956# digital_0.clkload0.A VGND sky130_fd_pr__nfet_01v8 ad=0.1113 pd=1.37 as=0.0588 ps=0.7 w=0.42 l=0.15
X1640 a_14440_1500# digital_0.hold28.A VGND VGND sky130_fd_pr__nfet_01v8 ad=0.0693 pd=0.75 as=0.11285 ps=1.045 w=0.42 l=0.15
X1641 a_12138_n702# digital_0.output10.A VGND VGND sky130_fd_pr__nfet_01v8 ad=0.1134 pd=1.38 as=0.1228 ps=1.065 w=0.42 l=0.15
X1642 a_6179_3132# digital_0._108_.Q VDPWR VDPWR sky130_fd_pr__pfet_01v8_hvt ad=0.135 pd=1.27 as=0.1625 ps=1.325 w=1 l=0.15
X1643 VGND VDPWR VGND VGND sky130_fd_pr__nfet_01v8 ad=0.143 pd=1.62 as=0 ps=0 w=0.55 l=0.59
X1644 VDPWR digital_0.input2.X digital_0._080_.A2 VDPWR sky130_fd_pr__pfet_01v8_hvt ad=0.26 pd=2.52 as=0.135 ps=1.27 w=1 l=0.15
X1645 a_4425_2730# digital_0.clkbuf_1_0__f_clk.X VGND VGND sky130_fd_pr__nfet_01v8 ad=0.1092 pd=1.36 as=0.0567 ps=0.69 w=0.42 l=0.15
X1646 VGND a_4730_1652# digital_0._101_.D VGND sky130_fd_pr__nfet_01v8 ad=0.11285 pd=1.045 as=0.169 ps=1.82 w=0.65 l=0.15
X1647 digital_0.clkbuf_1_1__f_clk.A a_8996_1500# VDPWR VDPWR sky130_fd_pr__pfet_01v8_hvt ad=0.14 pd=1.28 as=0.14 ps=1.28 w=1 l=0.15
X1648 LELO_GR01_0.x8.x1.x5.IBN LELO_GR01_0.x8.x1.x5.x9<2>.G VGND VGND sky130_fd_pr__nfet_01v8_lvt ad=0.3168 pd=1.62 as=0.5088 ps=2.98 w=0.96 l=0.94
X1649 a_3492_n702# a_3618_n518# VDPWR VDPWR sky130_fd_pr__pfet_01v8_hvt ad=0.2173 pd=2.17 as=0.2726 ps=1.61 w=0.82 l=0.25
X1650 VDPWR digital_0.output13.A a_5787_2146# VDPWR sky130_fd_pr__pfet_01v8_hvt ad=0.0567 pd=0.69 as=0.1092 ps=1.36 w=0.42 l=0.15
X1651 a_13660_1500# digital_0._113_.RESET_B VGND VGND sky130_fd_pr__nfet_01v8 ad=0.06405 pd=0.725 as=0.12495 ps=1.015 w=0.42 l=0.15
X1652 a_3814_386# a_3982_386# VDPWR VDPWR sky130_fd_pr__pfet_01v8_hvt ad=0.26 pd=2.52 as=0.135 ps=1.27 w=1 l=0.15
X1653 a_7527_2422# a_6337_2050# a_7418_2422# VGND sky130_fd_pr__special_nfet_01v8 ad=0.0669 pd=0.75 as=0.0711 ps=0.755 w=0.36 l=0.15
X1654 a_14323_962# a_14157_962# VGND VGND sky130_fd_pr__nfet_01v8 ad=0.1092 pd=1.36 as=0.0567 ps=0.69 w=0.42 l=0.15
X1655 a_3858_930# digital_0.output6.A VGND VGND sky130_fd_pr__nfet_01v8 ad=0.1134 pd=1.38 as=0.1228 ps=1.065 w=0.42 l=0.15
X1656 a_14029_3510# a_13679_3138# a_13934_3498# VDPWR sky130_fd_pr__pfet_01v8_hvt ad=0.07245 pd=0.765 as=0.0651 ps=0.73 w=0.42 l=0.15
X1657 a_15662_2044# a_15445_2044# VGND VGND sky130_fd_pr__nfet_01v8 ad=0.17225 pd=1.83 as=0.1228 ps=1.065 w=0.65 l=0.25
X1658 VGND digital_0._116_.Q digital_0._114_.RESET_B VGND sky130_fd_pr__nfet_01v8 ad=0.08775 pd=0.92 as=0.08775 ps=0.92 w=0.65 l=0.15
X1659 VGND a_6315_1474# digital_0.clkbuf_1_0__f_clk.X VGND sky130_fd_pr__nfet_01v8 ad=0.0588 pd=0.7 as=0.0588 ps=0.7 w=0.42 l=0.15
X1660 LELO_GR01_0.x7.x18.D LELO_GR01_0.x7.x18.G VGND VGND sky130_fd_pr__nfet_01v8_lvt ad=0.3168 pd=1.62 as=0.5088 ps=2.98 w=0.96 l=0.94
X1661 a_12138_n702# digital_0.output10.A VDPWR VDPWR sky130_fd_pr__pfet_01v8_hvt ad=0.27 pd=2.54 as=0.19265 ps=1.415 w=1 l=0.15
X1662 a_10077_2422# a_9631_2050# a_9981_2422# VGND sky130_fd_pr__special_nfet_01v8 ad=0.1401 pd=1.1 as=0.0594 ps=0.69 w=0.36 l=0.15
X1663 digital_0.clkload0.A a_11388_956# VGND VGND sky130_fd_pr__nfet_01v8 ad=0.0588 pd=0.7 as=0.0588 ps=0.7 w=0.42 l=0.15
X1664 LELO_GR01_0.x7.x1.x5.IBN LELO_GR01_0.x7.x7.G LELO_GR01_0.x7.x1.x7.D VGND sky130_fd_pr__nfet_01v8_lvt ad=0.5088 pd=2.98 as=0.3168 ps=1.62 w=0.96 l=0.94
X1665 VGND digital_0._101_.RESET_B a_4631_2410# VGND sky130_fd_pr__nfet_01v8 ad=0.1346 pd=1.15 as=0.0441 ps=0.63 w=0.42 l=0.15
X1666 a_5109_2348# a_4934_2422# a_5288_2410# VGND sky130_fd_pr__nfet_01v8 ad=0.1092 pd=1.36 as=0.06405 ps=0.725 w=0.42 l=0.15
X1667 a_10074_2562# a_10285_2910# VDPWR VDPWR sky130_fd_pr__pfet_01v8_hvt ad=0.0928 pd=0.93 as=0.2272 ps=1.35 w=0.64 l=0.15
X1668 VGND digital_0._113_.Q a_12989_206# VGND sky130_fd_pr__nfet_01v8 ad=0.1118 pd=1.04 as=0.0567 ps=0.69 w=0.42 l=0.15
X1669 LELO_GR01_0.x7.x19.D LELO_GR01_0.x8.PWRUP_N_1V8 LELO_GR01_0.x7.x18.D VDPWR sky130_fd_pr__pfet_01v8_lvt ad=0.5088 pd=2.98 as=0.3168 ps=1.62 w=0.96 l=0.94
X1670 VGND a_8996_1500# digital_0.clkbuf_1_1__f_clk.A VGND sky130_fd_pr__nfet_01v8 ad=0.0588 pd=0.7 as=0.0588 ps=0.7 w=0.42 l=0.15
X1671 VDPWR digital_0._065_.A2_N a_11397_1750# VDPWR sky130_fd_pr__pfet_01v8_hvt ad=0.14 pd=1.28 as=0.28 ps=2.56 w=1 l=0.15
X1672 VGND VDPWR VGND VGND sky130_fd_pr__nfet_01v8 ad=0.143 pd=1.62 as=0 ps=0 w=0.55 l=0.59
X1673 a_5648_956# a_4571_962# a_5486_1334# VDPWR sky130_fd_pr__pfet_01v8_hvt ad=0.0567 pd=0.69 as=0.0588 ps=0.7 w=0.42 l=0.15
X1674 a_14137_3132# a_13513_3138# a_14029_3510# VDPWR sky130_fd_pr__pfet_01v8_hvt ad=0.1155 pd=0.97 as=0.07245 ps=0.765 w=0.42 l=0.15
X1675 a_14383_234# a_14339_n158# a_14217_246# VGND sky130_fd_pr__nfet_01v8 ad=0.0441 pd=0.63 as=0.1401 ps=1.1 w=0.42 l=0.15
X1676 LELO_GR01_0.x7.x18.G LELO_GR01_0.x7.x18.D LELO_GR01_0.x7.x6<3>.G VGND sky130_fd_pr__nfet_01v8_lvt ad=0.3168 pd=1.62 as=0.5088 ps=2.98 w=0.96 l=0.94
X1677 VGND a_12189_3650# a_11931_3650# VGND sky130_fd_pr__nfet_01v8 ad=0.0567 pd=0.69 as=0.1092 ps=1.36 w=0.42 l=0.5
X1678 digital_0._057_.D a_12903_206# VDPWR VDPWR sky130_fd_pr__pfet_01v8_hvt ad=0.195 pd=1.39 as=0.16655 ps=1.39 w=1 l=0.15
X1679 a_3492_930# a_3618_1194# VDPWR VDPWR sky130_fd_pr__pfet_01v8_hvt ad=0.2173 pd=2.17 as=0.2726 ps=1.61 w=0.82 l=0.25
X1680 VDPWR digital_0._113_.Q a_12116_n132# VDPWR sky130_fd_pr__pfet_01v8_hvt ad=0.135 pd=1.27 as=0.26 ps=2.52 w=1 l=0.15
X1681 digital_0._109_.Q a_8145_2562# VDPWR VDPWR sky130_fd_pr__pfet_01v8_hvt ad=0.135 pd=1.27 as=0.3012 ps=2.66 w=1 l=0.15
X1682 VGND digital_0.input3.X digital_0._113_.RESET_B VGND sky130_fd_pr__nfet_01v8 ad=0.169 pd=1.82 as=0.08775 ps=0.92 w=0.65 l=0.15
C0 digital_0.input2.X digital_0.hold28.X 0.04255f
C1 a_12391_1500# a_11388_956# 0.01142f
C2 digital_0.load_slew17.X a_14578_1322# 0.0127f
C3 digital_0.hold28.A digital_0.hold21.X 0.2375f
C4 a_4594_3650# VDPWR 0.25542f
C5 a_3618_3834# uo_out<1> 0.04771f
C6 digital_0._119_.RESET_B VDPWR 0.41285f
C7 a_4005_n158# ui_in<0> 0.01004f
C8 digital_0.output12.A a_7643_n702# 0.05081f
C9 digital_0.output11.A a_11361_n702# 0.30019f
C10 digital_0._100_.RESET_B a_4833_3436# 0.02119f
C11 digital_0._117_.RESET_B a_4093_3510# 0.15327f
C12 digital_0.load_slew17.A a_12889_3171# 0.02246f
C13 a_4578_18940# VDPWR 0.02654f
C14 digital_0.hold28.A a_5785_1750# 0.0425f
C15 digital_0.clkload0.A digital_0._063_.A 0.57774f
C16 digital_0.input1.X a_11839_2588# 0.03384f
C17 a_2478_11860# VDPWR 0.36633f
C18 digital_0.hold22.X a_5159_1474# 0.03965f
C19 digital_0._116_.Q a_15537_n132# 0.10988f
C20 a_6889_2588# clk 0.04809f
C21 a_11107_2562# VDPWR 0.24913f
C22 digital_0._063_.A a_12116_188# 0.03973f
C23 digital_0.load_slew17.X digital_0.output11.A 0.13483f
C24 LELO_GR01_0.x7.x18.D a_4578_10200# 0.02079f
C25 a_2478_14990# a_2478_14480# 0.02417f
C26 a_4438_386# ui_in<0> 0.05995f
C27 a_4746_412# VDPWR 0.2464f
C28 a_10721_172# digital_0.output11.A 0.10199f
C29 digital_0.output4.A digital_0.load_slew15.X 0.06758f
C30 li_25094_17304# uo_out<0> 0.15198f
C31 li_19474_13804# uio_out<4> 0.05576f
C32 li_16454_13804# uio_out<1> 0.04763f
C33 m1_7720_5850# ui_in<0> 0.03674f
C34 li_16034_17304# uio_out<5> 0.06846f
C35 li_20574_17304# uio_out<7> 0.11272f
C36 a_11273_3436# a_11673_2588# 0.01052f
C37 digital_0.hold28.A a_5109_2348# 0.02428f
C38 digital_0.output6.A a_4015_1652# 0.01227f
C39 LELO_GR01_0.x7.x18.G clk 0.22346f
C40 a_6636_17810# VDPWR 0.40448f
C41 digital_0.load_slew15.X a_4609_110# 0.64569f
C42 LELO_GR01_0.PWRUP_1V8 ui_in<1> 0.20266f
C43 a_13679_3138# VDPWR 0.25956f
C44 a_17668_18750# LELO_GR01_0.x8.IBP_BG 0.03792f
C45 digital_0.hold23.X VDPWR 0.69749f
C46 a_14750_570# a_13605_n126# 0.0107f
C47 digital_0._116_.D a_5056_n702# 0.01954f
C48 a_4570_n16# a_4696_n132# 0.17589f
C49 a_20156_7909# a_19706_7559# 0.01328f
C50 LELO_GR01_0.x8.x1.x5.x9<2>.G a_19706_6759# 0.09093f
C51 LELO_GR01_0.x8.x1.x5.IBN LELO_GR01_0.x8.x1.x7.D 0.773f
C52 a_3492_n702# VDPWR 0.23185f
C53 digital_0.output13.A a_7349_3132# 0.02555f
C54 digital_0._109_.Q a_6906_3132# 0.16825f
C55 digital_0._102_.RESET_B a_14594_3510# 0.23803f
C56 digital_0._116_.Q digital_0._065_.A2_N 0.41011f
C57 digital_0._069_.A a_10285_2910# 0.07268f
C58 digital_0.clkload0.A digital_0._060_.A_N 0.44309f
C59 digital_0._101_.D a_4019_2050# 0.56437f
C60 digital_0.load_slew15.X digital_0._116_.D 0.12639f
C61 a_3853_2050# a_4587_2018# 0.06225f
C62 a_4354_3834# VDPWR 0.22681f
C63 digital_0._113_.D a_11388_956# 0.03541f
C64 a_3492_3650# uo_out<1> 0.02405f
C65 a_4292_0# VDPWR 0.29105f
C66 a_4243_n676# a_4479_n676# 0.22264f
C67 digital_0.output11.A a_11103_n702# 0.01211f
C68 digital_0.output12.A digital_0.hold26.X 0.30982f
C69 digital_0._117_.RESET_B a_4311_3106# 0.16612f
C70 digital_0.output8.A a_11273_3436# 0.10334f
C71 digital_0.load_slew17.A digital_0._110_.Q 0.14159f
C72 a_11931_3650# digital_0._067_.A 0.01288f
C73 LELO_GR01_0.x7.x1.x5.x3.S ui_in<0> 0.13388f
C74 LELO_GR01_0.x8.x1.x5.x3.S VDPWR 0.04564f
C75 uo_out<3> uo_out<4> 0.04002f
C76 digital_0.input1.X a_11673_2588# 0.58278f
C77 digital_0.output13.A digital_0.load_slew17.X 0.23645f
C78 a_10285_2910# VDPWR 0.13534f
C79 digital_0._114_.RESET_B a_9810_412# 0.21442f
C80 digital_0.input1.X clk 0.06462f
C81 digital_0._116_.D a_5218_778# 0.15108f
C82 LELO_GR01_0.x7.x18.G a_14358_10600# 0.07768f
C83 a_4530_626# ui_in<0> 0.0269f
C84 a_4610_386# VDPWR 0.26764f
C85 a_4979_3676# a_5215_3676# 0.22264f
C86 li_20574_17304# uo_out<0> 0.11068f
C87 li_19474_13804# uio_out<2> 0.04858f
C88 a_16018_18750# VDPWR 0.43757f
C89 LELO_GR01_0.x7.x18.D clk 0.05353f
C90 digital_0.load_slew15.X digital_0._119_.RESET_B 0.37097f
C91 a_11431_2382# digital_0._112_.Q 0.02786f
C92 LELO_GR01_0.x8.PWRUP_N_1V8 uio_out<1> 0.13793f
C93 digital_0._080_.A2 digital_0.hold28.X 0.10369f
C94 digital_0._102_.D VDPWR 0.43291f
C95 a_10253_930# a_10723_1276# 0.01408f
C96 LELO_GR01_0.x8.VREF_BG a_17668_17950# 0.02696f
C97 LELO_GR01_0.x7.x6<3>.G a_4578_16120# 0.06124f
C98 LELO_GR01_0.x8.PWRUP_N_1V8 LELO_GR01_0.x7.x1.x5.x9<2>.G 1.24064f
C99 digital_0._104_.D VDPWR 0.42293f
C100 a_4570_n16# a_4765_n158# 0.21963f
C101 a_4609_110# a_4696_n132# 0.05348f
C102 LELO_GR01_0.x8.x1.x5.x9<2>.G a_19706_7559# 0.0452f
C103 a_15537_n132# VDPWR 0.42922f
C104 digital_0.output11.A uio_out<6> 0.05469f
C105 a_10183_3138# a_10438_3498# 0.06418f
C106 digital_0._108_.Q a_7349_3132# 0.19481f
C107 digital_0.output13.A a_6906_3132# 0.03096f
C108 digital_0._109_.Q a_6179_3132# 0.12604f
C109 digital_0._102_.RESET_B a_14769_3436# 0.28095f
C110 a_14247_3106# a_14594_3510# 0.05116f
C111 digital_0._069_.A digital_0._065_.A2_N 1.54719f
C112 a_3853_2050# a_4019_2050# 0.72353f
C113 a_4228_3650# VDPWR 0.21567f
C114 a_12225_1500# a_11388_956# 0.0151f
C115 digital_0._113_.D digital_0._114_.Q 0.1414f
C116 digital_0._063_.A digital_0._112_.D 0.06733f
C117 a_3492_3650# uio_out<0> 0.09528f
C118 digital_0.load_slew17.X a_15537_n426# 0.09045f
C119 a_11673_412# digital_0.clkload0.X 0.3277f
C120 a_4005_n158# VDPWR 0.40313f
C121 digital_0._117_.RESET_B a_3743_3138# 0.02691f
C122 digital_0._111_.Q a_11415_3650# 0.10192f
C123 LELO_GR01_0.x7.x1.x5.x8.S ui_in<0> 0.09193f
C124 LELO_GR01_0.x8.x1.x5.x8.S VDPWR 1.36304f
C125 digital_0._069_.A digital_0._113_.Q 0.44561f
C126 digital_0.clkbuf_1_0__f_clk.X a_6315_1474# 1.62377f
C127 digital_0.output9.A digital_0.input3.X 0.28586f
C128 a_15445_2044# a_15634_1474# 0.01067f
C129 digital_0._104_.RESET_B digital_0._113_.RESET_B 0.02895f
C130 digital_0.hold28.A digital_0.output12.A 0.37337f
C131 a_11988_13420# VDPWR 0.43667f
C132 digital_0._116_.Q digital_0.output10.A 0.15667f
C133 digital_0._065_.A2_N VDPWR 0.98649f
C134 digital_0._114_.RESET_B a_9985_386# 0.26934f
C135 LELO_GR01_0.x8.PWRUP_N_1V8 a_2478_9750# 0.07785f
C136 LELO_GR01_0.x7.x18.G a_14358_10740# 0.07768f
C137 a_4438_386# VDPWR 0.58152f
C138 digital_0._106_.RESET_B digital_0.output11.A 0.05555f
C139 a_9981_246# a_10089_n132# 0.05722f
C140 a_4609_110# a_4479_n676# 0.01346f
C141 a_3814_386# uo_out<1> 0.0101f
C142 a_4118_412# ui_in<0> 0.01252f
C143 li_19474_13804# uio_out<3> 0.02629f
C144 li_20574_17304# uio_out<1> 0.05511f
C145 li_28516_19376# uio_out<7> 0.02105f
C146 digital_0.clkload0.A digital_0._110_.RESET_B 0.06392f
C147 a_12688_18180# VDPWR 0.42653f
C148 LELO_GR01_0.x8.PWRUP_N_1V8 clk 0.67625f
C149 digital_0.load_slew15.X a_4292_0# 0.0571f
C150 digital_0._080_.A2 a_5029_956# 0.02662f
C151 digital_0._104_.RESET_B a_14990_386# 0.01226f
C152 a_13513_3138# VDPWR 0.4604f
C153 digital_0._114_.Q digital_0._060_.B 0.34891f
C154 LELO_GR01_0.x8.VREF_BG LELO_GR01_0.x8.IBP_BG 1.82357f
C155 digital_0._113_.Q VDPWR 1.06118f
C156 a_13481_386# digital_0._105_.D 0.0117f
C157 digital_0._119_.RESET_B a_4696_n132# 0.16487f
C158 a_4609_110# a_4765_n158# 0.10599f
C159 LELO_GR01_0.x8.x1.x5.IBN a_21554_7825# 0.03033f
C160 digital_0.output11.A uio_out<5> 0.16995f
C161 digital_0._102_.RESET_B a_14029_3510# 0.16585f
C162 digital_0.hold28.A a_14137_3132# 0.02687f
C163 digital_0._108_.Q a_6906_3132# 0.025f
C164 digital_0.output13.A a_6179_3132# 0.03156f
C165 a_6235_3106# a_7349_3132# 0.01166f
C166 digital_0.hold25.X digital_0._100_.D 0.05078f
C167 digital_0._100_.RESET_B a_4512_2954# 0.17454f
C168 a_13679_3138# a_14594_3510# 0.11876f
C169 a_10017_3138# a_10438_3498# 0.08968f
C170 digital_0._069_.A a_10074_2562# 0.1628f
C171 digital_0.load_slew15.A a_8145_2562# 0.01629f
C172 a_3853_2050# digital_0._101_.D 0.45211f
C173 digital_0.output5.A VDPWR 0.85999f
C174 digital_0._116_.D a_4765_n158# 0.01864f
C175 a_3858_n702# a_4243_n676# 0.0425f
C176 digital_0._100_.RESET_B a_3743_3138# 0.02208f
C177 digital_0.hold20.X a_11415_3650# 0.22687f
C178 LELO_GR01_0.x7.x1.x5.x8.S rst_n 0.20083f
C179 LELO_GR01_0.x7.x1.x5.x3.S VDPWR 0.086f
C180 uo_out<2> uo_out<3> 0.04002f
C181 digital_0.hold28.A a_5159_1474# 0.23278f
C182 digital_0.clkbuf_1_0__f_clk.X a_4730_1652# 0.05431f
C183 a_6315_1474# digital_0._115_.RESET_B 0.1198f
C184 digital_0.input1.X a_7786_412# 0.05798f
C185 digital_0.output9.A a_15634_1474# 0.01758f
C186 digital_0.load_slew17.X digital_0._113_.RESET_B 0.02542f
C187 digital_0.output4.A a_4243_n676# 0.29967f
C188 digital_0.input2.X digital_0.hold22.X 0.05323f
C189 a_4610_386# a_5218_778# 0.03558f
C190 a_10074_2562# VDPWR 0.32965f
C191 digital_0._114_.RESET_B a_9245_412# 0.16228f
C192 digital_0._060_.B digital_0._114_.D 0.03251f
C193 digital_0._113_.D a_12903_206# 0.01671f
C194 LELO_GR01_0.x7.x1.x5.x9<2>.G a_9738_14010# 0.07064f
C195 LELO_GR01_0.x7.x18.G a_14358_11540# 0.07768f
C196 a_4530_626# VDPWR 0.28066f
C197 digital_0._106_.RESET_B a_10089_n132# 0.0122f
C198 digital_0._116_.SET_B ui_in<0> 0.03283f
C199 li_28516_19376# uo_out<0> 0.02633f
C200 li_16454_13804# uio_out<2> 0.05345f
C201 li_16034_17304# uio_out<1> 0.02206f
C202 li_27050_5051# VDPWR 0.07653f
C203 digital_0._108_.D digital_0.input1.X 0.13216f
C204 digital_0._069_.A a_6758_2410# 0.02907f
C205 digital_0.load_slew15.X a_4005_n158# 0.08554f
C206 LELO_GR01_0.PWRUP_1V8 VDPWR 12.2398f
C207 LELO_GR01_0.x7.x19.D clk 0.08461f
C208 LELO_GR01_0.x8.PWRUP_N_1V8 uio_out<4> 0.03306f
C209 a_12889_3171# VDPWR 0.09188f
C210 a_10253_930# digital_0._060_.B 0.14334f
C211 a_4609_110# a_4570_n16# 0.57903f
C212 digital_0._119_.RESET_B a_4765_n158# 0.15235f
C213 a_4292_0# a_4696_n132# 0.05116f
C214 LELO_GR01_0.x8.x1.x5.x8.G a_19706_6759# 0.08395f
C215 digital_0.output10.A VDPWR 0.66275f
C216 digital_0.hold26.X a_7643_n702# 0.04056f
C217 a_14247_3106# a_14029_3510# 0.20964f
C218 digital_0._108_.Q a_6179_3132# 0.03666f
C219 a_6235_3106# a_6906_3132# 0.142f
C220 digital_0._100_.RESET_B a_4581_2825# 0.16654f
C221 a_13679_3138# a_14769_3436# 0.04251f
C222 digital_0._069_.A a_7970_2588# 0.08736f
C223 digital_0.load_slew15.X a_4438_386# 0.04021f
C224 digital_0._111_.RESET_B a_10546_2422# 0.23459f
C225 digital_0.input1.X a_11951_2146# 0.05464f
C226 digital_0._116_.Q digital_0._116_.SET_B 0.04016f
C227 a_3858_3650# VDPWR 0.2492f
C228 a_6758_2410# VDPWR 0.08569f
C229 digital_0._116_.D a_4570_n16# 0.04133f
C230 digital_0.rst uio_out<6> 0.02183f
C231 digital_0.hold28.A a_11415_3650# 0.23122f
C232 digital_0.hold20.X digital_0._111_.Q 0.33141f
C233 digital_0._117_.RESET_B a_3577_3138# 0.29634f
C234 digital_0._069_.A digital_0._110_.Q 0.84039f
C235 digital_0.output5.A a_3998_3498# 0.01496f
C236 LELO_GR01_0.x7.x1.x5.x8.S VDPWR 1.96864f
C237 digital_0.clkbuf_1_0__f_clk.X a_4369_1474# 0.06171f
C238 digital_0.hold28.A digital_0.hold22.X 0.03679f
C239 digital_0.hold19.X a_4015_1652# 0.13065f
C240 digital_0.input1.X a_7961_386# 0.05806f
C241 digital_0.output4.A a_3858_n702# 0.02365f
C242 digital_0.clkload0.A digital_0._106_.D 0.02166f
C243 digital_0._112_.Q a_12646_1500# 0.01373f
C244 LELO_GR01_0.x8.x1.x7.D digital_0.pwr 0.35751f
C245 a_4438_386# a_5218_778# 0.06473f
C246 a_7970_2588# VDPWR 0.2918f
C247 digital_0._114_.RESET_B a_9463_654# 0.16893f
C248 digital_0._113_.D a_11758_188# 0.20193f
C249 a_6263_2562# clk 0.01109f
C250 a_4578_15320# a_4580_14870# 0.02767f
C251 a_10199_n158# a_10089_n132# 0.09774f
C252 digital_0._119_.RESET_B a_4243_n676# 0.01234f
C253 a_3982_386# ui_in<0> 0.0242f
C254 a_4118_412# VDPWR 0.24191f
C255 a_4594_3650# a_4979_3676# 0.0425f
C256 li_20574_17304# uio_out<4> 0.04147f
C257 li_19474_13804# uio_out<0> 0.09105f
C258 li_6344_7564# ui_in<0> 0.01762f
C259 digital_0.hold28.A digital_0._101_.D 0.04388f
C260 LELO_GR01_0.x7.x18.G uo_out<1> 0.17198f
C261 LELO_GR01_0.x8.PWRUP_N_1V8 uio_out<2> 0.06737f
C262 digital_0._060_.A_N a_9005_956# 0.06276f
C263 digital_0.input1.X a_6793_n676# 0.01254f
C264 digital_0._110_.Q VDPWR 0.87544f
C265 a_9930_930# digital_0._060_.B 0.0123f
C266 a_2478_17610# a_2478_17100# 0.02417f
C267 LELO_GR01_0.x8.VREF_BG a_16018_17950# 0.03137f
C268 LELO_GR01_0.x7.x18.G a_4578_16260# 0.02715f
C269 LELO_GR01_0.x8.PWRUP_N_1V8 LELO_GR01_0.x7.x1.x5.x8.G 0.87314f
C270 digital_0._119_.RESET_B a_4570_n16# 0.02491f
C271 a_21554_8625# LELO_GR01_0.x8.x1.x5.IBN 0.01243f
C272 LELO_GR01_0.x8.x1.x5.x8.G a_19706_7559# 0.11889f
C273 a_14229_n132# VDPWR 0.13243f
C274 a_13679_3138# a_14029_3510# 0.21686f
C275 a_14247_3106# digital_0._102_.RESET_B 0.17703f
C276 a_6235_3106# a_6179_3132# 0.27101f
C277 digital_0._100_.RESET_B a_4425_2730# 0.32537f
C278 digital_0._069_.A a_8145_2562# 0.07637f
C279 a_13513_3138# a_14594_3510# 0.10236f
C280 digital_0.load_slew15.X a_4530_626# 0.01606f
C281 digital_0._111_.RESET_B a_10721_2348# 0.27934f
C282 digital_0.input1.X digital_0._112_.Q 0.27047f
C283 digital_0.output4.A digital_0._116_.D 0.02714f
C284 a_3618_3834# VDPWR 0.23077f
C285 digital_0.hold28.A a_7643_n702# 0.23801f
C286 digital_0.hold22.X digital_0._080_.A2 0.05558f
C287 digital_0.load_slew17.X a_14175_n702# 0.0388f
C288 digital_0._116_.D a_4609_110# 0.04048f
C289 digital_0.rst uio_out<5> 0.01546f
C290 a_3618_n518# a_3858_n702# 0.11296f
C291 digital_0.hold28.A digital_0._111_.Q 0.09371f
C292 digital_0._100_.RESET_B a_3577_3138# 0.01208f
C293 digital_0.clkbuf_1_0__f_clk.X a_4111_1474# 0.01406f
C294 digital_0.input1.X digital_0._111_.D 0.02973f
C295 digital_0.hold19.X a_3471_1474# 0.0384f
C296 digital_0.input1.X a_7221_412# 0.03134f
C297 digital_0.clkload0.A a_9465_n126# 0.26106f
C298 a_4530_626# a_5218_778# 0.15365f
C299 a_8145_2562# VDPWR 0.4351f
C300 digital_0._114_.RESET_B a_8895_412# 0.05072f
C301 LELO_GR01_0.x7.x1.x5.x9<2>.G a_9738_14810# 0.07542f
C302 a_3814_386# ui_in<0> 0.01436f
C303 a_9631_n126# a_10089_n132# 0.03462f
C304 digital_0._116_.SET_B VDPWR 0.42786f
C305 a_4594_3650# digital_0.output4.A 0.22908f
C306 li_16034_17304# uio_out<4> 0.04614f
C307 li_20574_17304# uio_out<2> 0.05301f
C308 li_6344_7564# rst_n 0.05694f
C309 li_27422_7487# VDPWR 0.05159f
C310 a_2478_17610# VDPWR 0.36654f
C311 digital_0.output4.A digital_0._119_.RESET_B 0.14082f
C312 digital_0.output6.A digital_0.load_slew17.X 0.04071f
C313 LELO_GR01_0.x8.PWRUP_N_1V8 uio_out<3> 0.19275f
C314 digital_0.input1.X a_6687_n676# 0.03886f
C315 a_12635_3171# VDPWR 0.17332f
C316 LELO_GR01_0.x7.x18.G a_4578_17060# 0.02715f
C317 LELO_GR01_0.x7.x18.D a_4578_16260# 0.07875f
C318 digital_0._119_.RESET_B a_4609_110# 0.29549f
C319 a_4292_0# a_4570_n16# 0.12532f
C320 LELO_GR01_0.x8.x1.x5.x9<2>.G a_21554_7825# 0.07795f
C321 a_13679_3138# digital_0._102_.RESET_B 0.06095f
C322 digital_0._100_.RESET_B a_4386_2856# 0.05687f
C323 digital_0.load_slew15.X a_7970_2588# 0.01651f
C324 digital_0._069_.A a_7405_2588# 0.03092f
C325 a_13513_3138# a_14769_3436# 0.04359f
C326 digital_0._111_.RESET_B a_9981_2422# 0.15779f
C327 digital_0._116_.Q a_3814_386# 0.12158f
C328 a_3492_3650# VDPWR 0.23336f
C329 digital_0.hold28.A digital_0.hold26.X 0.04233f
C330 digital_0.load_slew17.X digital_0.hold27.X 0.21125f
C331 LELO_GR01_0.x7.x7.G a_4578_10610# 0.07253f
C332 a_2478_11860# LELO_GR01_0.x7.x24.D 0.04279f
C333 digital_0._103_.RESET_B a_11415_3650# 0.01104f
C334 digital_0._103_.D digital_0._111_.Q 0.03409f
C335 digital_0._069_.A digital_0._067_.B 0.24686f
C336 digital_0._100_.RESET_B digital_0.clkbuf_1_0__f_clk.X 0.13573f
C337 digital_0.hold28.A digital_0.hold20.X 0.07362f
C338 digital_0.input1.X digital_0._111_.RESET_B 0.09595f
C339 digital_0.hold28.A digital_0.input2.X 0.08662f
C340 digital_0.input1.X a_7439_654# 0.01907f
C341 digital_0._063_.A a_12391_1500# 0.01642f
C342 digital_0.load_slew17.X digital_0._113_.D 0.01383f
C343 digital_0._118_.D digital_0.input2.X 0.13337f
C344 digital_0.clkload0.A a_8689_n132# 0.04768f
C345 a_14358_13930# VDPWR 0.43333f
C346 a_7405_2588# VDPWR 0.20095f
C347 a_11388_956# a_12391_412# 0.01118f
C348 LELO_GR01_0.x7.x1.x5.x9<2>.G a_8336_14010# 0.08521f
C349 a_3982_386# VDPWR 0.4054f
C350 a_4354_3834# digital_0.output4.A 0.05307f
C351 li_16034_17304# uio_out<2> 0.02192f
C352 li_20574_17304# uio_out<3> 0.02848f
C353 li_16454_13804# uio_out<0> 0.06773f
C354 digital_0._108_.D a_6263_2562# 0.01251f
C355 digital_0._069_.A a_11431_2382# 0.08146f
C356 a_6636_18610# VDPWR 0.4456f
C357 digital_0.output4.A a_4292_0# 0.01981f
C358 LELO_GR01_0.x7.x18.G ui_in<1> 0.41477f
C359 LELO_GR01_0.x8.PWRUP_N_1V8 uo_out<1> 0.27217f
C360 digital_0.output9.A a_15685_386# 0.29644f
C361 digital_0._067_.B VDPWR 0.29223f
C362 digital_0.input1.X a_6451_n676# 0.05261f
C363 digital_0._109_.Q clk 0.09772f
C364 LELO_GR01_0.PWRUP_1V8 LELO_GR01_0.x8.IBP_BG 0.29949f
C365 LELO_GR01_0.x7.x18.D a_4578_17060# 0.07857f
C366 a_4292_0# a_4609_110# 0.10236f
C367 a_4005_n158# a_4570_n16# 0.04251f
C368 LELO_GR01_0.x8.x1.x5.x9<2>.G LELO_GR01_0.x8.x1.x5.IBN 0.96053f
C369 a_13513_3138# a_14029_3510# 0.11535f
C370 a_13679_3138# a_14247_3106# 0.18122f
C371 digital_0.hold28.A a_13103_3171# 0.01002f
C372 digital_0._100_.RESET_B a_4108_2840# 0.23049f
C373 digital_0._069_.A a_7623_2830# 0.02093f
C374 digital_0.load_slew15.X a_8145_2562# 0.0302f
C375 LELO_GR01_0.x8.x4.G a_26146_2651# 0.07043f
C376 digital_0._111_.D a_9631_2050# 0.21216f
C377 digital_0._111_.RESET_B a_10199_2018# 0.17458f
C378 digital_0.load_slew15.X digital_0._116_.SET_B 0.17291f
C379 digital_0._118_.D a_4826_1322# 0.1576f
C380 digital_0.load_slew17.X digital_0._060_.B 0.27403f
C381 digital_0.hold23.X a_14727_1474# 0.03924f
C382 digital_0.input2.X digital_0._080_.A2 0.16724f
C383 a_11431_2382# VDPWR 0.24609f
C384 a_3492_n702# a_3618_n518# 0.34134f
C385 digital_0._103_.RESET_B digital_0._111_.Q 0.05597f
C386 digital_0._069_.A digital_0._067_.A 0.27725f
C387 uio_in<6> uio_in<7> 0.03102f
C388 digital_0.clkbuf_1_0__f_clk.X a_3471_1474# 0.0174f
C389 a_7405_2588# a_7501_2588# 0.01379f
C390 digital_0._116_.Q a_12849_1866# 0.0283f
C391 LELO_GR01_0.x8.x1.x5.IBN digital_0.pwr 0.41364f
C392 digital_0.input1.X a_6871_412# 0.55733f
C393 digital_0._063_.A digital_0._113_.D 0.26285f
C394 digital_0.clkload0.A a_8578_n132# 0.04945f
C395 a_14358_14730# VDPWR 0.41173f
C396 a_7623_2830# VDPWR 0.20832f
C397 a_11388_956# a_12225_412# 0.01925f
C398 digital_0._114_.RESET_B a_8729_412# 0.31949f
C399 LELO_GR01_0.x7.x1.x5.x9<2>.G a_8336_14810# 0.12529f
C400 LELO_GR01_0.x8.PWRUP_N_1V8 LELO_GR01_0.x7.x25.D 1.02027f
C401 a_9981_246# a_10077_246# 0.01379f
C402 a_3814_386# VDPWR 0.26369f
C403 a_4228_3650# digital_0.output4.A 0.04929f
C404 digital_0.output5.A a_4979_3676# 0.2875f
C405 a_4354_3834# a_4594_3650# 0.11296f
C406 li_16034_17304# uio_out<3> 0.02381f
C407 li_8044_11904# ui_in<0> 0.03144f
C408 a_9981_2422# a_10089_2044# 0.05722f
C409 digital_0.output4.A a_4005_n158# 0.13076f
C410 LELO_GR01_0.x7.x18.G ui_in<0> 0.09674f
C411 LELO_GR01_0.x8.PWRUP_N_1V8 uio_out<0> 1.53021f
C412 digital_0._067_.A VDPWR 1.00583f
C413 digital_0.input1.X a_5974_n676# 0.0517f
C414 digital_0._112_.Q a_12849_778# 0.02638f
C415 digital_0._080_.A2 a_4826_1322# 0.01626f
C416 digital_0.output13.A clk 0.09547f
C417 a_16018_18750# LELO_GR01_0.x8.VREF_BG 0.01293f
C418 LELO_GR01_0.x7.x18.G LELO_GR01_0.x7.x20.D 0.09617f
C419 digital_0._114_.Q a_10495_n702# 0.10785f
C420 a_4005_n158# a_4609_110# 0.04359f
C421 a_4292_0# digital_0._119_.RESET_B 0.23197f
C422 LELO_GR01_0.x8.x1.x5.x9<2>.G a_21554_8625# 0.07164f
C423 a_13513_3138# digital_0._102_.RESET_B 0.33077f
C424 digital_0.load_slew15.A digital_0.input1.X 0.0333f
C425 digital_0._100_.RESET_B a_3821_2562# 0.27799f
C426 digital_0._069_.A a_7055_2588# 0.57366f
C427 digital_0._111_.D a_9465_2050# 0.16301f
C428 digital_0._111_.RESET_B a_9631_2050# 0.02764f
C429 digital_0.output13.A a_5486_1334# 0.04112f
C430 digital_0._118_.D digital_0._080_.A2 0.04205f
C431 digital_0._060_.B a_9981_246# 0.01098f
C432 digital_0._116_.SET_B a_4696_n132# 0.01389f
C433 a_10546_2422# VDPWR 0.29724f
C434 digital_0._116_.Q a_12646_1500# 0.01625f
C435 digital_0.input1.X digital_0._108_.RESET_B 0.48039f
C436 digital_0.input1.X a_6705_412# 0.32439f
C437 digital_0._063_.A a_12225_1500# 0.03888f
C438 a_12688_13928# VDPWR 0.03231f
C439 digital_0.clkload0.A a_8361_n132# 0.0679f
C440 a_4438_386# digital_0._116_.D 0.10248f
C441 a_4610_386# a_4746_412# 0.25769f
C442 a_7055_2588# VDPWR 0.25279f
C443 digital_0.input1.X ui_in<0> 0.09853f
C444 LELO_GR01_0.x7.x1.x5.x9<2>.G a_6936_14010# 0.07336f
C445 LELO_GR01_0.x8.PWRUP_N_1V8 a_2478_10550# 0.08238f
C446 a_9981_246# a_9886_234# 0.04983f
C447 digital_0.output5.A digital_0.output4.A 0.81276f
C448 li_20574_17304# uio_out<0> 0.0738f
C449 digital_0._069_.A a_10721_2348# 0.02029f
C450 a_10199_2018# a_10089_2044# 0.09774f
C451 a_12688_18980# VDPWR 0.39884f
C452 LELO_GR01_0.x7.x18.G rst_n 0.10648f
C453 LELO_GR01_0.x8.PWRUP_N_1V8 ui_in<1> 0.05534f
C454 digital_0._115_.Q a_7826_956# 0.03064f
C455 digital_0._060_.A_N digital_0._060_.B 0.23709f
C456 a_11098_3510# VDPWR 0.29664f
C457 digital_0._112_.Q a_12646_412# 0.01619f
C458 digital_0._108_.Q clk 0.08955f
C459 digital_0.input1.X digital_0.hold18.X 0.79772f
C460 LELO_GR01_0.x8.PWRUP_N_1V8 a_2478_16300# 0.07785f
C461 digital_0._114_.Q digital_0.hold21.X 0.33446f
C462 digital_0._080_.A2 a_5785_n426# 0.03996f
C463 a_12849_1866# VDPWR 0.13324f
C464 a_4005_n158# digital_0._119_.RESET_B 0.33236f
C465 LELO_GR01_0.x8.x1.x5.x9<2>.G a_20156_7909# 0.04123f
C466 a_13513_3138# a_14247_3106# 0.07009f
C467 digital_0._102_.D a_13679_3138# 0.22772f
C468 digital_0._109_.Q digital_0._108_.D 0.26787f
C469 digital_0._069_.A a_6889_2588# 0.06108f
C470 digital_0._116_.Q digital_0.input1.X 0.16959f
C471 digital_0.output13.A a_6455_3452# 0.10609f
C472 a_26146_3451# LELO_GR01_0.x8.x4.G 0.07706f
C473 digital_0._111_.RESET_B a_9465_2050# 0.30569f
C474 digital_0.load_slew15.X a_3814_386# 0.0115f
C475 digital_0.output13.A a_5661_1260# 0.16783f
C476 digital_0._104_.D digital_0.hold23.X 0.01575f
C477 a_10721_2348# VDPWR 0.41688f
C478 digital_0._060_.B digital_0._106_.RESET_B 0.03316f
C479 digital_0._116_.SET_B a_4765_n158# 0.04178f
C480 a_9245_412# a_9341_412# 0.01379f
C481 LELO_GR01_0.x7.x7.G a_4578_11410# 0.10007f
C482 uio_in<5> uio_in<6> 0.03102f
C483 digital_0._065_.A2_N a_11107_2562# 0.04936f
C484 digital_0._116_.Q digital_0.input3.X 0.50477f
C485 digital_0.clkload0.A digital_0._112_.Q 0.59782f
C486 a_4730_1652# digital_0.hold22.X 0.06567f
C487 digital_0._063_.A digital_0._063_.B 0.10792f
C488 digital_0.hold28.A a_14686_246# 0.02767f
C489 LELO_GR01_0.x7.x7.G ui_in<0> 0.12474f
C490 digital_0._112_.Q a_14298_1652# 0.22896f
C491 a_12688_14728# VDPWR 0.04865f
C492 a_4438_386# a_4746_412# 0.18443f
C493 a_4530_626# digital_0._116_.D 0.12989f
C494 a_6889_2588# VDPWR 0.46474f
C495 digital_0._114_.Q digital_0.clkload0.X 0.05621f
C496 a_5834_2740# clk 0.01812f
C497 LELO_GR01_0.x7.x15.I2 a_14358_15670# 0.03213f
C498 LELO_GR01_0.x7.x21.D a_2478_13680# 0.01254f
C499 LELO_GR01_0.x7.x18.G a_14358_11680# 0.07768f
C500 a_14781_956# VDPWR 0.14272f
C501 digital_0.output5.A a_4594_3650# 0.06395f
C502 a_4228_3650# a_4354_3834# 0.34134f
C503 li_16034_17304# uio_out<0> 0.04851f
C504 digital_0.clkload0.A digital_0._111_.D 0.09416f
C505 a_9631_2050# a_10089_2044# 0.03462f
C506 LELO_GR01_0.x7.x18.G VDPWR 57.9767f
C507 digital_0._101_.D a_4730_1652# 0.08082f
C508 LELO_GR01_0.x8.PWRUP_N_1V8 ui_in<0> 0.27771f
C509 digital_0.output9.A digital_0.rst 0.01235f
C510 digital_0._060_.A_N a_7826_956# 0.07193f
C511 a_9564_930# digital_0._114_.RESET_B 0.02681f
C512 a_11273_3436# VDPWR 0.40323f
C513 digital_0.load_slew17.X digital_0._112_.RESET_B 0.22865f
C514 digital_0._115_.Q a_7099_956# 0.03928f
C515 digital_0.input1.X a_5422_n702# 0.02833f
C516 LELO_GR01_0.PWRUP_1V8 LELO_GR01_0.x8.VREF_BG 0.87542f
C517 LELO_GR01_0.x7.x18.G a_14358_17550# 0.08223f
C518 LELO_GR01_0.x8.PWRUP_N_1V8 LELO_GR01_0.x7.x20.D 1.01793f
C519 LELO_GR01_0.x7.x19.D a_2478_16300# 0.01255f
C520 LELO_GR01_0.x7.x6<3>.G a_4578_16260# 0.06119f
C521 a_12646_1500# VDPWR 0.07876f
C522 a_4005_n158# a_4292_0# 0.23366f
C523 digital_0._060_.B a_10066_n524# 0.03878f
C524 a_14026_234# VDPWR 0.07761f
C525 LELO_GR01_0.x8.x1.x5.x8.S LELO_GR01_0.x8.x1.x5.x3.S 0.15786f
C526 a_13513_3138# a_13679_3138# 0.90347f
C527 digital_0.output13.A digital_0._108_.D 0.0461f
C528 digital_0._109_.Q digital_0._118_.RESET_B 0.20949f
C529 digital_0.hold28.A a_13934_3498# 0.01625f
C530 digital_0._069_.A digital_0.input1.X 0.74263f
C531 digital_0._108_.Q a_6455_3452# 0.02841f
C532 digital_0.output4.A a_4118_412# 0.02373f
C533 digital_0.output13.A a_4921_1334# 0.03568f
C534 digital_0.input1.X digital_0._107_.RESET_B 0.0466f
C535 digital_0.load_slew17.X digital_0._114_.RESET_B 0.10871f
C536 a_9981_2422# VDPWR 0.20688f
C537 digital_0._116_.SET_B a_4570_n16# 0.01992f
C538 a_6337_2050# clk 0.01012f
C539 a_14358_13930# a_14358_13420# 0.02417f
C540 digital_0.rst uio_out<4> 0.03798f
C541 digital_0._103_.RESET_B digital_0._103_.D 0.2639f
C542 digital_0._116_.Q a_15634_1474# 0.01381f
C543 digital_0._065_.A2_N a_10285_2910# 0.17239f
C544 digital_0.load_slew17.A a_15268_1474# 0.09342f
C545 LELO_GR01_0.x8.x1.x5.x9<2>.G digital_0.pwr 0.10804f
C546 digital_0.output9.A digital_0._113_.RESET_B 0.45713f
C547 digital_0.hold28.A a_14861_172# 0.01504f
C548 LELO_GR01_0.x7.x7.G rst_n 0.08726f
C549 digital_0._112_.Q a_13306_1500# 0.05762f
C550 digital_0.output6.A a_6503_930# 0.02703f
C551 a_11318_13928# VDPWR 0.02717f
C552 a_4438_386# a_4610_386# 0.20518f
C553 a_4530_626# a_4746_412# 0.07694f
C554 digital_0.input1.X VDPWR 4.60837f
C555 LELO_GR01_0.x7.x21.D LELO_GR01_0.x7.x22.D 0.56561f
C556 LELO_GR01_0.x8.PWRUP_N_1V8 a_2478_11060# 0.07785f
C557 LELO_GR01_0.x7.x18.G a_14358_12480# 0.07695f
C558 digital_0.output5.A a_4354_3834# 0.03614f
C559 li_16454_13804# VDPWR 0.21588f
C560 digital_0.clkload0.A digital_0._111_.RESET_B 0.0905f
C561 digital_0._116_.Q a_9631_2050# 0.03574f
C562 LELO_GR01_0.x7.x18.D VDPWR 2.59337f
C563 LELO_GR01_0.x8.PWRUP_N_1V8 rst_n 0.4002f
C564 digital_0._101_.D a_4369_1474# 0.09178f
C565 a_7155_930# a_7826_956# 0.15745f
C566 a_10533_3510# VDPWR 0.20705f
C567 digital_0.input1.X a_5182_n518# 0.02675f
C568 digital_0._060_.A_N a_7099_956# 0.02998f
C569 a_4658_3510# clk 0.0141f
C570 LELO_GR01_0.x7.x18.G a_4578_17200# 0.02715f
C571 LELO_GR01_0.x8.PWRUP_N_1V8 a_2478_17100# 0.08243f
C572 LELO_GR01_0.x7.x6<3>.G a_4578_17060# 0.06102f
C573 LELO_GR01_0.x7.x19.D LELO_GR01_0.x7.x20.D 0.56721f
C574 digital_0.input3.X VDPWR 0.7124f
C575 digital_0._060_.B a_9417_n702# 0.12037f
C576 a_20156_8709# LELO_GR01_0.x8.x1.x5.x9<2>.G 0.01325f
C577 a_12116_n132# VDPWR 0.46737f
C578 a_13513_3138# digital_0._102_.D 0.25021f
C579 digital_0._108_.Q digital_0._108_.D 0.1312f
C580 digital_0.output13.A digital_0._118_.RESET_B 0.44902f
C581 a_6235_3106# a_6455_3452# 0.01892f
C582 digital_0.output4.A digital_0._116_.SET_B 0.0386f
C583 digital_0.hold28.A a_14673_1334# 0.0243f
C584 digital_0.output13.A a_5139_930# 0.02199f
C585 digital_0.input1.X a_6684_0# 0.024f
C586 digital_0._112_.Q digital_0._112_.D 0.05172f
C587 digital_0._113_.Q digital_0._104_.D 0.02179f
C588 a_10199_2018# VDPWR 0.21445f
C589 digital_0._116_.SET_B a_4609_110# 0.14997f
C590 digital_0._060_.B a_9631_n126# 0.02586f
C591 digital_0.load_slew17.A digital_0.clkload0.A 0.60112f
C592 a_14319_3828# digital_0.hold24.X 0.13051f
C593 uio_in<4> uio_in<5> 0.03102f
C594 a_7405_2588# a_7513_2954# 0.05722f
C595 digital_0._116_.Q a_15394_1658# 0.02863f
C596 a_10074_2562# a_10285_2910# 0.27272f
C597 digital_0.clkbuf_1_0__f_clk.X digital_0.load_slew17.X 0.08061f
C598 digital_0.hold28.A a_6315_1474# 0.07006f
C599 digital_0.load_slew17.A a_14298_1652# 0.03657f
C600 digital_0._108_.D a_6503_2050# 0.20518f
C601 LELO_GR01_0.x8.x1.x5.x3.S LELO_GR01_0.PWRUP_1V8 0.21243f
C602 LELO_GR01_0.x7.x1.x5.x8.S a_6636_17810# 0.04689f
C603 LELO_GR01_0.x7.x23.D clk 0.08209f
C604 digital_0.clkbuf_1_1__f_clk.A a_8996_1500# 1.7641f
C605 digital_0._112_.Q a_13481_1474# 0.073f
C606 digital_0.output6.A a_6407_1188# 0.03182f
C607 LELO_GR01_0.x7.x7.G VDPWR 3.10838f
C608 a_4530_626# a_4610_386# 0.2094f
C609 digital_0._116_.SET_B digital_0._116_.D 0.06808f
C610 LELO_GR01_0.x7.x15.I2 a_14358_15810# 0.03213f
C611 LELO_GR01_0.x7.x1.x7.D a_12688_14988# 0.07102f
C612 LELO_GR01_0.x7.x21.D a_2478_14480# 0.04927f
C613 LELO_GR01_0.x7.x1.x5.x8.G a_6936_14010# 0.01247f
C614 a_9631_n126# a_9886_234# 0.06418f
C615 digital_0.output5.A a_4228_3650# 0.06236f
C616 digital_0._110_.Q a_11107_2562# 0.09101f
C617 digital_0._116_.Q a_9465_2050# 0.04863f
C618 LELO_GR01_0.x8.IBP_BG li_19474_13804# 0.16216f
C619 LELO_GR01_0.x8.PWRUP_N_1V8 VDPWR 27.6739f
C620 digital_0._101_.D a_4111_1474# 0.01079f
C621 a_3853_2050# a_4369_1474# 0.0112f
C622 digital_0.output13.A uo_out<1> 0.04832f
C623 a_10751_3106# VDPWR 0.21233f
C624 digital_0.input1.X a_5056_n702# 0.11328f
C625 a_15413_1260# a_15238_1334# 0.23366f
C626 digital_0._060_.A_N digital_0._114_.RESET_B 0.56493f
C627 digital_0._115_.Q a_7375_1276# 0.10697f
C628 a_7155_930# a_7099_956# 0.27101f
C629 a_4833_3436# clk 0.01885f
C630 LELO_GR01_0.x7.x18.D a_4578_17200# 0.0785f
C631 LELO_GR01_0.x7.x18.G a_17668_17950# 0.07043f
C632 LELO_GR01_0.x7.x19.D a_2478_17100# 0.04966f
C633 a_15634_1474# VDPWR 0.30125f
C634 digital_0._060_.B a_9151_n702# 0.20723f
C635 LELO_GR01_0.x8.x1.x5.x8.G a_20156_7909# 0.0824f
C636 a_11673_n132# VDPWR 0.37311f
C637 a_12889_3171# digital_0._102_.D 0.08097f
C638 a_6235_3106# digital_0._108_.D 0.22729f
C639 digital_0.output13.A digital_0._101_.RESET_B 0.01338f
C640 digital_0.load_slew15.X digital_0.input1.X 0.06421f
C641 digital_0.output4.A a_3982_386# 0.01877f
C642 digital_0.hold28.A a_14891_930# 0.01837f
C643 digital_0._108_.RESET_B a_7418_2422# 0.21671f
C644 digital_0.output13.A a_4571_962# 0.0224f
C645 digital_0._112_.Q a_10555_956# 0.05323f
C646 digital_0.load_slew17.X digital_0._115_.D 0.02542f
C647 digital_0.input1.X a_6397_n158# 0.03252f
C648 digital_0.hold28.A a_14871_n524# 0.01114f
C649 a_24508_6427# VDPWR 0.04298f
C650 a_4530_626# a_4005_n158# 0.01137f
C651 a_10997_386# a_11673_412# 0.03366f
C652 a_9631_2050# VDPWR 0.58345f
C653 digital_0._116_.SET_B digital_0._119_.RESET_B 0.1434f
C654 digital_0._060_.B digital_0._106_.D 0.23259f
C655 digital_0._112_.RESET_B uio_out<5> 0.01169f
C656 digital_0.output7.A digital_0.hold24.X 0.11322f
C657 a_7623_2830# a_7513_2954# 0.09774f
C658 a_7405_2588# a_7310_2588# 0.04983f
C659 digital_0._116_.Q a_15268_1474# 0.01631f
C660 a_10074_2562# digital_0._065_.A2_N 0.03186f
C661 digital_0.hold28.A a_4730_1652# 0.32286f
C662 digital_0._108_.D a_6337_2050# 0.1615f
C663 LELO_GR01_0.x8.x1.x5.x8.S LELO_GR01_0.PWRUP_1V8 0.02336f
C664 digital_0.clkbuf_1_1__f_clk.A a_8085_1500# 0.081f
C665 digital_0.load_slew17.X digital_0._115_.RESET_B 0.2603f
C666 digital_0._112_.Q a_12741_1500# 0.03367f
C667 digital_0.hold28.A digital_0._105_.RESET_B 0.21906f
C668 a_11318_14728# VDPWR 0.04219f
C669 a_4530_626# a_4438_386# 0.55766f
C670 digital_0._116_.SET_B a_4746_412# 0.16104f
C671 LELO_GR01_0.x7.x1.x5.x9<2>.G a_6936_14810# 0.0876f
C672 LELO_GR01_0.x7.x18.G a_14358_12620# 0.07579f
C673 a_14861_172# a_14686_246# 0.23366f
C674 digital_0._106_.D a_9886_234# 0.16124f
C675 li_20574_17304# VDPWR 0.01034f
C676 a_9981_2422# a_10077_2422# 0.01379f
C677 LELO_GR01_0.x7.x19.D VDPWR 0.5179f
C678 a_10183_3138# VDPWR 0.57678f
C679 digital_0._063_.A a_12391_412# 0.01705f
C680 digital_0.clkload0.A ui_in<0> 0.07979f
C681 a_6761_930# a_7099_956# 0.02816f
C682 digital_0._060_.A_N a_7375_1276# 0.05172f
C683 a_4093_3510# clk 0.01281f
C684 LELO_GR01_0.PWRUP_1V8 a_12688_18180# 0.07212f
C685 LELO_GR01_0.x7.x18.G LELO_GR01_0.x8.IBP_BG 0.45186f
C686 a_15394_1658# VDPWR 0.2411f
C687 LELO_GR01_0.x8.x8.D LELO_GR01_0.x8.x1.x7.D 0.01323f
C688 a_23824_9183# a_23816_8541# 0.01862f
C689 LELO_GR01_0.x8.x1.x5.x8.G LELO_GR01_0.x8.x1.x5.x9<2>.G 2.14916f
C690 digital_0._111_.Q digital_0._110_.D 0.01381f
C691 digital_0._108_.RESET_B a_7593_2348# 0.31857f
C692 digital_0.hold28.A a_14323_962# 0.03705f
C693 digital_0.output13.A a_4405_962# 0.15748f
C694 digital_0.hold28.A a_13746_n524# 0.36904f
C695 digital_0._115_.RESET_B digital_0._115_.Q 0.61892f
C696 a_10997_386# digital_0._057_.D 0.10953f
C697 a_9245_412# a_9353_778# 0.05722f
C698 a_9465_2050# VDPWR 0.4769f
C699 digital_0._116_.SET_B a_4292_0# 0.01513f
C700 digital_0._060_.B a_9465_n126# 0.02059f
C701 digital_0._113_.Q digital_0.output10.A 0.17074f
C702 LELO_GR01_0.x7.x7.G a_4578_11670# 0.0231f
C703 a_12849_778# VDPWR 0.13239f
C704 digital_0.load_slew15.A digital_0._109_.Q 0.04547f
C705 digital_0._116_.Q digital_0.clkload0.A 0.2873f
C706 a_13978_3650# digital_0.hold24.X 0.19269f
C707 uio_in<3> uio_in<4> 0.03102f
C708 a_7055_2588# a_7513_2954# 0.02761f
C709 LELO_GR01_0.x8.x1.x5.x8.G digital_0.pwr 0.0193f
C710 a_4111_1474# digital_0.input2.X 0.04949f
C711 digital_0.clkload0.A a_7001_110# 0.2453f
C712 a_6315_1474# a_8085_1500# 0.01896f
C713 digital_0.load_slew17.X a_5785_1750# 0.0452f
C714 digital_0._112_.Q digital_0._113_.RESET_B 0.61482f
C715 digital_0.hold28.A a_14339_n158# 0.01124f
C716 digital_0._116_.SET_B a_4610_386# 0.21194f
C717 a_4118_412# a_4438_386# 0.06363f
C718 a_6263_2562# VDPWR 0.23953f
C719 digital_0._100_.D clk 0.01981f
C720 LELO_GR01_0.x7.x1.x7.D a_12688_15788# 0.07449f
C721 LELO_GR01_0.x7.x18.G a_14358_13420# 0.07873f
C722 a_9465_n126# a_9886_234# 0.09313f
C723 a_13513_956# VDPWR 0.42753f
C724 a_3858_3650# digital_0.output5.A 0.22457f
C725 li_16034_17304# VDPWR 0.2899f
C726 digital_0._110_.Q digital_0._065_.A2_N 0.28222f
C727 digital_0._109_.Q digital_0._108_.RESET_B 0.02202f
C728 a_9981_2422# a_9886_2410# 0.04983f
C729 digital_0._116_.Q a_15685_386# 0.01071f
C730 LELO_GR01_0.x8.IBP_BG li_16454_13804# 0.05388f
C731 a_2478_18410# VDPWR 0.37812f
C732 digital_0._115_.RESET_B a_7329_778# 0.01838f
C733 digital_0._063_.A a_12225_412# 0.04705f
C734 a_10017_3138# VDPWR 0.50189f
C735 a_14891_930# a_15238_1334# 0.05116f
C736 a_7155_930# a_7375_1276# 0.01892f
C737 digital_0._060_.A_N digital_0._115_.D 0.06145f
C738 a_4311_3106# clk 0.01157f
C739 LELO_GR01_0.x7.x18.G a_17668_18750# 0.07801f
C740 a_15268_1474# VDPWR 0.22859f
C741 LELO_GR01_0.x8.x1.x5.x8.G a_20156_8709# 0.07053f
C742 a_14967_n702# a_15225_n702# 0.22264f
C743 LELO_GR01_0.x7.x1.x5.x8.S LELO_GR01_0.x7.x1.x5.x3.S 0.15786f
C744 digital_0._108_.RESET_B a_6853_2422# 0.15327f
C745 digital_0.hold28.A a_14157_962# 0.03214f
C746 digital_0.input1.X a_9886_2410# 0.01378f
C747 digital_0.output13.A a_3858_930# 0.02978f
C748 digital_0.load_slew17.X digital_0.hold28.X 0.01551f
C749 digital_0.hold28.A a_12737_n676# 0.04085f
C750 a_23138_6427# VDPWR 0.042f
C751 digital_0._115_.RESET_B digital_0._060_.A_N 0.04698f
C752 a_9463_654# a_9353_778# 0.09774f
C753 a_9245_412# a_9150_412# 0.04983f
C754 a_7418_2422# VDPWR 0.30054f
C755 a_12646_412# VDPWR 0.07765f
C756 digital_0._117_.RESET_B digital_0.hold28.A 0.04061f
C757 a_7717_3926# digital_0._109_.RESET_B 0.15333f
C758 digital_0._116_.Q digital_0._109_.Q 0.15483f
C759 digital_0._069_.A digital_0.clkload0.A 0.19013f
C760 a_13738_3834# digital_0.hold24.X 0.04731f
C761 a_7055_2588# a_7310_2588# 0.05562f
C762 digital_0._108_.D digital_0.output6.A 0.03091f
C763 digital_0._118_.RESET_B a_5787_2146# 0.01146f
C764 a_4015_1652# digital_0.input2.X 0.05384f
C765 digital_0.clkload0.A digital_0._107_.RESET_B 0.27625f
C766 a_6315_1474# digital_0.clkbuf_1_1__f_clk.A 0.33032f
C767 digital_0._112_.Q a_12959_1742# 0.04302f
C768 digital_0.hold28.A a_13771_n126# 0.02941f
C769 a_14358_14870# VDPWR 0.41237f
C770 a_4118_412# a_4530_626# 0.07272f
C771 digital_0._116_.SET_B a_4438_386# 0.04315f
C772 digital_0._115_.D a_7126_412# 0.16052f
C773 LELO_GR01_0.x7.x18.G a_11988_12620# 0.08893f
C774 LELO_GR01_0.x7.x1.x7.D a_11318_14986# 0.10629f
C775 digital_0._105_.RESET_B a_14686_246# 0.23846f
C776 li_28516_19376# VDPWR 0.46679f
C777 li_26138_5135# li_27050_5051# 0.03742f
C778 digital_0.hold21.X uio_out<6> 0.02807f
C779 digital_0._067_.A a_11107_2562# 0.17951f
C780 digital_0._116_.Q a_15427_386# 0.03753f
C781 LELO_GR01_0.x8.VREF_BG li_19474_13804# 0.12903f
C782 LELO_GR01_0.x7.x6<3>.G VDPWR 0.49558f
C783 digital_0.output13.A ui_in<0> 0.03984f
C784 digital_0.input2.X a_8895_412# 0.02778f
C785 digital_0.clkload0.A VDPWR 4.10952f
C786 a_14323_962# a_15238_1334# 0.12532f
C787 a_7155_930# digital_0._115_.D 0.19915f
C788 a_3743_3138# clk 0.04445f
C789 LELO_GR01_0.x8.PWRUP_N_1V8 LELO_GR01_0.x8.IBP_BG 1.35392f
C790 LELO_GR01_0.x7.x18.G a_16018_17950# 0.07055f
C791 a_14298_1652# VDPWR 0.09768f
C792 LELO_GR01_0.x8.x1.x5.x8.G a_18456_7909# 0.13066f
C793 a_11007_n524# digital_0.hold21.X 0.1356f
C794 digital_0._110_.Q a_12889_3171# 0.19068f
C795 digital_0._108_.RESET_B a_7071_2018# 0.16185f
C796 digital_0.hold28.A a_12626_n676# 0.03853f
C797 digital_0._115_.RESET_B a_7155_930# 0.01615f
C798 a_7593_2348# VDPWR 0.4188f
C799 a_3982_386# a_4005_n158# 0.01027f
C800 a_8895_412# a_9353_778# 0.03462f
C801 a_15685_386# VDPWR 0.3222f
C802 digital_0._100_.RESET_B digital_0.hold28.A 0.05884f
C803 digital_0._109_.D digital_0._109_.RESET_B 0.01991f
C804 digital_0._069_.A digital_0._109_.Q 0.09364f
C805 digital_0._116_.Q digital_0.output13.A 0.51717f
C806 a_13612_3650# digital_0.hold24.X 0.04161f
C807 uio_in<2> uio_in<3> 0.03102f
C808 a_6889_2588# a_7310_2588# 0.0858f
C809 digital_0.load_slew17.A digital_0._113_.RESET_B 0.11366f
C810 digital_0._118_.RESET_B digital_0.output6.A 0.03979f
C811 a_3471_1474# digital_0.input2.X 0.19057f
C812 digital_0._112_.Q a_12391_1500# 0.58748f
C813 digital_0.hold28.A digital_0._105_.D 0.19054f
C814 a_3982_386# a_4438_386# 0.18432f
C815 digital_0._116_.SET_B a_4530_626# 0.20931f
C816 a_4581_2825# clk 0.01275f
C817 LELO_GR01_0.x7.x18.G LELO_GR01_0.x7.x24.D 0.09098f
C818 LELO_GR01_0.x7.x1.x5.x8.G a_6936_14810# 0.0438f
C819 LELO_GR01_0.x7.x1.x7.D a_11318_15786# 0.098f
C820 a_14578_1322# VDPWR 0.08292f
C821 digital_0._105_.RESET_B a_14861_172# 0.27927f
C822 a_14339_n158# a_14686_246# 0.05116f
C823 a_3618_3834# a_3858_3650# 0.11296f
C824 digital_0.hold21.X uio_out<5> 0.11745f
C825 digital_0._108_.Q digital_0._108_.RESET_B 0.43139f
C826 a_9631_2050# a_9886_2410# 0.06121f
C827 digital_0._116_.Q a_15331_564# 0.02336f
C828 LELO_GR01_0.x8.IBP_BG li_20574_17304# 0.16831f
C829 digital_0.input2.X digital_0._114_.D 0.1958f
C830 digital_0._109_.Q VDPWR 2.67904f
C831 a_14323_962# a_15413_1260# 0.04251f
C832 a_14157_962# a_15238_1334# 0.10236f
C833 a_14891_930# a_14673_1334# 0.20964f
C834 a_6761_930# digital_0._115_.D 0.03034f
C835 digital_0.hold19.X clk 0.04668f
C836 LELO_GR01_0.x7.x18.G LELO_GR01_0.x8.VREF_BG 0.43674f
C837 LELO_GR01_0.x7.x6<3>.G a_4578_17200# 0.06102f
C838 a_13306_1500# VDPWR 0.29974f
C839 digital_0.output11.A VDPWR 0.695f
C840 a_14871_n524# a_14967_n702# 0.41909f
C841 a_10066_n524# digital_0.hold21.X 0.0578f
C842 digital_0._108_.RESET_B a_6503_2050# 0.02352f
C843 digital_0._065_.A2_N a_11431_2382# 0.18087f
C844 digital_0.hold28.A digital_0._114_.Q 0.24425f
C845 digital_0.load_slew15.A a_9005_956# 0.10021f
C846 LELO_GR01_0.x8.x7.D uio_out<3> 0.09207f
C847 digital_0.hold28.A a_12409_n676# 0.03941f
C848 digital_0._116_.Q a_15537_n426# 0.10493f
C849 digital_0._115_.Q digital_0.output12.A 0.08304f
C850 a_6853_2422# VDPWR 0.2019f
C851 a_8895_412# a_9150_412# 0.06418f
C852 digital_0.output6.A uo_out<1> 0.01222f
C853 LELO_GR01_0.x8.IBP_BG a_23138_5627# 0.08725f
C854 LELO_GR01_0.x7.x7.G a_11988_12620# 0.05469f
C855 a_15427_386# VDPWR 0.28056f
C856 digital_0._105_.RESET_B a_14967_n702# 0.01499f
C857 digital_0.hold25.X digital_0.hold28.A 0.05966f
C858 digital_0._069_.A digital_0.output13.A 0.39387f
C859 digital_0._069_.B digital_0._109_.Q 0.15126f
C860 digital_0.load_slew15.X digital_0.clkload0.A 0.16115f
C861 a_12829_3676# digital_0.hold24.X 0.01182f
C862 uio_out<7> uio_oe<0> 0.04188f
C863 digital_0._116_.Q a_12741_1500# 0.0357f
C864 a_8145_2562# a_7970_2588# 0.23366f
C865 digital_0._101_.RESET_B digital_0.output6.A 0.12575f
C866 a_4578_18940# LELO_GR01_0.x7.x18.G 0.05431f
C867 LELO_GR01_0.x7.x22.D clk 0.08265f
C868 LELO_GR01_0.x7.x15.I1 digital_0.pwr 3.07391f
C869 digital_0.input1.X digital_0._116_.D 0.56277f
C870 a_3471_1474# digital_0._118_.D 0.15255f
C871 a_11951_2146# a_12225_1500# 0.01052f
C872 digital_0._112_.Q digital_0._113_.D 0.05158f
C873 digital_0.hold28.A a_13605_n126# 0.02312f
C874 a_11388_956# a_11673_412# 0.01467f
C875 a_3982_386# a_4530_626# 0.05758f
C876 a_4425_2730# clk 0.02654f
C877 digital_0._116_.SET_B a_4118_412# 0.12109f
C878 LELO_GR01_0.x7.x6<3>.G a_4578_11670# 0.0833f
C879 digital_0._112_.D VDPWR 0.37175f
C880 a_13771_n126# a_14686_246# 0.12532f
C881 digital_0._105_.RESET_B a_14121_246# 0.15995f
C882 a_7088_n132# a_7302_n132# 0.09774f
C883 digital_0._118_.RESET_B digital_0._100_.D 0.02835f
C884 digital_0._111_.Q a_10571_2588# 0.0635f
C885 digital_0._067_.A digital_0._065_.A2_N 0.05698f
C886 a_9465_2050# a_9886_2410# 0.09016f
C887 digital_0._116_.Q digital_0.rst 0.0844f
C888 LELO_GR01_0.x8.IBP_BG li_16034_17304# 2.71829f
C889 digital_0.hold28.A digital_0._114_.D 0.05847f
C890 a_3577_3138# clk 0.03012f
C891 digital_0.input2.X a_8729_412# 0.02991f
C892 digital_0.output13.A VDPWR 1.52648f
C893 digital_0._112_.Q a_13306_412# 0.05449f
C894 digital_0.clkbuf_1_0__f_clk.X uio_out<1> 0.23348f
C895 a_14157_962# a_15413_1260# 0.04359f
C896 a_14323_962# a_14673_1334# 0.2298f
C897 a_13481_1474# VDPWR 0.41625f
C898 a_18456_8709# LELO_GR01_0.x8.x1.x5.x8.G 0.08382f
C899 a_10089_n132# VDPWR 0.1421f
C900 a_12635_3171# digital_0._110_.Q 0.10396f
C901 digital_0._108_.RESET_B a_6337_2050# 0.29526f
C902 digital_0._069_.A a_10555_956# 0.09902f
C903 digital_0._116_.Q a_9005_956# 0.08964f
C904 digital_0.hold28.A a_12138_n702# 0.02815f
C905 a_8996_1500# digital_0._114_.Q 0.01113f
C906 a_9985_386# a_9810_412# 0.23366f
C907 a_7071_2018# VDPWR 0.21034f
C908 digital_0._114_.D a_9150_412# 0.17109f
C909 LELO_GR01_0.x8.VREF_BG a_24508_5627# 0.08035f
C910 LELO_GR01_0.x8.IBP_BG a_23138_6427# 0.07231f
C911 digital_0.rst rst_n 0.04656f
C912 a_15331_564# VDPWR 0.16987f
C913 a_7181_3926# a_7717_3926# 0.03302f
C914 digital_0._069_.A digital_0._108_.Q 0.21107f
C915 digital_0._069_.B digital_0.output13.A 0.06911f
C916 digital_0.load_slew15.X digital_0._109_.Q 0.3838f
C917 uio_in<1> uio_in<2> 0.03102f
C918 digital_0._116_.Q digital_0._113_.RESET_B 0.0903f
C919 digital_0._101_.RESET_B a_4477_2044# 0.0122f
C920 LELO_GR01_0.x7.x1.x5.x8.S a_6636_18610# 0.0331f
C921 a_4578_18940# LELO_GR01_0.x7.x18.D 0.07043f
C922 digital_0._112_.Q a_12225_1500# 0.61031f
C923 a_4386_2856# clk 0.04028f
C924 digital_0._114_.Q a_11673_412# 0.05501f
C925 a_3982_386# a_4118_412# 0.34236f
C926 LELO_GR01_0.x8.PWRUP_N_1V8 LELO_GR01_0.x7.x24.D 1.02091f
C927 a_10555_956# VDPWR 0.30113f
C928 a_13771_n126# a_14861_172# 0.04251f
C929 a_14339_n158# a_14121_246# 0.20964f
C930 a_7157_n158# a_7302_n132# 0.05722f
C931 a_3492_3650# a_3618_3834# 0.34134f
C932 a_15537_n426# VDPWR 0.38628f
C933 digital_0._101_.RESET_B digital_0._100_.D 0.02215f
C934 digital_0._069_.A a_6503_2050# 0.01885f
C935 LELO_GR01_0.x8.VREF_BG li_25094_17304# 0.06893f
C936 digital_0.clkbuf_1_0__f_clk.X clk 0.08283f
C937 digital_0._108_.Q VDPWR 0.7999f
C938 digital_0._112_.Q a_13481_386# 0.13799f
C939 a_14157_962# a_14673_1334# 0.11535f
C940 a_14323_962# a_14891_930# 0.18639f
C941 LELO_GR01_0.x8.PWRUP_N_1V8 LELO_GR01_0.x8.VREF_BG 0.1353f
C942 LELO_GR01_0.x7.x18.G a_16018_18750# 0.08612f
C943 digital_0._113_.RESET_B rst_n 0.01264f
C944 a_12741_1500# VDPWR 0.20453f
C945 digital_0._103_.RESET_B a_10641_3132# 0.01264f
C946 a_4093_3510# a_4201_3132# 0.05722f
C947 digital_0._067_.B digital_0._110_.Q 0.23129f
C948 digital_0.input3.X digital_0.hold23.X 0.40399f
C949 digital_0.clkbuf_1_1__f_clk.A a_11388_956# 0.31527f
C950 digital_0.hold28.A a_11898_n518# 0.02479f
C951 LELO_GR01_0.x8.x1.x7.D uio_out<5> 0.01237f
C952 a_8996_1500# a_10253_930# 0.02665f
C953 a_6503_2050# VDPWR 0.52701f
C954 a_8729_412# a_9150_412# 0.08813f
C955 LELO_GR01_0.x8.VREF_BG a_24508_6427# 0.08053f
C956 digital_0.rst VDPWR 0.38967f
C957 a_7181_3926# digital_0._109_.D 0.15276f
C958 digital_0._069_.A a_6235_3106# 0.01502f
C959 digital_0._069_.B digital_0._108_.Q 0.09275f
C960 digital_0.load_slew15.X digital_0.output13.A 0.30872f
C961 digital_0._110_.Q a_11431_2382# 0.1842f
C962 digital_0._116_.Q a_12959_1742# 0.01673f
C963 a_7623_2830# a_7970_2588# 0.05116f
C964 digital_0._112_.Q digital_0._063_.B 0.19593f
C965 digital_0.output6.A a_3858_930# 0.2018f
C966 a_3982_386# digital_0._116_.SET_B 0.2124f
C967 a_3814_386# a_4118_412# 0.15326f
C968 a_4108_2840# clk 0.01158f
C969 digital_0._114_.Q digital_0._057_.D 0.1217f
C970 a_5834_2740# VDPWR 0.11935f
C971 LELO_GR01_0.x8.PWRUP_N_1V8 a_2478_11860# 0.08228f
C972 LELO_GR01_0.x7.x18.G a_11988_13420# 0.09528f
C973 a_9005_956# VDPWR 0.37849f
C974 a_13605_n126# a_14686_246# 0.10236f
C975 a_14339_n158# digital_0._105_.RESET_B 0.17615f
C976 a_13771_n126# a_14121_246# 0.21772f
C977 a_6962_n16# a_7302_n132# 0.03462f
C978 digital_0._069_.A a_6337_2050# 0.20455f
C979 digital_0._110_.D a_11949_3132# 0.21477f
C980 LELO_GR01_0.x8.VREF_BG li_20574_17304# 0.62391f
C981 LELO_GR01_0.PWRUP_1V8 li_19474_13804# 0.14344f
C982 a_3743_3138# uo_out<1> 0.01728f
C983 a_6235_3106# VDPWR 0.20377f
C984 digital_0._112_.Q a_12741_412# 0.02968f
C985 a_14157_962# a_14891_930# 0.06944f
C986 a_12688_18980# LELO_GR01_0.PWRUP_1V8 0.0709f
C987 a_4578_18140# a_4578_18000# 0.11733f
C988 LELO_GR01_0.x8.PWRUP_N_1V8 a_6636_17810# 0.08178f
C989 LELO_GR01_0.x7.x18.G a_12688_18180# 0.04612f
C990 digital_0._113_.RESET_B VDPWR 0.51311f
C991 digital_0._115_.Q a_7643_n702# 0.10048f
C992 digital_0.output12.A uio_out<7> 0.15834f
C993 a_4311_3106# a_4201_3132# 0.09774f
C994 digital_0._067_.A digital_0._110_.Q 0.02392f
C995 digital_0._067_.B a_12635_3171# 0.02078f
C996 digital_0.hold28.A a_11772_n702# 0.02315f
C997 a_8996_1500# a_9930_930# 0.01168f
C998 digital_0.output6.A ui_in<0> 0.05109f
C999 a_9463_654# a_9810_412# 0.05116f
C1000 a_6337_2050# VDPWR 0.49299f
C1001 digital_0.input3.X a_15537_n132# 0.0498f
C1002 digital_0._113_.Q a_14026_234# 0.02109f
C1003 LELO_GR01_0.x7.x23.D a_2478_11060# 0.01256f
C1004 a_14990_386# VDPWR 0.23307f
C1005 digital_0.load_slew15.X digital_0._108_.Q 0.39674f
C1006 uio_in<0> uio_in<1> 0.03102f
C1007 digital_0.input1.X digital_0._065_.A2_N 0.08836f
C1008 digital_0.hold28.A digital_0._104_.RESET_B 0.12906f
C1009 digital_0._116_.Q a_12391_1500# 0.46975f
C1010 a_7055_2588# a_7970_2588# 0.11669f
C1011 LELO_GR01_0.x8.x8.D digital_0.pwr 0.01602f
C1012 digital_0._112_.Q a_11397_1750# 0.07183f
C1013 digital_0.load_slew17.X digital_0.input2.X 1.43539f
C1014 a_2478_12370# VDPWR 0.36615f
C1015 a_3821_2562# clk 0.01558f
C1016 digital_0._114_.Q a_10997_386# 0.03347f
C1017 a_5144_2954# VDPWR 0.0873f
C1018 a_9734_16126# a_9734_15874# 0.05415f
C1019 LELO_GR01_0.x7.x1.x5.IBN a_9734_15074# 0.03188f
C1020 a_13605_n126# a_14861_172# 0.04359f
C1021 digital_0._107_.D a_7720_n132# 0.15794f
C1022 a_13771_n126# digital_0._105_.RESET_B 0.0568f
C1023 digital_0._069_.A a_5787_2146# 0.13005f
C1024 digital_0._116_.Q digital_0.output6.A 0.35713f
C1025 digital_0.input1.X digital_0._113_.Q 0.06947f
C1026 LELO_GR01_0.x8.VREF_BG li_16034_17304# 1.30777f
C1027 digital_0.hold19.X uo_out<1> 0.3563f
C1028 a_4658_3510# VDPWR 0.29919f
C1029 digital_0._112_.Q digital_0._112_.RESET_B 0.1416f
C1030 a_14157_962# a_14323_962# 0.88854f
C1031 a_6407_1188# digital_0.hold28.X 0.13591f
C1032 LELO_GR01_0.x7.x18.G LELO_GR01_0.PWRUP_1V8 0.70727f
C1033 digital_0._057_.D a_12903_206# 0.18216f
C1034 a_12959_1742# VDPWR 0.21177f
C1035 digital_0._115_.Q digital_0.hold26.X 0.28428f
C1036 digital_0.output12.A uo_out<0> 0.08734f
C1037 a_3743_3138# a_4201_3132# 0.03462f
C1038 digital_0.load_slew15.X a_5834_2740# 0.01145f
C1039 digital_0.hold28.A a_11361_n702# 0.04551f
C1040 a_8996_1500# a_9690_1194# 0.01771f
C1041 digital_0.input2.X digital_0._115_.Q 0.05497f
C1042 digital_0.output6.A a_6209_386# 0.29721f
C1043 a_5787_2146# VDPWR 0.30415f
C1044 a_8895_412# a_9810_412# 0.12532f
C1045 digital_0._113_.Q a_12116_n132# 0.02856f
C1046 LELO_GR01_0.x7.x7.G a_11988_13420# 0.01283f
C1047 a_14750_570# VDPWR 0.21886f
C1048 digital_0.load_slew15.X a_6235_3106# 0.11514f
C1049 a_6889_2588# a_7970_2588# 0.10236f
C1050 digital_0.hold28.A digital_0.load_slew17.X 0.38972f
C1051 digital_0._116_.Q digital_0._113_.D 0.02084f
C1052 a_7055_2588# a_8145_2562# 0.04176f
C1053 a_7623_2830# a_7405_2588# 0.20964f
C1054 LELO_GR01_0.x8.x1.x5.x8.S LELO_GR01_0.x8.PWRUP_N_1V8 0.82429f
C1055 a_4111_1474# a_4369_1474# 0.22264f
C1056 LELO_GR01_0.x7.x23.D VDPWR 0.46956f
C1057 a_3814_386# a_3982_386# 0.10799f
C1058 a_4726_2954# VDPWR 0.14415f
C1059 a_14358_16750# a_14358_16610# 0.11733f
C1060 LELO_GR01_0.x7.x1.x5.IBN a_9734_15874# 0.03039f
C1061 a_13771_n126# a_14339_n158# 0.18517f
C1062 a_13605_n126# a_14121_246# 0.11535f
C1063 digital_0._107_.RESET_B a_7302_n132# 0.0122f
C1064 a_14175_n702# VDPWR 0.21324f
C1065 digital_0._069_.A digital_0.output6.A 0.05638f
C1066 digital_0._101_.RESET_B a_4425_2730# 0.01698f
C1067 a_6853_2422# a_6961_2044# 0.05722f
C1068 LELO_GR01_0.PWRUP_1V8 li_16454_13804# 0.1614f
C1069 digital_0._112_.Q a_12959_654# 0.01855f
C1070 digital_0._115_.RESET_B a_7786_412# 0.2207f
C1071 a_4833_3436# VDPWR 0.41403f
C1072 digital_0.hold24.X uio_out<2> 0.06138f
C1073 a_5486_1334# digital_0.hold28.X 0.01419f
C1074 a_3577_3138# uo_out<1> 0.04554f
C1075 LELO_GR01_0.x7.x18.G a_4578_18000# 0.02741f
C1076 digital_0._057_.D a_11758_188# 0.05684f
C1077 a_12391_1500# VDPWR 0.31755f
C1078 LELO_GR01_0.x7.x15.I1 LELO_GR01_0.x7.x28.e 0.05397f
C1079 a_7302_n132# VDPWR 0.1421f
C1080 digital_0._067_.A digital_0._067_.B 0.0927f
C1081 digital_0.clkbuf_1_0__f_clk.X digital_0._118_.RESET_B 0.02881f
C1082 digital_0.input1.X a_6758_2410# 0.01933f
C1083 digital_0.hold28.A digital_0._115_.Q 0.67138f
C1084 digital_0.hold28.A a_11103_n702# 0.06614f
C1085 a_24508_6687# VDPWR 0.40196f
C1086 a_8996_1500# a_9564_930# 0.01256f
C1087 digital_0.input2.X digital_0._060_.A_N 0.15931f
C1088 digital_0._104_.RESET_B a_15238_1334# 0.24255f
C1089 a_9463_654# a_9245_412# 0.20964f
C1090 digital_0.output6.A VDPWR 2.29583f
C1091 a_8895_412# a_9985_386# 0.04251f
C1092 digital_0._113_.Q a_11673_n132# 0.02112f
C1093 a_14624_386# VDPWR 0.2165f
C1094 digital_0._105_.D a_13746_n524# 0.08812f
C1095 ui_in<7> uio_in<0> 0.03102f
C1096 a_6889_2588# a_8145_2562# 0.04359f
C1097 digital_0._116_.Q a_12225_1500# 0.03354f
C1098 a_7055_2588# a_7405_2588# 0.21686f
C1099 LELO_GR01_0.x7.x1.x5.x3.S LELO_GR01_0.x8.PWRUP_N_1V8 0.01138f
C1100 a_4578_18940# LELO_GR01_0.x7.x6<3>.G 0.04269f
C1101 digital_0.load_slew17.X a_8996_1500# 0.04199f
C1102 a_2478_13170# VDPWR 0.36634f
C1103 digital_0._114_.Q a_9985_386# 0.12191f
C1104 LELO_GR01_0.x8.PWRUP_N_1V8 a_7536_12960# 0.0713f
C1105 LELO_GR01_0.x7.x15.I2 a_14358_16610# 0.03213f
C1106 a_13605_n126# digital_0._105_.RESET_B 0.32663f
C1107 a_7157_n158# a_7720_n132# 0.04983f
C1108 digital_0.hold27.X VDPWR 0.27305f
C1109 a_7643_n702# uio_out<7> 0.02375f
C1110 digital_0._110_.Q digital_0.input1.X 0.46751f
C1111 a_7071_2018# a_6961_2044# 0.09774f
C1112 digital_0._112_.Q a_12391_412# 0.54816f
C1113 digital_0.hold28.A uio_out<6> 1.10116f
C1114 digital_0._115_.RESET_B a_7961_386# 0.2717f
C1115 a_4093_3510# VDPWR 0.20326f
C1116 digital_0.hold24.X uio_out<3> 0.04052f
C1117 a_5661_1260# digital_0.hold28.X 0.06227f
C1118 digital_0.clkbuf_1_0__f_clk.X uo_out<1> 0.99683f
C1119 LELO_GR01_0.x8.PWRUP_N_1V8 LELO_GR01_0.PWRUP_1V8 1.33517f
C1120 LELO_GR01_0.x7.x18.D a_4578_18000# 0.0784f
C1121 digital_0._113_.D VDPWR 0.34082f
C1122 a_12626_n676# a_12737_n676# 0.34134f
C1123 a_4093_3510# a_4189_3510# 0.01379f
C1124 digital_0.clkbuf_1_0__f_clk.X digital_0._101_.RESET_B 0.03102f
C1125 digital_0.clkbuf_1_0__f_clk.X a_4571_962# 0.01387f
C1126 digital_0.hold28.A digital_0._060_.A_N 0.319f
C1127 a_14298_1652# digital_0.hold23.X 0.0633f
C1128 digital_0.hold28.A a_11007_n524# 0.06789f
C1129 LELO_GR01_0.x8.x7.D VDPWR 0.9076f
C1130 digital_0.input2.X a_7155_930# 0.02385f
C1131 digital_0._104_.RESET_B a_15413_1260# 0.27961f
C1132 digital_0.output13.A a_3858_n702# 0.20929f
C1133 a_4477_2044# VDPWR 0.13355f
C1134 a_8729_412# a_9810_412# 0.10236f
C1135 a_8895_412# a_9245_412# 0.21986f
C1136 LELO_GR01_0.x7.x7.S a_4578_10610# 0.04269f
C1137 LELO_GR01_0.x7.x15.I2 LELO_GR01_0.x7.x28.e 0.20671f
C1138 a_13306_412# VDPWR 0.27608f
C1139 digital_0.load_slew15.X a_4833_3436# 0.02484f
C1140 digital_0.output4.A digital_0.output13.A 0.98451f
C1141 digital_0._100_.RESET_B digital_0._117_.RESET_B 0.0533f
C1142 a_6889_2588# a_7405_2588# 0.1152f
C1143 digital_0._116_.Q digital_0._063_.B 0.03106f
C1144 a_7055_2588# a_7623_2830# 0.18122f
C1145 LELO_GR01_0.x7.x1.x5.x8.S LELO_GR01_0.x8.PWRUP_N_1V8 0.68241f
C1146 a_4015_1652# a_4111_1474# 0.41909f
C1147 digital_0._060_.A_N a_9150_412# 0.01017f
C1148 digital_0._100_.D VDPWR 0.4864f
C1149 LELO_GR01_0.x8.PWRUP_N_1V8 a_7536_13760# 0.06872f
C1150 LELO_GR01_0.x7.x6<3>.G a_4578_12470# 0.17387f
C1151 LELO_GR01_0.x7.x18.G a_14358_13930# 0.07778f
C1152 digital_0._060_.B VDPWR 0.8894f
C1153 a_6962_n16# a_7720_n132# 0.06418f
C1154 digital_0._105_.D a_13771_n126# 0.26638f
C1155 a_13605_n126# a_14339_n158# 0.06944f
C1156 a_7157_n158# a_7467_234# 0.01379f
C1157 li_19474_13804# li_26594_13804# 0.01047f
C1158 digital_0.load_slew15.X digital_0.output6.A 0.03649f
C1159 a_6503_2050# a_6961_2044# 0.03462f
C1160 LELO_GR01_0.PWRUP_1V8 li_20574_17304# 0.11512f
C1161 digital_0._112_.Q a_12225_412# 0.03217f
C1162 digital_0.hold28.A uio_out<5> 0.12857f
C1163 digital_0.hold23.X a_14578_1322# 0.01201f
C1164 digital_0._115_.RESET_B a_7221_412# 0.16061f
C1165 a_4311_3106# VDPWR 0.20609f
C1166 digital_0._063_.A a_11673_412# 0.01783f
C1167 digital_0.load_slew17.X digital_0._057_.D 0.08998f
C1168 LELO_GR01_0.x7.x18.D a_2478_17610# 0.01495f
C1169 digital_0._057_.D a_10721_172# 0.0192f
C1170 a_12225_1500# VDPWR 0.40328f
C1171 a_9886_234# VDPWR 0.08243f
C1172 digital_0.clkload0.A digital_0._102_.D 0.10539f
C1173 digital_0._109_.RESET_B a_7349_3132# 0.0171f
C1174 a_4093_3510# a_3998_3498# 0.04983f
C1175 digital_0.load_slew15.A digital_0._114_.RESET_B 0.46709f
C1176 digital_0.clkload0.A digital_0._104_.D 0.01129f
C1177 digital_0.clkbuf_1_0__f_clk.X a_4405_962# 0.27099f
C1178 digital_0.hold28.A a_7155_930# 0.07444f
C1179 LELO_GR01_0.x8.x1.x7.D uio_out<4> 0.0368f
C1180 a_14298_1652# digital_0._104_.D 0.11042f
C1181 digital_0.hold28.A a_10066_n524# 0.37603f
C1182 a_24508_7487# VDPWR 0.4909f
C1183 digital_0._104_.RESET_B a_14673_1334# 0.15622f
C1184 digital_0.output13.A a_3618_n518# 0.01024f
C1185 digital_0.load_slew17.X a_15225_n702# 0.04269f
C1186 LELO_GR01_0.x8.x4.G uio_out<5> 0.01224f
C1187 a_8895_412# a_9463_654# 0.17589f
C1188 a_8729_412# a_9985_386# 0.04359f
C1189 LELO_GR01_0.x7.x15.I2 LELO_GR01_0.x7.x15.I1 6.22f
C1190 a_13481_386# VDPWR 0.40136f
C1191 digital_0.output12.A a_8361_n676# 0.18503f
C1192 digital_0._116_.Q digital_0.hold19.X 0.16979f
C1193 digital_0.hold25.X digital_0._117_.RESET_B 0.03177f
C1194 ui_in<6> ui_in<7> 0.03102f
C1195 digital_0._101_.RESET_B a_4934_2422# 0.24076f
C1196 a_6889_2588# a_7623_2830# 0.07009f
C1197 digital_0._069_.A digital_0._063_.B 0.07845f
C1198 digital_0._116_.Q a_11397_1750# 0.11782f
C1199 digital_0._067_.A a_10721_2348# 0.01082f
C1200 digital_0.output13.A digital_0._119_.RESET_B 0.02817f
C1201 digital_0.load_slew17.X digital_0.clkbuf_1_1__f_clk.A 0.03332f
C1202 a_4512_2954# VDPWR 0.21031f
C1203 LELO_GR01_0.x7.x18.G a_14358_14730# 0.07579f
C1204 LELO_GR01_0.x7.x15.I2 a_14358_16750# 0.03211f
C1205 LELO_GR01_0.x7.x1.x7.D a_11996_16042# 0.04055f
C1206 LELO_GR01_0.x7.x21.D a_2478_14990# 0.07916f
C1207 a_7826_956# VDPWR 0.38831f
C1208 a_13605_n126# a_13771_n126# 0.88354f
C1209 a_7001_110# a_7720_n132# 0.08638f
C1210 digital_0.pwr uio_out<6> 0.0126f
C1211 a_10017_3138# a_10074_2562# 0.01118f
C1212 digital_0.clkload0.A digital_0._065_.A2_N 0.47362f
C1213 digital_0._067_.B digital_0.input1.X 0.06946f
C1214 digital_0._108_.Q a_7310_2588# 0.03535f
C1215 digital_0.hold28.A digital_0._110_.RESET_B 0.01111f
C1216 digital_0._118_.RESET_B digital_0.hold28.X 0.01443f
C1217 a_10721_2348# a_10546_2422# 0.23366f
C1218 LELO_GR01_0.PWRUP_1V8 li_16034_17304# 0.91109f
C1219 digital_0._116_.Q digital_0._112_.RESET_B 0.16563f
C1220 a_4921_1334# a_5029_956# 0.05722f
C1221 digital_0._112_.Q digital_0.clkload0.X 0.05079f
C1222 digital_0.hold28.A uio_out<7> 0.24136f
C1223 digital_0._104_.D a_14578_1322# 0.15816f
C1224 digital_0._115_.RESET_B a_7439_654# 0.16793f
C1225 a_3743_3138# VDPWR 0.5824f
C1226 digital_0._063_.A digital_0._057_.D 0.03085f
C1227 LELO_GR01_0.x8.PWRUP_N_1V8 a_2478_17610# 0.07797f
C1228 LELO_GR01_0.x7.x18.G a_4578_18140# 0.02747f
C1229 digital_0._063_.B VDPWR 0.114f
C1230 a_12409_n676# a_12626_n676# 0.11296f
C1231 digital_0.clkload0.A a_13513_3138# 0.24455f
C1232 a_11273_3436# digital_0._067_.A 0.08334f
C1233 digital_0.load_slew15.X digital_0._100_.D 0.02447f
C1234 digital_0._116_.Q digital_0._114_.RESET_B 0.21966f
C1235 digital_0.clkload0.A digital_0._113_.Q 0.5049f
C1236 digital_0.clkbuf_1_0__f_clk.X a_3858_930# 0.05881f
C1237 digital_0.hold28.A a_6761_930# 0.35896f
C1238 digital_0.input1.X a_11431_2382# 0.04179f
C1239 LELO_GR01_0.x8.x1.x7.D uio_out<2> 0.01731f
C1240 LELO_GR01_0.x8.x1.x5.IBN uio_out<1> 0.06217f
C1241 digital_0.hold28.A a_9417_n702# 0.03595f
C1242 a_23138_6685# VDPWR 0.40004f
C1243 digital_0.input2.X a_6503_930# 0.01481f
C1244 digital_0.clkbuf_1_1__f_clk.A digital_0._115_.Q 0.01221f
C1245 digital_0._104_.RESET_B a_14891_930# 0.17107f
C1246 digital_0.load_slew17.X a_14967_n702# 0.07019f
C1247 a_8729_412# a_9245_412# 0.10687f
C1248 digital_0._113_.Q a_12116_188# 0.1402f
C1249 a_12741_412# VDPWR 0.18813f
C1250 digital_0.output12.A a_7214_n524# 0.03686f
C1251 digital_0.load_slew17.A digital_0.hold24.X 0.22808f
C1252 a_12829_3676# digital_0.hold28.A 0.01518f
C1253 a_5215_3676# a_4833_3436# 0.01164f
C1254 digital_0.hold25.X digital_0._100_.RESET_B 0.20198f
C1255 uo_out<0> uio_in<7> 0.03102f
C1256 digital_0._101_.RESET_B a_5109_2348# 0.33823f
C1257 a_6889_2588# a_7055_2588# 0.85951f
C1258 digital_0._069_.A a_11397_1750# 0.03427f
C1259 a_2478_13680# VDPWR 0.36615f
C1260 digital_0.load_slew17.X a_6315_1474# 0.02845f
C1261 digital_0._115_.D a_6871_412# 0.2732f
C1262 digital_0.hold23.X a_15331_564# 0.13052f
C1263 digital_0._060_.A_N digital_0._057_.D 0.0102f
C1264 digital_0.load_slew17.X a_14121_246# 0.04828f
C1265 a_4581_2825# VDPWR 0.21157f
C1266 LELO_GR01_0.x7.x18.G a_12688_13928# 0.05702f
C1267 a_7099_956# VDPWR 0.47681f
C1268 a_13605_n126# digital_0._105_.D 0.16659f
C1269 digital_0._107_.RESET_B a_7720_n132# 0.01778f
C1270 digital_0.pwr uio_out<5> 0.32017f
C1271 digital_0.clkload0.A a_10074_2562# 0.02183f
C1272 digital_0._118_.RESET_B a_5029_956# 0.0122f
C1273 a_5139_930# a_5029_956# 0.09774f
C1274 digital_0._115_.RESET_B a_6871_412# 0.05004f
C1275 digital_0.clkbuf_1_0__f_clk.X ui_in<0> 0.10867f
C1276 digital_0.load_slew17.X a_9810_412# 0.01685f
C1277 digital_0.hold19.X VDPWR 0.61914f
C1278 LELO_GR01_0.x7.x19.D a_2478_17610# 0.07959f
C1279 LELO_GR01_0.x8.PWRUP_N_1V8 a_6636_18610# 0.07579f
C1280 LELO_GR01_0.x7.x18.G a_12688_18980# 0.05114f
C1281 LELO_GR01_0.x7.x18.D a_4578_18140# 0.07839f
C1282 digital_0._057_.D digital_0._106_.RESET_B 0.1952f
C1283 a_11397_1750# VDPWR 0.39039f
C1284 a_7720_n132# VDPWR 0.08228f
C1285 digital_0.clkload0.A a_12889_3171# 0.06293f
C1286 a_11273_3436# a_11098_3510# 0.23366f
C1287 a_3743_3138# a_3998_3498# 0.06418f
C1288 digital_0.clkbuf_1_0__f_clk.X a_3618_1194# 0.05232f
C1289 digital_0.hold28.A a_6503_930# 0.06312f
C1290 digital_0.input1.X a_10546_2422# 0.07247f
C1291 LELO_GR01_0.x8.x1.x7.D uio_out<3> 0.08931f
C1292 digital_0._113_.RESET_B a_14727_1474# 0.05845f
C1293 digital_0.hold28.A a_9151_n702# 0.07162f
C1294 a_23138_7485# VDPWR 0.49026f
C1295 digital_0.input2.X a_6407_1188# 0.01252f
C1296 a_6315_1474# digital_0._115_.Q 0.01213f
C1297 digital_0.clkbuf_1_1__f_clk.A digital_0._060_.A_N 0.01683f
C1298 digital_0._104_.RESET_B a_14323_962# 0.03186f
C1299 digital_0.load_slew17.X a_14871_n524# 0.06502f
C1300 a_8729_412# a_9463_654# 0.05348f
C1301 digital_0._114_.D a_8895_412# 0.22225f
C1302 LELO_GR01_0.x8.IBP_BG LELO_GR01_0.x8.x7.D 0.01913f
C1303 LELO_GR01_0.x7.x7.S a_4578_11410# 0.06641f
C1304 LELO_GR01_0.x8.PWRUP_N_1V8 a_24510_4435# 0.07045f
C1305 digital_0._112_.RESET_B VDPWR 0.49432f
C1306 digital_0.output12.A a_6793_n676# 0.06985f
C1307 digital_0.output8.A digital_0._111_.Q 0.01689f
C1308 a_12718_3676# digital_0.hold28.A 0.04305f
C1309 digital_0._116_.Q digital_0.clkbuf_1_0__f_clk.X 0.85211f
C1310 ui_in<5> ui_in<6> 0.03102f
C1311 uio_out<0> uo_out<7> 0.04002f
C1312 digital_0._101_.RESET_B a_4369_2422# 0.15328f
C1313 digital_0._110_.D a_12094_2588# 0.16124f
C1314 LELO_GR01_0.x7.x22.D VDPWR 0.47437f
C1315 digital_0.output13.A a_4005_n158# 0.01555f
C1316 digital_0.hold28.A digital_0._106_.D 0.03543f
C1317 digital_0._115_.D a_6705_412# 0.17271f
C1318 digital_0.hold23.X digital_0.rst 0.04694f
C1319 digital_0._060_.A_N a_10997_386# 0.11444f
C1320 digital_0.load_slew17.X digital_0._105_.RESET_B 0.37488f
C1321 a_4425_2730# VDPWR 0.48484f
C1322 LELO_GR01_0.x7.x18.G a_12688_14728# 0.03598f
C1323 LELO_GR01_0.x7.x1.x5.x9<2>.G a_9734_15074# 0.07821f
C1324 LELO_GR01_0.x7.x1.x7.D LELO_GR01_0.x7.x15.I2 0.05291f
C1325 digital_0._080_.A2 uo_out<0> 0.154f
C1326 digital_0._115_.D ui_in<0> 0.04405f
C1327 digital_0._114_.RESET_B VDPWR 0.28577f
C1328 digital_0._107_.D digital_0.output12.A 0.13431f
C1329 a_24508_5627# a_24510_5235# 0.03228f
C1330 li_16454_13804# li_19474_13804# 0.58797f
C1331 li_25094_17304# li_26594_13804# 0.04731f
C1332 a_6853_2422# a_6949_2422# 0.01379f
C1333 a_10199_2018# a_10546_2422# 0.05116f
C1334 a_4571_962# a_5029_956# 0.02761f
C1335 a_10253_930# digital_0._114_.Q 0.16072f
C1336 a_3577_3138# VDPWR 0.45692f
C1337 digital_0.hold28.A uio_out<1> 0.01888f
C1338 digital_0._115_.RESET_B a_6705_412# 0.32383f
C1339 digital_0._113_.Q digital_0._112_.D 0.16698f
C1340 digital_0.load_slew17.X a_9985_386# 0.01558f
C1341 LELO_GR01_0.x7.x6<3>.G a_4578_18000# 0.06102f
C1342 digital_0._118_.D uio_out<1> 0.11305f
C1343 digital_0._115_.RESET_B ui_in<0> 0.06503f
C1344 a_12138_n702# a_12409_n676# 0.14228f
C1345 digital_0.clkload0.A digital_0._110_.Q 0.30798f
C1346 digital_0._103_.D a_10438_3498# 0.18336f
C1347 digital_0._109_.D a_6906_3132# 0.02492f
C1348 digital_0.hold19.X a_3998_3498# 0.16052f
C1349 digital_0.clkbuf_1_0__f_clk.X a_3492_930# 0.04552f
C1350 digital_0.input1.X a_10721_2348# 0.06197f
C1351 a_13481_1474# digital_0._113_.Q 0.09983f
C1352 digital_0._113_.RESET_B digital_0.hold23.X 0.05674f
C1353 digital_0.hold28.A a_8689_n676# 0.05519f
C1354 digital_0.hold22.X a_4921_1334# 0.02302f
C1355 digital_0.input2.X a_5486_1334# 0.0145f
C1356 a_6315_1474# digital_0._060_.A_N 0.02403f
C1357 digital_0._104_.RESET_B a_14157_962# 0.30695f
C1358 digital_0.load_slew17.X a_14323_962# 0.02513f
C1359 digital_0._114_.Q a_12903_206# 0.08777f
C1360 a_8729_412# a_8895_412# 0.72771f
C1361 LELO_GR01_0.x7.x23.D LELO_GR01_0.x7.x24.D 0.57215f
C1362 a_2478_12370# a_2478_11860# 0.02417f
C1363 LELO_GR01_0.x8.PWRUP_N_1V8 a_24510_5235# 0.07874f
C1364 a_12959_654# VDPWR 0.20326f
C1365 digital_0.output11.A digital_0.output10.A 0.16386f
C1366 digital_0.output12.A a_6687_n676# 0.10114f
C1367 a_12501_3676# digital_0.hold28.A 0.07923f
C1368 digital_0._101_.RESET_B a_4587_2018# 0.16612f
C1369 digital_0.input1.X a_6889_2588# 0.257f
C1370 digital_0._116_.Q digital_0._115_.RESET_B 0.12965f
C1371 a_2478_14480# VDPWR 0.36633f
C1372 digital_0._065_.A2_N a_10555_956# 0.05724f
C1373 digital_0.hold23.X a_14990_386# 0.16949f
C1374 a_9930_930# a_8895_412# 0.01331f
C1375 digital_0._060_.A_N a_9810_412# 0.04191f
C1376 digital_0.load_slew17.X a_14339_n158# 0.02229f
C1377 a_4386_2856# VDPWR 0.58636f
C1378 digital_0.input2.X a_8689_n132# 0.09274f
C1379 LELO_GR01_0.x7.x6<3>.G a_4578_13270# 0.1739f
C1380 LELO_GR01_0.x7.x1.x5.x9<2>.G a_9734_15874# 0.07742f
C1381 digital_0.pwr uo_out<0> 0.01965f
C1382 a_11273_3436# digital_0.input1.X 0.0102f
C1383 digital_0.output4.A digital_0.output6.A 0.11904f
C1384 a_9631_2050# a_10546_2422# 0.12499f
C1385 a_6853_2422# a_6758_2410# 0.04983f
C1386 LELO_GR01_0.x8.PWRUP_N_1V8 li_19474_13804# 0.21502f
C1387 digital_0.clkbuf_1_0__f_clk.X VDPWR 3.2398f
C1388 digital_0.hold28.A clk 0.12393f
C1389 digital_0._113_.Q a_10555_956# 0.03678f
C1390 LELO_GR01_0.x7.x18.D LELO_GR01_0.x7.x18.G 2.45274f
C1391 a_9985_386# a_9981_246# 0.01024f
C1392 LELO_GR01_0.x7.x25.S a_2478_8440# 0.07365f
C1393 LELO_GR01_0.x8.x8.D a_23824_9183# 0.01319f
C1394 a_18456_9509# a_18456_8709# 0.0149f
C1395 a_10751_3106# a_11098_3510# 0.05116f
C1396 digital_0.load_slew15.X a_4425_2730# 0.03433f
C1397 a_3577_3138# a_3998_3498# 0.09313f
C1398 digital_0.input1.X a_9981_2422# 0.03365f
C1399 digital_0._118_.RESET_B digital_0.hold22.X 0.01385f
C1400 LELO_GR01_0.x8.x1.x5.IBN uio_out<2> 0.16593f
C1401 digital_0._113_.RESET_B digital_0._104_.D 0.14716f
C1402 LELO_GR01_0.x8.x1.x5.x9<2>.G uio_out<1> 0.2636f
C1403 digital_0.hold28.A a_8578_n676# 0.05586f
C1404 digital_0.input2.X a_5661_1260# 0.01355f
C1405 a_6315_1474# a_7155_930# 0.01392f
C1406 digital_0.load_slew17.X a_14157_962# 0.02587f
C1407 a_8729_412# digital_0._114_.D 0.21987f
C1408 digital_0._113_.RESET_B a_15537_n132# 0.15506f
C1409 digital_0._114_.Q a_11758_188# 0.09812f
C1410 a_4274_2410# VDPWR 0.07993f
C1411 LELO_GR01_0.x7.x23.D a_2478_11860# 0.04931f
C1412 LELO_GR01_0.x8.PWRUP_N_1V8 a_19356_4659# 0.07971f
C1413 a_12391_412# VDPWR 0.25666f
C1414 digital_0.output12.A a_6451_n676# 0.32309f
C1415 digital_0.output4.A a_4093_3510# 0.02057f
C1416 digital_0.output8.A digital_0.hold28.A 0.21345f
C1417 ui_in<4> ui_in<5> 0.03102f
C1418 digital_0._101_.RESET_B a_4019_2050# 0.02526f
C1419 digital_0._116_.Q a_5785_1750# 0.09599f
C1420 LELO_GR01_0.x7.x7.G li_8044_11904# 0.10918f
C1421 LELO_GR01_0.x7.x7.S VDPWR 0.2479f
C1422 digital_0.hold23.X a_14750_570# 0.02874f
C1423 digital_0._060_.A_N a_9985_386# 0.0923f
C1424 digital_0.load_slew17.X a_13771_n126# 0.44761f
C1425 a_4108_2840# VDPWR 0.30131f
C1426 LELO_GR01_0.x7.x18.G LELO_GR01_0.x7.x7.G 1.11899f
C1427 a_11996_16842# LELO_GR01_0.x7.x1.x7.D 0.01242f
C1428 LELO_GR01_0.x7.x1.x5.x9<2>.G a_7886_15060# 0.09093f
C1429 digital_0.hold28.X ui_in<0> 0.0359f
C1430 digital_0._115_.D VDPWR 0.3415f
C1431 a_10495_n702# VDPWR 0.22031f
C1432 digital_0.pwr uio_out<1> 0.47664f
C1433 digital_0._109_.Q a_8145_2562# 0.10309f
C1434 a_10199_2018# a_9981_2422# 0.20964f
C1435 a_9465_2050# a_10546_2422# 0.10236f
C1436 a_9631_2050# a_10721_2348# 0.04206f
C1437 digital_0.clkbuf_1_0__f_clk.X a_5855_564# 0.02045f
C1438 a_4921_1334# a_5017_1334# 0.01379f
C1439 digital_0.hold24.X VDPWR 0.33129f
C1440 a_5486_1334# digital_0._080_.A2 0.04226f
C1441 LELO_GR01_0.x8.PWRUP_N_1V8 LELO_GR01_0.x7.x18.G 1.91932f
C1442 digital_0._115_.RESET_B VDPWR 0.3818f
C1443 a_8996_1500# clk 0.32451f
C1444 a_7214_n524# digital_0.hold26.X 0.11101f
C1445 digital_0.output10.A a_15537_n426# 0.01849f
C1446 a_4910_n132# VDPWR 0.14291f
C1447 a_11898_n518# a_12138_n702# 0.11296f
C1448 a_10183_3138# a_11098_3510# 0.12532f
C1449 digital_0.load_slew15.X a_4386_2856# 0.01351f
C1450 digital_0.input1.X a_10199_2018# 0.04358f
C1451 digital_0._116_.Q digital_0.hold28.X 0.43768f
C1452 LELO_GR01_0.x8.x1.x5.IBN uio_out<3> 0.01379f
C1453 digital_0._113_.RESET_B digital_0._113_.Q 0.06051f
C1454 digital_0.hold28.A a_8361_n676# 0.07922f
C1455 digital_0.hold22.X a_4571_962# 0.03825f
C1456 digital_0.input2.X a_4921_1334# 0.01082f
C1457 a_6315_1474# a_6761_930# 0.02203f
C1458 LELO_GR01_0.x8.x4.G uio_out<4> 0.05842f
C1459 digital_0._114_.Q a_10546_246# 0.01523f
C1460 a_4934_2422# VDPWR 0.28302f
C1461 a_14358_14870# a_14358_14730# 0.11733f
C1462 LELO_GR01_0.x7.x7.G a_11318_13928# 0.08487f
C1463 LELO_GR01_0.x8.VREF_BG LELO_GR01_0.x8.x7.D 0.39898f
C1464 LELO_GR01_0.x8.PWRUP_N_1V8 a_19356_5459# 0.07091f
C1465 a_12225_412# VDPWR 0.44153f
C1466 digital_0._107_.D a_7643_n702# 0.02881f
C1467 digital_0.output12.A a_5974_n676# 0.0263f
C1468 a_14415_3650# a_14673_3650# 0.22264f
C1469 a_12189_3650# digital_0.hold28.A 0.04232f
C1470 digital_0.load_slew15.X digital_0.clkbuf_1_0__f_clk.X 0.19843f
C1471 digital_0.hold28.A a_14762_2018# 0.01966f
C1472 a_12517_2044# a_12977_2044# 0.04637f
C1473 digital_0.hold23.X a_14624_386# 0.02107f
C1474 digital_0._060_.A_N a_9245_412# 0.04713f
C1475 digital_0.load_slew17.X digital_0._105_.D 0.04227f
C1476 a_3821_2562# VDPWR 0.42018f
C1477 LELO_GR01_0.x7.x18.D LELO_GR01_0.x7.x7.G 0.51952f
C1478 LELO_GR01_0.x7.x1.x5.IBN LELO_GR01_0.x7.x15.I2 0.85196f
C1479 a_8336_16210# a_7886_15860# 0.01328f
C1480 digital_0.pwr clk 0.7848f
C1481 digital_0.hold21.X VDPWR 0.29451f
C1482 a_12737_n676# uio_out<6> 0.10738f
C1483 digital_0.hold28.A a_7786_412# 0.0176f
C1484 a_9631_2050# a_9981_2422# 0.21963f
C1485 a_9465_2050# a_10721_2348# 0.04358f
C1486 a_6503_2050# a_6758_2410# 0.06121f
C1487 LELO_GR01_0.x8.PWRUP_N_1V8 li_16454_13804# 0.14051f
C1488 digital_0.clkbuf_1_0__f_clk.X a_5218_778# 0.01624f
C1489 a_4921_1334# a_4826_1322# 0.04983f
C1490 LELO_GR01_0.x7.x19.D LELO_GR01_0.x7.x18.G 0.09695f
C1491 LELO_GR01_0.x7.x6<3>.G a_4578_18140# 0.061f
C1492 LELO_GR01_0.x8.PWRUP_N_1V8 LELO_GR01_0.x7.x18.D 0.42659f
C1493 a_5785_1750# VDPWR 0.45212f
C1494 a_6793_n676# digital_0.hold26.X 0.13552f
C1495 digital_0.output12.A ui_in<0> 0.01916f
C1496 a_10183_3138# a_11273_3436# 0.04251f
C1497 a_10751_3106# a_10533_3510# 0.20964f
C1498 digital_0.hold28.A digital_0._108_.D 0.26157f
C1499 a_10017_3138# a_11098_3510# 0.10236f
C1500 a_12189_2588# a_12285_2588# 0.01379f
C1501 digital_0.input1.X a_9631_2050# 0.5984f
C1502 digital_0._118_.RESET_B digital_0.input2.X 0.03142f
C1503 a_15634_1474# digital_0.input3.X 0.21856f
C1504 a_12741_1500# a_12837_1500# 0.01379f
C1505 digital_0.hold28.A a_7214_n524# 0.31818f
C1506 digital_0.hold22.X a_4405_962# 0.03637f
C1507 digital_0.input2.X a_5139_930# 0.01388f
C1508 a_6315_1474# a_6503_930# 0.02551f
C1509 digital_0.load_slew17.X digital_0._114_.Q 0.33859f
C1510 digital_0._063_.A a_11388_956# 0.15277f
C1511 a_5109_2348# VDPWR 0.4074f
C1512 LELO_GR01_0.x7.x7.S a_4578_11670# 0.06807f
C1513 digital_0.clkload0.X VDPWR 0.30522f
C1514 digital_0._107_.D digital_0.hold26.X 0.2083f
C1515 a_11673_n132# a_12116_n132# 0.02551f
C1516 digital_0.output4.A a_3743_3138# 0.03979f
C1517 a_11835_3828# digital_0.hold20.X 0.13551f
C1518 digital_0.load_slew17.A a_11415_3650# 0.04186f
C1519 a_10986_3828# digital_0._111_.Q 0.19245f
C1520 a_11931_3650# digital_0.hold28.A 0.07125f
C1521 uo_out<1> uo_out<2> 0.04012f
C1522 ui_in<3> ui_in<4> 0.03102f
C1523 digital_0._101_.RESET_B a_3853_2050# 0.29551f
C1524 digital_0.load_slew15.X digital_0._115_.RESET_B 0.01898f
C1525 a_14358_15670# VDPWR 0.4124f
C1526 digital_0._116_.Q digital_0.output12.A 0.0318f
C1527 digital_0.load_slew17.X a_13605_n126# 0.07514f
C1528 digital_0._060_.A_N a_9463_654# 0.02268f
C1529 LELO_GR01_0.x8.PWRUP_N_1V8 LELO_GR01_0.x7.x7.G 0.02474f
C1530 LELO_GR01_0.x7.x1.x5.x9<2>.G a_7886_15860# 0.0438f
C1531 LELO_GR01_0.x7.x1.x5.IBN LELO_GR01_0.x7.x1.x7.D 0.76824f
C1532 digital_0.hold28.X VDPWR 0.72346f
C1533 digital_0.pwr uio_out<4> 1.36703f
C1534 a_12626_n676# uio_out<6> 0.0305f
C1535 a_9631_2050# a_10199_2018# 0.17589f
C1536 a_6337_2050# a_6758_2410# 0.08657f
C1537 a_9465_2050# a_9981_2422# 0.11067f
C1538 LELO_GR01_0.x7.x18.G li_16034_17304# 0.0114f
C1539 a_9690_1194# a_9930_930# 0.11296f
C1540 digital_0.hold28.A uio_out<3> 0.0234f
C1541 a_4921_1334# digital_0._080_.A2 0.02998f
C1542 digital_0._109_.RESET_B clk 0.06624f
C1543 LELO_GR01_0.x7.x19.D LELO_GR01_0.x7.x18.D 0.52197f
C1544 digital_0.clkbuf_1_1__f_clk.A clk 0.08325f
C1545 digital_0.input2.X uo_out<1> 0.03619f
C1546 a_9985_386# a_9631_n126# 0.01571f
C1547 digital_0._113_.Q a_14175_n702# 0.10119f
C1548 a_11772_n702# a_11898_n518# 0.34134f
C1549 a_10183_3138# a_10533_3510# 0.2298f
C1550 digital_0.hold28.A digital_0._118_.RESET_B 0.0236f
C1551 a_10017_3138# a_11273_3436# 0.04348f
C1552 digital_0.input1.X a_9465_2050# 0.85093f
C1553 LELO_GR01_0.x8.x1.x5.x9<2>.G uio_out<2> 0.18851f
C1554 LELO_GR01_0.x8.x1.x5.x8.G uio_out<1> 0.02644f
C1555 a_23816_7741# VDPWR 0.51142f
C1556 digital_0.input2.X a_4571_962# 0.05857f
C1557 digital_0._063_.A digital_0._114_.Q 0.33693f
C1558 digital_0.load_slew17.X a_10253_930# 0.03163f
C1559 digital_0.output9.A a_15413_1260# 0.1187f
C1560 a_6315_1474# a_6407_1188# 0.01183f
C1561 digital_0._114_.Q a_9981_246# 0.01244f
C1562 a_4369_2422# VDPWR 0.20033f
C1563 LELO_GR01_0.x8.x4.G uio_out<3> 0.06264f
C1564 a_11318_14728# LELO_GR01_0.x7.x7.G 0.07043f
C1565 digital_0.output7.A a_14673_3650# 0.33721f
C1566 a_14319_3828# a_14415_3650# 0.41909f
C1567 digital_0.output4.A digital_0.hold19.X 0.13728f
C1568 digital_0.load_slew17.A digital_0._111_.Q 0.0457f
C1569 a_11835_3828# digital_0.hold28.A 0.06142f
C1570 a_10986_3828# digital_0.hold20.X 0.0578f
C1571 uo_out<1> uio_in<7> 0.01524f
C1572 a_6263_2562# digital_0.input1.X 0.0576f
C1573 digital_0.hold28.A digital_0._112_.Q 0.12694f
C1574 digital_0._116_.Q a_5159_1474# 0.04967f
C1575 a_12688_14988# VDPWR 0.40785f
C1576 digital_0.hold28.A digital_0._107_.D 0.33909f
C1577 digital_0.load_slew17.X a_12903_206# 0.02868f
C1578 digital_0.hold28.X a_5855_564# 0.02464f
C1579 digital_0._060_.A_N a_8895_412# 0.05119f
C1580 LELO_GR01_0.x7.x18.G a_14358_14870# 0.07585f
C1581 LELO_GR01_0.x7.x1.x5.x8.G a_7886_15060# 0.08329f
C1582 a_4696_n132# a_4910_n132# 0.09774f
C1583 a_5029_956# VDPWR 0.13345f
C1584 digital_0._114_.Q uio_out<6> 0.02456f
C1585 li_20574_17304# li_25094_17304# 0.16156f
C1586 digital_0.pwr uio_out<2> 1.08732f
C1587 a_12409_n676# uio_out<6> 0.0247f
C1588 digital_0._108_.Q a_7405_2588# 0.01667f
C1589 digital_0.load_slew15.X a_5109_2348# 0.02273f
C1590 a_9465_2050# a_10199_2018# 0.05348f
C1591 LELO_GR01_0.x8.PWRUP_N_1V8 li_20574_17304# 0.1665f
C1592 digital_0.output13.A a_3814_386# 0.02643f
C1593 digital_0._118_.RESET_B digital_0._080_.A2 0.0312f
C1594 digital_0.load_slew17.X a_8729_412# 0.01028f
C1595 a_4571_962# a_4826_1322# 0.05936f
C1596 a_5139_930# digital_0._080_.A2 0.0192f
C1597 digital_0._060_.A_N digital_0._114_.Q 0.41411f
C1598 LELO_GR01_0.x7.x19.D LELO_GR01_0.x8.PWRUP_N_1V8 1.01963f
C1599 a_2478_18410# LELO_GR01_0.x7.x18.D 0.03962f
C1600 LELO_GR01_0.x7.x6<3>.G LELO_GR01_0.x7.x18.G 2.42153f
C1601 digital_0.hold22.X ui_in<0> 0.03205f
C1602 digital_0._118_.D uo_out<1> 0.02319f
C1603 digital_0._113_.Q digital_0.hold27.X 0.29726f
C1604 a_2478_9240# LELO_GR01_0.x7.x25.S 0.04279f
C1605 a_23824_9983# LELO_GR01_0.x8.x8.D 0.0403f
C1606 digital_0.output10.A a_14175_n702# 0.05543f
C1607 digital_0.output12.A VDPWR 0.83044f
C1608 a_10183_3138# a_10751_3106# 0.18639f
C1609 digital_0.hold28.A digital_0._101_.RESET_B 0.07022f
C1610 a_10017_3138# a_10533_3510# 0.11053f
C1611 a_6889_2588# a_7593_2348# 0.0117f
C1612 digital_0.input1.X a_7418_2422# 0.0583f
C1613 digital_0.load_slew15.X digital_0.hold28.X 0.10298f
C1614 digital_0._118_.D a_4571_962# 0.22412f
C1615 LELO_GR01_0.x8.x1.x5.x9<2>.G uio_out<3> 0.01563f
C1616 a_15394_1658# a_15634_1474# 0.11296f
C1617 digital_0._113_.D digital_0._113_.Q 0.13305f
C1618 LELO_GR01_0.x8.x1.x7.D VDPWR 7.25077f
C1619 digital_0.input2.X a_4405_962# 0.05903f
C1620 digital_0.load_slew17.X a_9930_930# 0.22317f
C1621 digital_0._114_.Q digital_0._106_.RESET_B 0.02897f
C1622 a_4587_2018# VDPWR 0.20903f
C1623 digital_0.load_slew17.A digital_0.hold20.X 0.30012f
C1624 a_10986_3828# digital_0.hold28.A 0.31844f
C1625 digital_0.output7.A a_14415_3650# 0.09919f
C1626 digital_0.output4.A a_3577_3138# 0.04107f
C1627 uo_out<1> uio_in<6> 0.01524f
C1628 ui_in<2> ui_in<3> 0.02544f
C1629 digital_0._116_.Q digital_0.hold22.X 0.02396f
C1630 digital_0.clkload0.A a_9981_2422# 0.01894f
C1631 a_14358_15810# VDPWR 0.4122f
C1632 a_14137_3132# VDPWR 0.13238f
C1633 digital_0.load_slew17.X a_11758_188# 0.10776f
C1634 digital_0._060_.A_N digital_0._114_.D 0.2278f
C1635 LELO_GR01_0.x7.x1.x5.IBN a_9734_16126# 0.03033f
C1636 a_4765_n158# a_4910_n132# 0.05722f
C1637 digital_0.pwr uio_out<3> 0.78988f
C1638 a_12138_n702# uio_out<6> 0.02493f
C1639 digital_0.output13.A a_7055_2588# 0.01416f
C1640 digital_0._116_.Q digital_0._101_.D 0.03774f
C1641 digital_0.clkload0.A digital_0.input1.X 0.16048f
C1642 a_9465_2050# a_9631_2050# 0.58439f
C1643 LELO_GR01_0.x8.PWRUP_N_1V8 li_16034_17304# 0.06617f
C1644 a_9564_930# a_9690_1194# 0.34134f
C1645 digital_0._112_.Q a_11673_412# 0.15246f
C1646 a_4405_962# a_4826_1322# 0.08968f
C1647 a_4571_962# digital_0._080_.A2 0.54622f
C1648 digital_0._109_.D clk 0.04646f
C1649 LELO_GR01_0.x7.x6<3>.G LELO_GR01_0.x7.x18.D 3.48833f
C1650 a_2478_18410# LELO_GR01_0.x8.PWRUP_N_1V8 0.08598f
C1651 a_5159_1474# VDPWR 0.19046f
C1652 digital_0._114_.Q a_10066_n524# 0.19386f
C1653 digital_0.output10.A digital_0.hold27.X 0.26256f
C1654 a_10017_3138# a_10751_3106# 0.07009f
C1655 a_12189_2588# a_12297_2954# 0.05722f
C1656 digital_0.input1.X a_7593_2348# 0.06177f
C1657 digital_0._118_.D a_4405_962# 0.28146f
C1658 LELO_GR01_0.x8.x8.D uio_out<6> 0.09672f
C1659 a_23816_8541# VDPWR 0.46053f
C1660 digital_0.load_slew17.X a_9690_1194# 0.02336f
C1661 digital_0._114_.Q a_10199_n158# 0.01652f
C1662 a_4019_2050# VDPWR 0.26374f
C1663 digital_0.load_slew17.A digital_0.hold28.A 0.74228f
C1664 digital_0.output7.A a_14319_3828# 0.08742f
C1665 digital_0.output4.A digital_0.clkbuf_1_0__f_clk.X 0.11998f
C1666 a_10986_3828# digital_0._103_.D 0.08235f
C1667 uo_out<1> uio_in<5> 0.01524f
C1668 a_12688_15788# VDPWR 0.48955f
C1669 digital_0.clkbuf_1_0__f_clk.X a_4609_110# 0.26295f
C1670 digital_0._060_.A_N a_8729_412# 0.0892f
C1671 digital_0._063_.A a_11758_188# 0.19905f
C1672 digital_0.load_slew17.X a_10546_246# 0.05733f
C1673 digital_0.input3.X a_15685_386# 0.05386f
C1674 digital_0._113_.Q a_13481_386# 0.01298f
C1675 digital_0.hold23.X digital_0._112_.RESET_B 0.03501f
C1676 LELO_GR01_0.x7.x6<3>.G LELO_GR01_0.x7.x7.G 0.18658f
C1677 LELO_GR01_0.x7.x1.x5.x8.G a_7886_15860# 0.11889f
C1678 a_4570_n16# a_4910_n132# 0.03462f
C1679 a_6397_n158# digital_0.output12.A 0.12593f
C1680 a_10721_172# a_10546_246# 0.23366f
C1681 LELO_GR01_0.x8.IBP_BG a_17850_3465# 0.03645f
C1682 li_16034_17304# li_20574_17304# 0.53964f
C1683 digital_0.pwr uo_out<1> 0.11286f
C1684 a_11898_n518# uio_out<6> 0.02962f
C1685 digital_0._108_.Q a_7055_2588# 0.05336f
C1686 digital_0.output13.A a_6889_2588# 0.03125f
C1687 digital_0._065_.A2_N digital_0._063_.B 0.07695f
C1688 digital_0.hold28.A a_6871_412# 0.03561f
C1689 digital_0.clkbuf_1_0__f_clk.X digital_0._116_.D 0.06069f
C1690 a_11415_3650# VDPWR 0.15332f
C1691 a_4405_962# digital_0._080_.A2 0.05298f
C1692 LELO_GR01_0.x7.x6<3>.G LELO_GR01_0.x8.PWRUP_N_1V8 0.15085f
C1693 a_2478_18410# LELO_GR01_0.x7.x19.D 0.0428f
C1694 digital_0.input2.X ui_in<0> 0.6795f
C1695 digital_0.hold22.X VDPWR 0.85729f
C1696 a_5328_n132# VDPWR 0.08367f
C1697 digital_0.output4.A a_4108_2840# 0.01871f
C1698 a_10017_3138# a_10183_3138# 0.90596f
C1699 digital_0._108_.D a_6315_1474# 0.01566f
C1700 digital_0._110_.RESET_B a_12297_2954# 0.0122f
C1701 a_12189_2588# a_12094_2588# 0.04983f
C1702 digital_0.input1.X a_6853_2422# 0.0523f
C1703 digital_0._118_.D a_3858_930# 0.04095f
C1704 LELO_GR01_0.x8.x1.x5.x8.G uio_out<2> 0.03449f
C1705 a_15268_1474# a_15394_1658# 0.34134f
C1706 digital_0._063_.B digital_0._113_.Q 0.11351f
C1707 a_12741_1500# a_12849_1866# 0.05722f
C1708 LELO_GR01_0.x8.x1.x5.x9<2>.G uio_out<0> 0.26511f
C1709 LELO_GR01_0.x7.x15.I1 uio_out<1> 0.01153f
C1710 LELO_GR01_0.x8.x8.D uio_out<5> 0.03472f
C1711 digital_0.load_slew17.X a_9564_930# 0.0197f
C1712 digital_0._101_.D VDPWR 0.51353f
C1713 digital_0._114_.Q a_9631_n126# 0.03081f
C1714 LELO_GR01_0.x7.x15.I2 a_14358_9800# 0.05314f
C1715 digital_0._114_.D uio_out<7> 0.04697f
C1716 digital_0._069_.A digital_0._111_.Q 0.5148f
C1717 digital_0.output5.A a_3743_3138# 0.02964f
C1718 digital_0.load_slew17.A digital_0._103_.D 0.05237f
C1719 uo_out<1> uio_in<4> 0.01524f
C1720 digital_0._116_.Q digital_0.input2.X 0.28045f
C1721 digital_0.load_slew15.X a_5159_1474# 0.0143f
C1722 digital_0._110_.D a_11839_2588# 0.28168f
C1723 digital_0.clkload0.A a_9631_2050# 0.0398f
C1724 a_11318_14986# VDPWR 0.40021f
C1725 digital_0._112_.Q digital_0.clkbuf_1_1__f_clk.A 0.01425f
C1726 digital_0.hold28.A a_6962_n16# 0.02877f
C1727 digital_0.load_slew17.X a_10721_172# 0.07847f
C1728 digital_0.input3.X a_15427_386# 0.09301f
C1729 digital_0._112_.RESET_B a_15537_n132# 0.01612f
C1730 digital_0._106_.RESET_B a_11758_188# 0.01207f
C1731 a_7643_n702# VDPWR 0.20871f
C1732 digital_0.pwr uio_out<0> 0.19138f
C1733 a_11772_n702# uio_out<6> 0.01904f
C1734 a_6906_3132# a_7349_3132# 0.03064f
C1735 digital_0._108_.Q a_6889_2588# 0.20914f
C1736 digital_0.output13.A digital_0.input1.X 0.1634f
C1737 digital_0._065_.A2_N a_11397_1750# 0.23515f
C1738 digital_0.hold28.A a_6705_412# 0.02955f
C1739 digital_0._110_.RESET_B a_12977_2044# 0.15239f
C1740 digital_0.clkbuf_1_0__f_clk.X a_4746_412# 0.02823f
C1741 digital_0._117_.RESET_B clk 0.02723f
C1742 digital_0._112_.Q a_10997_386# 0.21804f
C1743 digital_0._111_.Q VDPWR 0.92926f
C1744 digital_0.hold28.A ui_in<0> 0.10389f
C1745 digital_0.hold22.X a_5855_564# 0.13052f
C1746 a_11103_n702# a_11361_n702# 0.22264f
C1747 a_5974_n676# a_5785_n426# 0.06801f
C1748 digital_0.output4.A a_3821_2562# 0.02787f
C1749 digital_0._110_.Q a_12225_1500# 0.01233f
C1750 a_12407_2830# a_12297_2954# 0.09774f
C1751 digital_0.input1.X a_7071_2018# 0.04904f
C1752 digital_0._118_.D a_3618_1194# 0.04847f
C1753 digital_0.load_slew17.X digital_0._115_.Q 0.02243f
C1754 digital_0._116_.Q a_5868_n676# 0.0126f
C1755 digital_0._113_.RESET_B a_12849_1866# 0.0122f
C1756 a_12741_1500# a_12646_1500# 0.04983f
C1757 digital_0.output6.A a_3982_386# 0.01037f
C1758 LELO_GR01_0.x8.x1.x5.IBN VDPWR 0.20525f
C1759 LELO_GR01_0.x8.x8.D uio_out<7> 0.12253f
C1760 digital_0.hold28.X a_4570_n16# 0.21957f
C1761 a_3853_2050# VDPWR 0.43673f
C1762 LELO_GR01_0.x8.IBP_BG LELO_GR01_0.x8.x1.x7.D 0.34321f
C1763 a_10721_172# a_11103_n702# 0.01537f
C1764 digital_0.output11.A a_11673_n132# 0.01364f
C1765 a_13978_3650# digital_0.output7.A 0.19817f
C1766 digital_0.output5.A digital_0.hold19.X 0.14207f
C1767 digital_0._116_.Q digital_0.hold28.A 0.54222f
C1768 digital_0.load_slew17.A digital_0._103_.RESET_B 0.19207f
C1769 uo_out<1> uio_in<3> 0.01524f
C1770 digital_0.load_slew15.X digital_0.hold22.X 0.10557f
C1771 digital_0._110_.D a_11673_2588# 0.16707f
C1772 digital_0.clkload0.A a_9465_2050# 0.03523f
C1773 digital_0._116_.Q digital_0._118_.D 0.02374f
C1774 digital_0.load_slew15.A a_8996_1500# 0.10404f
C1775 digital_0.hold28.A a_7001_110# 0.03327f
C1776 a_11318_15786# VDPWR 0.49163f
C1777 digital_0._063_.A digital_0.load_slew17.X 0.09461f
C1778 digital_0.load_slew15.X a_5328_n132# 0.01888f
C1779 digital_0.load_slew17.X a_9981_246# 0.04534f
C1780 digital_0.input3.X a_15331_564# 0.06382f
C1781 digital_0._113_.Q digital_0._112_.RESET_B 0.03559f
C1782 digital_0.input2.X digital_0._107_.RESET_B 0.08188f
C1783 digital_0._119_.RESET_B a_4910_n132# 0.0122f
C1784 digital_0._114_.D a_9151_n702# 0.11686f
C1785 digital_0._080_.A2 ui_in<0> 0.04989f
C1786 digital_0._106_.RESET_B a_10546_246# 0.23197f
C1787 digital_0.hold26.X VDPWR 0.20799f
C1788 digital_0.pwr ui_in<1> 0.04222f
C1789 a_11772_n702# uio_out<5> 0.09496f
C1790 a_11361_n702# uio_out<6> 0.03713f
C1791 digital_0._108_.Q digital_0.input1.X 0.36036f
C1792 digital_0.clkload0.A a_13513_956# 0.05786f
C1793 digital_0._110_.RESET_B a_12517_2044# 0.01901f
C1794 digital_0.clkbuf_1_0__f_clk.X a_4610_386# 0.04855f
C1795 digital_0._100_.RESET_B clk 0.05988f
C1796 digital_0.hold28.A rst_n 0.01542f
C1797 digital_0.hold20.X VDPWR 0.20866f
C1798 digital_0.hold22.X a_5218_778# 0.01608f
C1799 digital_0._080_.A2 digital_0.hold18.X 0.03079f
C1800 digital_0.input2.X VDPWR 1.21475f
C1801 digital_0.hold18.X a_5785_n426# 0.02809f
C1802 digital_0.clkload0.A a_10017_3138# 0.25364f
C1803 digital_0.output8.A digital_0._110_.D 0.10382f
C1804 a_11839_2588# a_12297_2954# 0.03462f
C1805 digital_0.input1.X a_6503_2050# 0.66507f
C1806 digital_0._116_.Q digital_0._080_.A2 0.29289f
C1807 a_12929_2562# a_12754_2588# 0.23366f
C1808 digital_0._118_.D a_3492_930# 0.05418f
C1809 LELO_GR01_0.x8.x8.D uo_out<0> 0.44755f
C1810 digital_0.load_slew17.X digital_0._060_.A_N 0.10855f
C1811 a_12959_1742# a_12849_1866# 0.09774f
C1812 digital_0._116_.Q a_5785_n426# 0.05027f
C1813 a_21554_8625# VDPWR 0.01509f
C1814 digital_0.hold28.X a_4609_110# 0.2739f
C1815 digital_0._114_.Q a_9465_n126# 0.02565f
C1816 LELO_GR01_0.x7.x7.S a_4578_12470# 0.0891f
C1817 a_9353_778# VDPWR 0.14218f
C1818 digital_0._069_.A digital_0.hold28.A 0.2176f
C1819 digital_0.output5.A a_3577_3138# 0.03934f
C1820 uo_out<1> uio_in<2> 0.01524f
C1821 digital_0.load_slew15.A a_8085_1500# 0.23464f
C1822 digital_0._116_.Q a_8996_1500# 0.22559f
C1823 digital_0.hold28.A digital_0._107_.RESET_B 0.02622f
C1824 digital_0.clkload0.A a_12646_412# 0.01378f
C1825 digital_0.load_slew17.X digital_0._106_.RESET_B 0.40971f
C1826 digital_0.input3.X digital_0.rst 0.07436f
C1827 a_2478_15790# LELO_GR01_0.x7.x21.D 0.04278f
C1828 a_4826_1322# VDPWR 0.07905f
C1829 a_10199_n158# a_10546_246# 0.05116f
C1830 digital_0._106_.RESET_B a_10721_172# 0.33297f
C1831 LELO_GR01_0.x8.x7.D a_24510_4435# 0.01356f
C1832 digital_0.pwr ui_in<0> 4.48662f
C1833 a_11361_n702# uio_out<5> 0.1379f
C1834 a_11103_n702# uio_out<6> 0.05255f
C1835 a_6179_3132# a_6906_3132# 0.02551f
C1836 a_14029_3510# a_14137_3132# 0.05722f
C1837 a_7593_2348# a_7418_2422# 0.23366f
C1838 digital_0.clkbuf_1_0__f_clk.X a_4438_386# 0.80511f
C1839 digital_0.hold25.X clk 0.05023f
C1840 digital_0.hold28.A VDPWR 9.41114f
C1841 digital_0._060_.A_N digital_0._115_.Q 0.51122f
C1842 digital_0._080_.A2 a_5422_n702# 0.0249f
C1843 digital_0.load_slew17.X uio_out<5> 0.0255f
C1844 digital_0._118_.D VDPWR 0.47254f
C1845 a_11007_n524# a_11103_n702# 0.41909f
C1846 digital_0._117_.RESET_B digital_0._108_.D 0.02801f
C1847 a_11839_2588# a_12094_2588# 0.06418f
C1848 digital_0.input1.X a_6337_2050# 0.88302f
C1849 digital_0._116_.Q a_15238_1334# 0.02502f
C1850 digital_0.load_slew17.X a_7155_930# 0.02391f
C1851 digital_0._113_.RESET_B digital_0.input3.X 0.31841f
C1852 a_12391_1500# a_12849_1866# 0.02761f
C1853 LELO_GR01_0.x8.x1.x5.x8.G uio_out<0> 0.20302f
C1854 LELO_GR01_0.x8.x4.G VDPWR 0.3846f
C1855 LELO_GR01_0.x7.x15.I2 a_14358_10600# 0.03227f
C1856 a_9150_412# VDPWR 0.08232f
C1857 digital_0.load_slew15.A digital_0._109_.RESET_B 0.2238f
C1858 a_13738_3834# a_13978_3650# 0.11296f
C1859 digital_0.output5.A digital_0.clkbuf_1_0__f_clk.X 0.10018f
C1860 uo_out<1> uio_in<1> 0.01524f
C1861 digital_0.load_slew15.X digital_0.input2.X 0.51945f
C1862 digital_0.load_slew15.A digital_0.clkbuf_1_1__f_clk.A 0.33672f
C1863 digital_0._116_.Q a_8085_1500# 0.02437f
C1864 digital_0.load_slew17.X a_10199_n158# 0.04773f
C1865 digital_0._112_.D a_13513_956# 0.17222f
C1866 digital_0.input3.X a_14990_386# 0.0449f
C1867 a_9734_16926# LELO_GR01_0.x7.x1.x5.IBN 0.01243f
C1868 LELO_GR01_0.x7.x20.D a_2478_14990# 0.01256f
C1869 LELO_GR01_0.x7.x18.G LELO_GR01_0.x7.x23.D 0.0959f
C1870 digital_0._080_.A2 VDPWR 1.31753f
C1871 a_9631_n126# a_10546_246# 0.12532f
C1872 a_4765_n158# a_5328_n132# 0.04983f
C1873 digital_0._106_.RESET_B a_9981_246# 0.15327f
C1874 LELO_GR01_0.x8.x7.D a_24510_5235# 0.03877f
C1875 digital_0.pwr rst_n 0.37242f
C1876 a_5785_n426# VDPWR 0.22024f
C1877 a_11103_n702# uio_out<5> 0.06594f
C1878 a_11007_n524# uio_out<6> 0.05652f
C1879 digital_0._102_.RESET_B a_14137_3132# 0.01854f
C1880 digital_0.output13.A a_6263_2562# 0.03576f
C1881 digital_0.clkbuf_1_0__f_clk.X a_4530_626# 0.37684f
C1882 LELO_GR01_0.x8.x1.x5.x3.S a_19706_7559# 0.03706f
C1883 digital_0._103_.D VDPWR 0.46708f
C1884 a_7155_930# digital_0._115_.Q 0.42751f
C1885 a_8996_1500# VDPWR 1.26622f
C1886 digital_0._116_.D digital_0.output12.A 0.02365f
C1887 a_12741_412# a_12837_412# 0.01379f
C1888 digital_0._117_.RESET_B digital_0._118_.RESET_B 0.02389f
C1889 a_11673_2588# a_12094_2588# 0.08638f
C1890 digital_0._110_.RESET_B a_12754_2588# 0.23011f
C1891 digital_0.input1.X a_5787_2146# 0.029f
C1892 digital_0._116_.Q a_15413_1260# 0.01544f
C1893 digital_0._112_.Q a_14157_962# 0.01995f
C1894 LELO_GR01_0.x7.x15.I1 uio_out<3> 0.05552f
C1895 a_12391_1500# a_12646_1500# 0.05639f
C1896 digital_0._113_.RESET_B a_15634_1474# 0.05421f
C1897 LELO_GR01_0.x8.x1.x5.x9<2>.G VDPWR 0.02384f
C1898 digital_0._112_.D a_12646_412# 0.18319f
C1899 LELO_GR01_0.x8.IBP_BG LELO_GR01_0.x8.x1.x5.IBN 1.0986f
C1900 LELO_GR01_0.x8.VREF_BG LELO_GR01_0.x8.x1.x7.D 0.2748f
C1901 LELO_GR01_0.x7.x15.I2 a_14358_10740# 0.03225f
C1902 a_11673_412# VDPWR 0.37188f
C1903 digital_0.load_slew15.A a_7717_3926# 0.05053f
C1904 digital_0._116_.Q digital_0._109_.RESET_B 0.14924f
C1905 digital_0.load_slew15.X digital_0.hold28.A 0.39788f
C1906 uo_out<1> uio_in<0> 0.01524f
C1907 uio_out<5> uio_out<6> 4.65114f
C1908 digital_0._116_.Q digital_0.clkbuf_1_1__f_clk.A 0.51145f
C1909 digital_0._116_.Q a_14861_172# 0.03126f
C1910 digital_0.input3.X a_14750_570# 0.03824f
C1911 digital_0.load_slew17.X a_9631_n126# 0.34377f
C1912 LELO_GR01_0.x8.PWRUP_N_1V8 a_2478_12370# 0.07785f
C1913 LELO_GR01_0.x7.x1.x5.x9<2>.G a_9734_16126# 0.07793f
C1914 a_15238_1334# VDPWR 0.29863f
C1915 a_9631_n126# a_10721_172# 0.04251f
C1916 a_4570_n16# a_5328_n132# 0.06121f
C1917 a_4765_n158# a_5075_234# 0.01379f
C1918 a_10199_n158# a_9981_246# 0.20964f
C1919 digital_0.pwr VDPWR 1.84062f
C1920 a_11007_n524# uio_out<5> 0.05566f
C1921 digital_0.output4.A a_4019_2050# 0.03374f
C1922 a_14247_3106# a_14137_3132# 0.09774f
C1923 digital_0._108_.Q a_6263_2562# 0.1333f
C1924 digital_0.clkload0.A digital_0._112_.D 0.19682f
C1925 digital_0.clkbuf_1_0__f_clk.X a_4118_412# 0.0356f
C1926 digital_0._108_.RESET_B a_6315_1474# 0.01182f
C1927 a_7071_2018# a_7418_2422# 0.05116f
C1928 a_7155_930# digital_0._060_.A_N 0.25649f
C1929 digital_0._103_.RESET_B VDPWR 0.44486f
C1930 a_15427_386# a_15685_386# 0.22264f
C1931 a_8085_1500# VDPWR 0.43254f
C1932 a_14686_246# VDPWR 0.29787f
C1933 digital_0.output5.A a_3821_2562# 0.11346f
C1934 digital_0.hold24.X a_12889_3171# 0.06547f
C1935 digital_0.hold28.A a_14594_3510# 0.04247f
C1936 digital_0._117_.RESET_B digital_0._101_.RESET_B 0.02368f
C1937 digital_0._110_.RESET_B a_12929_2562# 0.29183f
C1938 a_12407_2830# a_12754_2588# 0.05116f
C1939 digital_0._110_.D digital_0._112_.Q 0.01027f
C1940 digital_0.input1.X digital_0.output6.A 0.27898f
C1941 digital_0.load_slew15.X digital_0._080_.A2 0.28327f
C1942 LELO_GR01_0.x7.x25.S clk 0.06987f
C1943 digital_0._112_.Q a_11388_956# 0.03217f
C1944 digital_0.load_slew17.X a_6503_930# 0.01529f
C1945 a_13481_1474# a_14298_1652# 0.01071f
C1946 digital_0._113_.D a_12646_1500# 0.17079f
C1947 digital_0._113_.RESET_B a_15394_1658# 0.05524f
C1948 LELO_GR01_0.x7.x28.e uio_out<0> 0.04188f
C1949 LELO_GR01_0.x7.x15.I2 a_14358_11540# 0.03213f
C1950 digital_0._057_.D VDPWR 0.29805f
C1951 digital_0._116_.Q a_7717_3926# 0.09861f
C1952 digital_0._069_.A digital_0._109_.RESET_B 0.13826f
C1953 LELO_GR01_0.x8.IBP_BG a_26146_2651# 0.01369f
C1954 a_13612_3650# a_13738_3834# 0.34134f
C1955 uio_out<7> uio_out<6> 4.43788f
C1956 uo_out<1> ui_in<7> 0.01524f
C1957 digital_0._108_.Q a_7418_2422# 0.04376f
C1958 digital_0._069_.A digital_0.clkbuf_1_1__f_clk.A 0.17589f
C1959 digital_0._116_.Q a_6315_1474# 0.10023f
C1960 a_2478_14990# VDPWR 0.36615f
C1961 a_15445_2044# digital_0._104_.RESET_B 0.01053f
C1962 a_13934_3498# VDPWR 0.07761f
C1963 digital_0.input3.X a_14624_386# 0.12626f
C1964 digital_0.load_slew17.X digital_0._106_.D 0.02067f
C1965 digital_0._113_.Q digital_0.clkload0.X 0.01348f
C1966 LELO_GR01_0.x8.PWRUP_N_1V8 LELO_GR01_0.x7.x23.D 1.01794f
C1967 LELO_GR01_0.x7.x1.x5.x9<2>.G LELO_GR01_0.x7.x1.x5.IBN 0.95897f
C1968 a_15413_1260# VDPWR 0.42403f
C1969 a_9631_n126# a_9981_246# 0.21986f
C1970 a_9465_n126# a_10546_246# 0.10236f
C1971 a_4609_110# a_5328_n132# 0.08671f
C1972 digital_0._060_.A_N uio_out<7> 0.01067f
C1973 a_10199_n158# digital_0._106_.RESET_B 0.16611f
C1974 a_15225_n702# VDPWR 0.27651f
C1975 digital_0.output4.A digital_0._101_.D 0.07036f
C1976 a_13679_3138# a_14137_3132# 0.02761f
C1977 digital_0._069_.A a_10997_386# 0.15376f
C1978 digital_0.clkbuf_1_0__f_clk.X digital_0._116_.SET_B 0.10059f
C1979 a_6503_2050# a_7418_2422# 0.12532f
C1980 digital_0._109_.RESET_B VDPWR 0.34784f
C1981 a_14673_3650# uio_out<2> 0.01197f
C1982 digital_0._060_.A_N a_9417_n702# 0.21739f
C1983 digital_0.clkbuf_1_1__f_clk.A VDPWR 2.96746f
C1984 a_2478_9750# a_2478_9240# 0.02417f
C1985 a_14861_172# VDPWR 0.41248f
C1986 digital_0.hold24.X digital_0._110_.Q 0.27296f
C1987 digital_0.output13.A digital_0._109_.Q 0.65918f
C1988 digital_0.hold25.X digital_0._118_.RESET_B 0.23246f
C1989 digital_0._117_.RESET_B a_4201_3132# 0.0122f
C1990 a_11839_2588# a_12754_2588# 0.12532f
C1991 digital_0._110_.RESET_B a_12189_2588# 0.15328f
C1992 digital_0.clkload0.A a_12741_1500# 0.01233f
C1993 digital_0.load_slew17.X a_6407_1188# 0.01406f
C1994 digital_0._112_.Q digital_0._114_.Q 0.01919f
C1995 a_12225_1500# a_12646_1500# 0.08341f
C1996 a_13481_1474# a_13306_1500# 0.23366f
C1997 digital_0._113_.RESET_B a_15268_1474# 0.05822f
C1998 LELO_GR01_0.x7.x15.I1 uio_out<0> 0.82378f
C1999 digital_0._113_.D a_12116_n132# 0.11811f
C2000 LELO_GR01_0.x7.x7.S a_4578_13270# 0.0891f
C2001 a_10997_386# VDPWR 0.44744f
C2002 digital_0._069_.B digital_0._109_.RESET_B 0.05146f
C2003 LELO_GR01_0.x8.IBP_BG LELO_GR01_0.x8.x4.G 0.46232f
C2004 uio_out<7> uio_out<5> 7.98646f
C2005 uo_out<1> ui_in<6> 0.01524f
C2006 uo_out<0> uio_out<6> 3.09611f
C2007 digital_0._108_.Q a_7593_2348# 0.14941f
C2008 digital_0._116_.Q a_4730_1652# 0.04067f
C2009 digital_0.load_slew15.X a_8085_1500# 0.22875f
C2010 digital_0.output9.A digital_0._104_.RESET_B 0.01331f
C2011 a_11949_3132# VDPWR 0.41107f
C2012 digital_0.load_slew17.X a_9465_n126# 0.34076f
C2013 LELO_GR01_0.x8.PWRUP_N_1V8 a_2478_13170# 0.08238f
C2014 a_14673_1334# VDPWR 0.20848f
C2015 a_9465_n126# a_10721_172# 0.04359f
C2016 a_9631_n126# digital_0._106_.RESET_B 0.025f
C2017 LELO_GR01_0.x8.x7.D a_24508_5627# 0.03796f
C2018 a_24508_6687# a_24508_6427# 0.05215f
C2019 a_14967_n702# VDPWR 0.2813f
C2020 digital_0.output4.A a_3853_2050# 0.03999f
C2021 digital_0.clkbuf_1_0__f_clk.X a_3982_386# 0.05242f
C2022 digital_0.input1.X a_12225_1500# 0.2685f
C2023 a_6503_2050# a_7593_2348# 0.04251f
C2024 a_6337_2050# a_7418_2422# 0.10236f
C2025 a_7071_2018# a_6853_2422# 0.20964f
C2026 a_7717_3926# VDPWR 0.37235f
C2027 a_14415_3650# uio_out<2> 0.01559f
C2028 digital_0.load_slew17.X clk 0.02208f
C2029 a_3471_1474# uo_out<1> 0.01581f
C2030 a_15331_564# a_15427_386# 0.41909f
C2031 digital_0.rst a_15685_386# 0.01224f
C2032 digital_0._060_.A_N a_9151_n702# 0.05057f
C2033 a_6315_1474# VDPWR 1.29194f
C2034 digital_0._114_.D digital_0._107_.D 0.01863f
C2035 LELO_GR01_0.x7.x25.D a_2478_8440# 0.01257f
C2036 a_14121_246# VDPWR 0.19918f
C2037 digital_0.hold24.X a_12635_3171# 0.03924f
C2038 digital_0._108_.Q digital_0._109_.Q 0.45233f
C2039 digital_0.hold28.A a_14029_3510# 0.03014f
C2040 a_11673_2588# a_12754_2588# 0.10232f
C2041 a_11839_2588# a_12929_2562# 0.04251f
C2042 a_12407_2830# a_12189_2588# 0.20964f
C2043 digital_0.clkload0.A digital_0._113_.RESET_B 0.03427f
C2044 digital_0._112_.Q a_10253_930# 0.03684f
C2045 digital_0._113_.RESET_B a_14298_1652# 0.04992f
C2046 digital_0._063_.B a_12646_1500# 0.02188f
C2047 digital_0._060_.A_N digital_0._106_.D 0.0378f
C2048 LELO_GR01_0.x8.PWRUP_N_1V8 LELO_GR01_0.x8.x7.D 0.35809f
C2049 LELO_GR01_0.x8.VREF_BG LELO_GR01_0.x8.x1.x5.IBN 0.70178f
C2050 LELO_GR01_0.PWRUP_1V8 a_23816_7741# 0.07044f
C2051 LELO_GR01_0.x8.IBP_BG LELO_GR01_0.x8.x1.x5.x9<2>.G 0.07383f
C2052 a_9810_412# VDPWR 0.29391f
C2053 digital_0._069_.A digital_0._109_.D 0.24586f
C2054 digital_0.load_slew15.X digital_0._109_.RESET_B 0.13693f
C2055 LELO_GR01_0.x8.IBP_BG a_26146_3451# 0.03731f
C2056 uo_out<1> ui_in<5> 0.01524f
C2057 uo_out<0> uio_out<5> 0.03086f
C2058 clk ena 0.0466f
C2059 digital_0.load_slew15.X digital_0.clkbuf_1_1__f_clk.A 0.08471f
C2060 digital_0._116_.Q a_4369_1474# 0.03961f
C2061 digital_0.output4.A digital_0.input2.X 0.28315f
C2062 LELO_GR01_0.x7.x15.I2 uio_out<0> 0.01838f
C2063 LELO_GR01_0.x7.x21.D clk 0.08198f
C2064 a_14891_930# VDPWR 0.21146f
C2065 a_9631_n126# a_10199_n158# 0.17589f
C2066 a_9465_n126# a_9981_246# 0.11104f
C2067 LELO_GR01_0.x8.x7.D a_24508_6427# 0.03513f
C2068 a_14871_n524# VDPWR 0.17823f
C2069 digital_0._111_.Q a_11107_2562# 0.05623f
C2070 digital_0._109_.Q a_5834_2740# 0.02608f
C2071 LELO_GR01_0.x8.IBP_BG digital_0.pwr 0.85344f
C2072 digital_0.input1.X digital_0._063_.B 0.05111f
C2073 a_6337_2050# a_7593_2348# 0.04359f
C2074 a_6503_2050# a_6853_2422# 0.21907f
C2075 digital_0.hold22.X a_4610_386# 0.03025f
C2076 digital_0._109_.D VDPWR 0.37332f
C2077 a_14319_3828# uio_out<2> 0.01208f
C2078 digital_0.rst a_15427_386# 0.02787f
C2079 a_4730_1652# VDPWR 0.11178f
C2080 digital_0._105_.RESET_B VDPWR 0.52195f
C2081 a_6235_3106# digital_0._109_.Q 0.06913f
C2082 digital_0._108_.Q digital_0.output13.A 1.1935f
C2083 digital_0.hold28.A digital_0._102_.RESET_B 0.07102f
C2084 a_11673_2588# a_12929_2562# 0.04348f
C2085 a_12407_2830# digital_0._110_.RESET_B 0.16613f
C2086 a_11839_2588# a_12189_2588# 0.2298f
C2087 digital_0.clkload0.A a_12959_1742# 0.01114f
C2088 digital_0.load_slew17.X a_5661_1260# 0.02191f
C2089 digital_0._113_.RESET_B a_13306_1500# 0.21676f
C2090 LELO_GR01_0.x7.x15.I1 ui_in<0> 0.5098f
C2091 digital_0._060_.A_N a_9465_n126# 0.01437f
C2092 digital_0._080_.A2 a_4570_n16# 0.01547f
C2093 LELO_GR01_0.PWRUP_1V8 LELO_GR01_0.x8.x1.x7.D 0.31323f
C2094 a_9985_386# VDPWR 0.40703f
C2095 digital_0._106_.D a_10066_n524# 0.08019f
C2096 digital_0.output4.A digital_0.hold28.A 0.02309f
C2097 digital_0._069_.B digital_0._109_.D 0.31606f
C2098 LELO_GR01_0.x8.IBP_BG a_17850_2665# 0.01274f
C2099 digital_0._069_.A a_7181_3926# 0.10637f
C2100 uo_out<1> ui_in<4> 0.01524f
C2101 uo_out<0> uio_out<7> 2.74561f
C2102 digital_0.output4.A digital_0._118_.D 0.01499f
C2103 digital_0._108_.Q a_7071_2018# 0.0176f
C2104 digital_0.load_slew15.X a_6315_1474# 0.01128f
C2105 digital_0._116_.Q a_4111_1474# 0.07156f
C2106 a_14358_16610# VDPWR 0.4118f
C2107 a_14762_2018# digital_0.load_slew17.X 0.15507f
C2108 digital_0.hold28.X digital_0._116_.SET_B 0.2535f
C2109 LELO_GR01_0.x7.x18.G LELO_GR01_0.x7.x22.D 0.09541f
C2110 a_14323_962# VDPWR 0.58788f
C2111 a_9465_n126# digital_0._106_.RESET_B 0.29575f
C2112 a_13746_n524# VDPWR 0.10416f
C2113 a_9151_n702# uio_out<7> 0.01383f
C2114 a_14029_3510# a_14125_3510# 0.01379f
C2115 digital_0.output13.A a_5834_2740# 0.03854f
C2116 digital_0._111_.Q a_10285_2910# 0.09477f
C2117 digital_0.load_slew15.A a_8895_412# 0.0113f
C2118 a_6337_2050# a_6853_2422# 0.11025f
C2119 a_6503_2050# a_7071_2018# 0.17589f
C2120 digital_0.hold22.X a_4438_386# 0.30264f
C2121 a_6503_930# a_6761_930# 0.22264f
C2122 a_7181_3926# VDPWR 0.3936f
C2123 digital_0.output7.A uio_out<2> 0.01528f
C2124 digital_0.rst a_15331_564# 0.03645f
C2125 a_4369_1474# VDPWR 0.27396f
C2126 a_14339_n158# VDPWR 0.20793f
C2127 a_9151_n702# a_9417_n702# 0.18284f
C2128 a_6235_3106# digital_0.output13.A 0.42579f
C2129 digital_0.hold28.A a_14247_3106# 0.01984f
C2130 digital_0.hold28.A a_14727_1474# 0.21748f
C2131 digital_0.output4.A digital_0._080_.A2 0.01573f
C2132 a_11673_2588# a_12189_2588# 0.11276f
C2133 a_11839_2588# digital_0._110_.RESET_B 0.0256f
C2134 digital_0.clkload0.A a_12391_1500# 0.03155f
C2135 digital_0._113_.RESET_B a_13481_1474# 0.31828f
C2136 a_12959_1742# a_13306_1500# 0.05116f
C2137 LELO_GR01_0.x7.x15.I1 rst_n 2.32604f
C2138 LELO_GR01_0.x7.x28.e VDPWR 0.35484f
C2139 digital_0._080_.A2 a_4609_110# 0.03336f
C2140 LELO_GR01_0.PWRUP_1V8 a_23816_8541# 0.07606f
C2141 a_9245_412# VDPWR 0.20352f
C2142 digital_0.load_slew15.X digital_0._109_.D 0.02615f
C2143 a_12718_3676# a_12829_3676# 0.34134f
C2144 digital_0._069_.A digital_0._117_.RESET_B 0.02538f
C2145 digital_0._069_.B a_7181_3926# 0.0498f
C2146 uo_out<1> ui_in<3> 0.01524f
C2147 digital_0._109_.Q a_5787_2146# 0.0795f
C2148 digital_0._116_.Q a_4015_1652# 0.06256f
C2149 digital_0.load_slew17.A a_12977_2044# 0.09383f
C2150 a_11996_16042# VDPWR 0.51334f
C2151 a_15662_2044# a_15773_2044# 0.34134f
C2152 digital_0._115_.Q a_7786_412# 0.04301f
C2153 digital_0.input3.X digital_0._112_.RESET_B 0.51331f
C2154 digital_0._080_.A2 digital_0._116_.D 0.05981f
C2155 LELO_GR01_0.x8.PWRUP_N_1V8 a_2478_13680# 0.07785f
C2156 LELO_GR01_0.x7.x1.x5.x9<2>.G a_9734_16926# 0.07164f
C2157 a_14157_962# VDPWR 0.44164f
C2158 a_9465_n126# a_10199_n158# 0.05348f
C2159 digital_0._116_.D a_5785_n426# 0.02948f
C2160 digital_0._106_.D a_9631_n126# 0.28157f
C2161 a_12737_n676# VDPWR 0.21266f
C2162 a_8689_n676# uio_out<7> 0.12677f
C2163 a_14029_3510# a_13934_3498# 0.04983f
C2164 digital_0._108_.Q a_5834_2740# 0.19177f
C2165 digital_0._111_.Q digital_0._065_.A2_N 0.04647f
C2166 a_6337_2050# a_7071_2018# 0.05348f
C2167 digital_0.hold22.X a_4530_626# 0.02056f
C2168 digital_0._117_.RESET_B VDPWR 0.51821f
C2169 a_13978_3650# uio_out<2> 0.01362f
C2170 digital_0.output7.A uio_out<3> 0.0113f
C2171 digital_0._115_.Q a_7214_n524# 0.19457f
C2172 a_4111_1474# VDPWR 0.28624f
C2173 LELO_GR01_0.x7.x25.D LELO_GR01_0.x7.x25.S 0.54618f
C2174 a_13771_n126# VDPWR 0.34252f
C2175 a_6235_3106# digital_0._108_.Q 0.27639f
C2176 digital_0.hold28.A a_13679_3138# 0.54831f
C2177 digital_0._069_.A a_11388_956# 0.07827f
C2178 digital_0.hold28.A digital_0.hold23.X 0.25288f
C2179 a_11839_2588# a_12407_2830# 0.18639f
C2180 a_11673_2588# digital_0._110_.RESET_B 0.29517f
C2181 digital_0.clkload0.A digital_0._113_.D 0.33859f
C2182 digital_0._113_.RESET_B a_12741_1500# 0.15227f
C2183 a_12391_1500# a_13306_1500# 0.12532f
C2184 LELO_GR01_0.x7.x15.I1 VDPWR 0.18351f
C2185 a_7221_412# a_7317_412# 0.01379f
C2186 digital_0._113_.D a_12116_188# 0.08678f
C2187 a_9463_654# VDPWR 0.20904f
C2188 uio_out<1> uo_out<0> 0.02119f
C2189 uo_out<1> ui_in<2> 0.01109f
C2190 uio_out<4> uio_out<5> 4.31608f
C2191 digital_0._108_.Q a_6337_2050# 0.01107f
C2192 digital_0.output13.A a_5787_2146# 0.20621f
C2193 digital_0._109_.Q digital_0.output6.A 0.08051f
C2194 digital_0._116_.Q a_3471_1474# 0.09323f
C2195 a_14358_16750# VDPWR 0.41178f
C2196 digital_0._112_.Q digital_0.load_slew17.X 0.10167f
C2197 a_11951_2146# digital_0._063_.A 0.12815f
C2198 digital_0._115_.Q a_7961_386# 0.16858f
C2199 digital_0._110_.D VDPWR 0.49027f
C2200 digital_0._113_.RESET_B digital_0.rst 0.05663f
C2201 LELO_GR01_0.x8.PWRUP_N_1V8 LELO_GR01_0.x7.x22.D 1.03144f
C2202 LELO_GR01_0.x7.x1.x5.x9<2>.G a_8336_16210# 0.0408f
C2203 a_11388_956# VDPWR 1.29102f
C2204 a_9465_n126# a_9631_n126# 0.71139f
C2205 a_12626_n676# VDPWR 0.22031f
C2206 a_8578_n676# uio_out<7> 0.04362f
C2207 digital_0._108_.D a_6179_3132# 0.19159f
C2208 digital_0.clkbuf_1_0__f_clk.X digital_0.input1.X 0.04278f
C2209 digital_0._109_.RESET_B a_7513_2954# 0.0167f
C2210 digital_0._111_.Q a_10074_2562# 0.14549f
C2211 LELO_GR01_0.x8.VREF_BG digital_0.pwr 0.86357f
C2212 digital_0.clkload0.A digital_0._060_.B 0.0287f
C2213 digital_0._116_.Q digital_0._114_.D 0.01083f
C2214 digital_0.load_slew15.A a_8729_412# 0.01003f
C2215 a_6337_2050# a_6503_2050# 0.57945f
C2216 LELO_GR01_0.x8.x1.x5.x3.S a_20156_7909# 0.39909f
C2217 digital_0._063_.B a_13513_956# 0.04505f
C2218 a_6407_1188# a_6503_930# 0.41909f
C2219 digital_0._100_.RESET_B VDPWR 0.66751f
C2220 digital_0._118_.D a_4610_386# 0.01235f
C2221 a_13738_3834# uio_out<2> 0.01636f
C2222 a_14990_386# digital_0.rst 0.20274f
C2223 a_4015_1652# VDPWR 0.18342f
C2224 a_12741_412# a_12849_778# 0.05722f
C2225 LELO_GR01_0.x7.x25.D a_2478_9240# 0.04975f
C2226 digital_0._105_.D VDPWR 0.63078f
C2227 a_8689_n676# a_9151_n702# 0.01329f
C2228 digital_0.hold28.A digital_0._102_.D 0.0588f
C2229 digital_0._069_.A digital_0._114_.Q 0.11348f
C2230 digital_0.hold28.A digital_0._104_.D 0.01437f
C2231 a_11673_2588# a_12407_2830# 0.07009f
C2232 digital_0.clkload0.A a_12225_1500# 0.02839f
C2233 a_12391_1500# a_13481_1474# 0.04251f
C2234 a_12959_1742# a_12741_1500# 0.20964f
C2235 a_2478_8440# VDPWR 0.35724f
C2236 digital_0._115_.Q digital_0._107_.D 0.05963f
C2237 LELO_GR01_0.x7.x15.I2 a_14358_11680# 0.03213f
C2238 LELO_GR01_0.PWRUP_1V8 LELO_GR01_0.x8.x1.x5.IBN 0.01235f
C2239 a_8895_412# VDPWR 0.56591f
C2240 a_12501_3676# a_12718_3676# 0.11296f
C2241 digital_0.load_slew15.X digital_0._117_.RESET_B 0.66421f
C2242 uo_out<1> ena 0.01524f
C2243 digital_0._108_.Q a_5787_2146# 0.2103f
C2244 digital_0.output13.A digital_0.output6.A 0.44247f
C2245 digital_0._116_.Q a_12977_2044# 0.1029f
C2246 digital_0.load_slew17.A digital_0._104_.RESET_B 0.17179f
C2247 LELO_GR01_0.x7.x15.I2 VDPWR 9.63687f
C2248 digital_0.input1.X digital_0._115_.D 0.16136f
C2249 a_15445_2044# a_15662_2044# 0.11296f
C2250 digital_0.output9.A a_15773_2044# 0.05454f
C2251 digital_0._112_.Q digital_0._063_.A 0.04419f
C2252 digital_0._115_.Q a_7221_412# 0.01744f
C2253 a_10641_3132# VDPWR 0.1421f
C2254 LELO_GR01_0.x7.x6<3>.G a_4578_14070# 0.17405f
C2255 LELO_GR01_0.x8.PWRUP_N_1V8 a_2478_14480# 0.08228f
C2256 a_14358_17550# LELO_GR01_0.x7.x15.I2 0.01611f
C2257 LELO_GR01_0.x7.x18.D LELO_GR01_0.x7.x7.S 0.42102f
C2258 digital_0._114_.Q VDPWR 0.66737f
C2259 a_9465_n126# digital_0._106_.D 0.17578f
C2260 a_23138_6685# a_23138_6427# 0.05264f
C2261 a_12409_n676# VDPWR 0.23642f
C2262 a_8361_n676# uio_out<7> 0.04389f
C2263 digital_0.input1.X digital_0._115_.RESET_B 0.12763f
C2264 LELO_GR01_0.x8.x1.x5.x3.S LELO_GR01_0.x8.x1.x5.x9<2>.G 0.8357f
C2265 digital_0._113_.D digital_0._112_.D 0.03199f
C2266 digital_0.hold25.X VDPWR 0.48168f
C2267 a_13612_3650# uio_out<2> 0.10554f
C2268 digital_0._116_.SET_B a_5328_n132# 0.02506f
C2269 digital_0._114_.D digital_0._107_.RESET_B 0.03531f
C2270 a_15773_2044# uio_out<4> 0.09104f
C2271 a_3471_1474# VDPWR 0.26987f
C2272 a_12741_412# a_12646_412# 0.04983f
C2273 digital_0._112_.RESET_B a_12849_778# 0.0122f
C2274 a_3492_n702# digital_0.pwr 0.09089f
C2275 a_13605_n126# VDPWR 0.43113f
C2276 digital_0._111_.Q digital_0._110_.Q 0.40253f
C2277 digital_0.hold28.A a_13513_3138# 0.05199f
C2278 digital_0._069_.A a_10253_930# 0.02944f
C2279 digital_0.hold28.A digital_0._113_.Q 0.30888f
C2280 a_11673_2588# a_11839_2588# 0.87953f
C2281 digital_0.clkload0.A digital_0._063_.B 0.11409f
C2282 digital_0.input1.X a_12225_412# 0.26507f
C2283 a_12225_1500# a_13306_1500# 0.10236f
C2284 a_12959_1742# digital_0._113_.RESET_B 0.15941f
C2285 a_12391_1500# a_12741_1500# 0.20646f
C2286 a_23824_9183# VDPWR 0.43842f
C2287 digital_0._112_.Q digital_0._060_.A_N 0.02707f
C2288 digital_0._112_.D a_13306_412# 0.0484f
C2289 a_12297_2954# VDPWR 0.1435f
C2290 a_7221_412# a_7329_778# 0.05722f
C2291 LELO_GR01_0.PWRUP_1V8 a_21554_8625# 0.01077f
C2292 LELO_GR01_0.x7.x7.S LELO_GR01_0.x7.x7.G 1.15979f
C2293 LELO_GR01_0.x7.x15.I2 a_14358_12480# 0.03247f
C2294 digital_0._114_.D VDPWR 0.54679f
C2295 digital_0.load_slew15.X digital_0._100_.RESET_B 0.13419f
C2296 uio_out<4> uo_out<0> 0.02532f
C2297 clk uio_out<1> 0.2303f
C2298 ui_in<1> ui_in<2> 0.02728f
C2299 digital_0._108_.Q digital_0.output6.A 0.02626f
C2300 digital_0.load_slew17.A digital_0.load_slew17.X 0.21454f
C2301 a_4581_2825# a_4891_2588# 0.01379f
C2302 digital_0.clkload0.A a_12741_412# 0.0383f
C2303 LELO_GR01_0.x7.x1.x7.D VDPWR 7.31029f
C2304 digital_0.output9.A a_15662_2044# 0.0735f
C2305 digital_0._115_.Q a_7439_654# 0.03672f
C2306 LELO_GR01_0.x7.x18.G a_14358_15670# 0.07584f
C2307 a_8336_17010# LELO_GR01_0.x7.x1.x5.x9<2>.G 0.01325f
C2308 a_10253_930# VDPWR 0.27902f
C2309 a_12138_n702# VDPWR 0.23442f
C2310 a_13679_3138# a_13934_3498# 0.05936f
C2311 digital_0.load_slew17.A a_12754_2588# 0.02309f
C2312 digital_0._065_.A2_N a_8996_1500# 0.02293f
C2313 digital_0.load_slew15.X a_8895_412# 0.03256f
C2314 digital_0.output6.A a_6503_2050# 0.11064f
C2315 LELO_GR01_0.x8.x1.x5.x3.S a_20156_8709# 0.43586f
C2316 a_14415_3650# rst_n 0.01083f
C2317 a_14673_3650# VDPWR 0.30936f
C2318 a_14750_570# a_14990_386# 0.11296f
C2319 a_12977_2044# VDPWR 0.42042f
C2320 a_12959_654# a_12849_778# 0.09774f
C2321 a_12903_206# VDPWR 0.23899f
C2322 a_8578_n676# a_8689_n676# 0.34134f
C2323 digital_0.hold28.A a_12889_3171# 0.36492f
C2324 digital_0.load_slew15.A a_9564_930# 0.10984f
C2325 digital_0.input1.X digital_0.clkload0.X 0.0693f
C2326 digital_0.hold28.A digital_0.output10.A 0.60659f
C2327 a_12391_1500# digital_0._113_.RESET_B 0.02136f
C2328 a_12225_1500# a_13481_1474# 0.04359f
C2329 digital_0._063_.B a_13306_1500# 0.045f
C2330 LELO_GR01_0.x8.x8.D VDPWR 0.78444f
C2331 digital_0._112_.D a_13481_386# 0.07146f
C2332 a_12094_2588# VDPWR 0.08586f
C2333 a_7439_654# a_7329_778# 0.09774f
C2334 a_7221_412# a_7126_412# 0.04983f
C2335 digital_0._115_.Q a_7157_n158# 0.02148f
C2336 LELO_GR01_0.x7.x23.D a_2478_12370# 0.07916f
C2337 a_12688_14988# a_12688_14728# 0.05215f
C2338 a_8689_n132# a_8689_n676# 0.01212f
C2339 a_8729_412# VDPWR 0.45095f
C2340 digital_0.load_slew15.X digital_0.hold25.X 0.17724f
C2341 digital_0.output8.A a_12501_3676# 0.2107f
C2342 a_5321_3676# digital_0._100_.RESET_B 0.06915f
C2343 uio_out<2> uo_out<0> 0.02119f
C2344 digital_0._069_.A a_12517_2044# 0.04577f
C2345 digital_0.hold28.A a_6758_2410# 0.01088f
C2346 digital_0._116_.Q digital_0._104_.RESET_B 0.21132f
C2347 digital_0.load_slew15.A digital_0.load_slew17.X 0.07051f
C2348 digital_0.clkload0.A digital_0._112_.RESET_B 0.04217f
C2349 a_11996_16842# VDPWR 0.47143f
C2350 digital_0.output9.A a_15445_2044# 0.23716f
C2351 digital_0._115_.Q a_6871_412# 0.03003f
C2352 digital_0._113_.Q a_11673_412# 0.03324f
C2353 a_4578_16260# a_4578_16120# 0.11733f
C2354 LELO_GR01_0.x7.x1.x5.x8.G a_8336_16210# 0.0824f
C2355 LELO_GR01_0.x7.x18.G a_12688_14988# 0.03591f
C2356 a_9930_930# VDPWR 0.33244f
C2357 a_11898_n518# VDPWR 0.21806f
C2358 digital_0._102_.D a_13934_3498# 0.16221f
C2359 digital_0._109_.D a_7310_2588# 0.16937f
C2360 digital_0.load_slew17.A a_12929_2562# 0.08003f
C2361 digital_0._069_.A a_10571_2588# 0.01725f
C2362 digital_0.load_slew15.X digital_0._114_.D 0.07006f
C2363 digital_0.output6.A a_6337_2050# 0.03742f
C2364 digital_0.clkload0.A digital_0._114_.RESET_B 0.28573f
C2365 a_12829_3676# uio_out<3> 0.0971f
C2366 digital_0._063_.B digital_0._112_.D 0.22726f
C2367 a_5661_1260# a_6407_1188# 0.01491f
C2368 a_14415_3650# VDPWR 0.27696f
C2369 digital_0.input2.X digital_0._116_.SET_B 0.01256f
C2370 a_12517_2044# VDPWR 0.38778f
C2371 a_12391_412# a_12849_778# 0.02761f
C2372 digital_0._112_.RESET_B a_15685_386# 0.04908f
C2373 digital_0._107_.D uio_out<7> 0.01273f
C2374 a_11758_188# VDPWR 0.20711f
C2375 digital_0.hold28.A digital_0._110_.Q 0.24467f
C2376 a_4833_3436# a_4658_3510# 0.23366f
C2377 digital_0._116_.Q a_9564_930# 0.02163f
C2378 digital_0.load_slew15.A digital_0._115_.Q 0.01104f
C2379 a_12225_1500# a_12741_1500# 0.10591f
C2380 a_12391_1500# a_12959_1742# 0.1745f
C2381 digital_0._063_.B a_13481_1474# 0.05501f
C2382 digital_0._113_.D digital_0._113_.RESET_B 0.0128f
C2383 LELO_GR01_0.x7.x25.S VDPWR 0.2406f
C2384 digital_0._065_.A2_N digital_0._057_.D 0.19574f
C2385 LELO_GR01_0.x8.x4.G li_26138_5135# 0.13976f
C2386 digital_0._112_.D a_12741_412# 0.03721f
C2387 a_6871_412# a_7329_778# 0.02761f
C2388 digital_0._115_.Q a_6962_n16# 0.04244f
C2389 LELO_GR01_0.PWRUP_1V8 LELO_GR01_0.x8.x1.x5.x9<2>.G 0.06338f
C2390 LELO_GR01_0.x7.x15.I2 a_14358_12620# 0.03223f
C2391 a_12189_3650# a_12501_3676# 0.08501f
C2392 a_5321_3676# digital_0.hold25.X 0.13114f
C2393 a_5215_3676# digital_0._100_.RESET_B 0.08202f
C2394 uio_out<3> uo_out<0> 0.02494f
C2395 uio_out<2> uio_out<1> 4.35378f
C2396 digital_0._111_.Q a_11431_2382# 0.09446f
C2397 digital_0._100_.D a_5834_2740# 0.08113f
C2398 digital_0._116_.Q digital_0.load_slew17.X 1.04879f
C2399 digital_0.clkload0.A a_12959_654# 0.03872f
C2400 digital_0._115_.Q a_6705_412# 0.02557f
C2401 digital_0._113_.Q digital_0._057_.D 0.83281f
C2402 a_2478_16300# a_2478_15790# 0.02417f
C2403 LELO_GR01_0.x7.x1.x5.x8.G LELO_GR01_0.x7.x1.x5.x9<2>.G 2.09666f
C2404 LELO_GR01_0.x7.x18.G a_14358_15810# 0.07582f
C2405 LELO_GR01_0.x7.x20.D LELO_GR01_0.x7.x21.D 0.57307f
C2406 a_9690_1194# VDPWR 0.24132f
C2407 digital_0._115_.Q ui_in<0> 0.08289f
C2408 LELO_GR01_0.x8.PWRUP_N_1V8 a_17850_3465# 0.07736f
C2409 a_11772_n702# VDPWR 0.20997f
C2410 a_13513_3138# a_13934_3498# 0.09313f
C2411 LELO_GR01_0.PWRUP_1V8 digital_0.pwr 0.12579f
C2412 digital_0.load_slew15.X a_8729_412# 0.046f
C2413 digital_0.output6.A a_5787_2146# 0.07057f
C2414 digital_0._065_.A2_N digital_0.clkbuf_1_1__f_clk.A 0.34f
C2415 LELO_GR01_0.x8.x1.x5.x8.S a_18456_7909# 0.3991f
C2416 LELO_GR01_0.x8.x1.x5.x3.S LELO_GR01_0.x8.x1.x5.x8.G 2.32397f
C2417 a_5661_1260# a_5486_1334# 0.23366f
C2418 a_14319_3828# VDPWR 0.17734f
C2419 digital_0.input2.X a_3982_386# 0.01632f
C2420 digital_0.input1.X digital_0.output12.A 0.26695f
C2421 digital_0.output9.A uio_out<4> 0.10459f
C2422 a_14624_386# a_14750_570# 0.34134f
C2423 digital_0._104_.RESET_B VDPWR 0.63061f
C2424 digital_0._112_.RESET_B a_15427_386# 0.07401f
C2425 a_12391_412# a_12646_412# 0.05639f
C2426 a_8361_n676# a_8578_n676# 0.11296f
C2427 a_10546_246# VDPWR 0.29483f
C2428 digital_0.hold28.A a_12635_3171# 0.22282f
C2429 digital_0._111_.Q digital_0._067_.A 0.70965f
C2430 digital_0.load_slew15.A digital_0._060_.A_N 0.12024f
C2431 a_2478_9240# VDPWR 0.36721f
C2432 digital_0.clkbuf_1_1__f_clk.A digital_0._113_.Q 0.06071f
C2433 digital_0._065_.A2_N a_10997_386# 0.08028f
C2434 digital_0._063_.B a_12741_1500# 0.03579f
C2435 a_12225_1500# digital_0._113_.RESET_B 0.29446f
C2436 digital_0._115_.Q a_7001_110# 0.03603f
C2437 a_6871_412# a_7126_412# 0.05936f
C2438 digital_0._112_.D digital_0._112_.RESET_B 0.50234f
C2439 LELO_GR01_0.x7.x15.I2 a_14358_13420# 0.04814f
C2440 a_2478_13170# LELO_GR01_0.x7.x23.D 0.04279f
C2441 a_8578_n132# a_8578_n676# 0.02141f
C2442 a_12189_3650# digital_0.output8.A 0.2967f
C2443 a_4979_3676# digital_0._100_.RESET_B 0.06405f
C2444 a_5215_3676# digital_0.hold25.X 0.01066f
C2445 uo_out<1> uo_out<0> 0.16793f
C2446 uio_out<3> uio_out<1> 0.10111f
C2447 digital_0._100_.D a_5144_2954# 0.16221f
C2448 digital_0.output4.A a_4111_1474# 0.02257f
C2449 digital_0._116_.Q digital_0._063_.A 0.02243f
C2450 digital_0._069_.A digital_0.load_slew17.X 0.01229f
C2451 digital_0.clkload0.A a_12391_412# 0.42157f
C2452 LELO_GR01_0.x7.x1.x5.IBN VDPWR 0.52866f
C2453 digital_0._080_.A2 digital_0._116_.SET_B 0.01838f
C2454 digital_0._108_.D clk 0.04255f
C2455 a_7349_3132# VDPWR 0.43345f
C2456 LELO_GR01_0.x7.x18.G a_12688_15788# 0.0373f
C2457 LELO_GR01_0.x7.x20.D a_2478_15790# 0.0493f
C2458 LELO_GR01_0.x7.x1.x5.x8.G a_8336_17010# 0.07053f
C2459 LELO_GR01_0.x7.x6<3>.G LELO_GR01_0.x7.x7.S 4.34539f
C2460 a_9564_930# VDPWR 0.22283f
C2461 a_8578_n132# a_8689_n132# 0.34134f
C2462 a_21554_6773# a_21558_6509# 0.05091f
C2463 a_11361_n702# VDPWR 0.26066f
C2464 a_6687_n676# uo_out<0> 0.03345f
C2465 digital_0.hold27.X a_14175_n702# 0.09101f
C2466 digital_0.load_slew17.A digital_0._110_.RESET_B 0.4928f
C2467 LELO_GR01_0.x8.x1.x5.x8.S LELO_GR01_0.x8.x1.x5.x8.G 3.06086f
C2468 digital_0.output7.A VDPWR 0.65628f
C2469 digital_0.hold23.X a_14323_962# 0.03307f
C2470 digital_0.load_slew17.X VDPWR 3.49689f
C2471 digital_0._112_.RESET_B a_15331_564# 0.062f
C2472 a_12225_412# a_12646_412# 0.08671f
C2473 a_4578_10610# a_4578_10200# 0.03078f
C2474 a_14358_10740# a_14358_10600# 0.11733f
C2475 digital_0.output10.A a_15225_n702# 0.32551f
C2476 a_10721_172# VDPWR 0.40273f
C2477 digital_0.clkbuf_1_0__f_clk.X digital_0._109_.Q 0.02899f
C2478 digital_0._111_.Q a_11098_3510# 0.02563f
C2479 digital_0._069_.B a_7349_3132# 0.0939f
C2480 digital_0.hold28.A digital_0._067_.B 0.03715f
C2481 a_4311_3106# a_4658_3510# 0.05116f
C2482 digital_0._116_.Q digital_0._060_.A_N 0.21917f
C2483 LELO_GR01_0.x7.x1.x5.x3.S a_7886_15860# 0.03706f
C2484 a_23824_9983# VDPWR 0.41304f
C2485 digital_0._063_.B digital_0._113_.RESET_B 0.46526f
C2486 digital_0._113_.D a_12391_1500# 0.22012f
C2487 a_12225_1500# a_12959_1742# 0.05348f
C2488 digital_0._115_.Q digital_0._107_.RESET_B 0.02898f
C2489 a_12754_2588# VDPWR 0.30116f
C2490 a_6705_412# a_7126_412# 0.09313f
C2491 digital_0._112_.D a_12959_654# 0.02423f
C2492 digital_0._112_.RESET_B a_15537_n426# 0.171f
C2493 a_14861_172# digital_0.output10.A 0.10933f
C2494 a_11931_3650# digital_0.output8.A 0.01092f
C2495 digital_0.output4.A digital_0._100_.RESET_B 0.11602f
C2496 digital_0.load_slew17.A a_12829_3676# 0.05892f
C2497 uio_out<0> uo_out<0> 0.02551f
C2498 uo_out<1> uio_out<1> 0.03485f
C2499 digital_0._111_.Q a_10721_2348# 0.12856f
C2500 digital_0.output4.A a_4015_1652# 0.0215f
C2501 digital_0._069_.A digital_0._063_.A 0.05653f
C2502 digital_0.clkload0.A a_12225_412# 0.46589f
C2503 LELO_GR01_0.x7.x21.D VDPWR 0.47013f
C2504 digital_0._118_.RESET_B clk 0.03859f
C2505 a_6906_3132# VDPWR 0.34656f
C2506 LELO_GR01_0.x7.x1.x5.x8.G a_6636_16210# 0.13066f
C2507 LELO_GR01_0.x7.x6<3>.G a_4580_14870# 0.13443f
C2508 digital_0._115_.Q VDPWR 0.65477f
C2509 LELO_GR01_0.x8.x7.D a_24508_6687# 0.0355f
C2510 a_11103_n702# VDPWR 0.26761f
C2511 a_6451_n676# uo_out<0> 0.04495f
C2512 digital_0._108_.D a_6455_3452# 0.08622f
C2513 digital_0._109_.RESET_B a_7970_2588# 0.23165f
C2514 digital_0._118_.RESET_B a_5486_1334# 0.22627f
C2515 a_4477_2044# digital_0.output6.A 0.02655f
C2516 LELO_GR01_0.x8.x1.x5.x8.S a_18456_8709# 0.45344f
C2517 a_5139_930# a_5486_1334# 0.05116f
C2518 a_13978_3650# VDPWR 0.24846f
C2519 digital_0._104_.D a_14323_962# 0.25815f
C2520 digital_0.hold23.X a_14157_962# 0.04872f
C2521 digital_0._063_.A VDPWR 0.86185f
C2522 digital_0._112_.RESET_B digital_0.rst 0.12764f
C2523 digital_0.output10.A a_14967_n702# 0.07618f
C2524 a_9981_246# VDPWR 0.20009f
C2525 digital_0.clkbuf_1_0__f_clk.X digital_0.output13.A 0.18952f
C2526 digital_0._111_.Q a_11273_3436# 0.01945f
C2527 digital_0._069_.A a_6179_3132# 0.01076f
C2528 a_3743_3138# a_4658_3510# 0.12532f
C2529 uio_oe<6> uio_oe<7> 0.04157f
C2530 a_18456_9509# VDPWR 0.40138f
C2531 digital_0._063_.B a_12959_1742# 0.02229f
C2532 a_12225_1500# a_12391_1500# 0.57808f
C2533 digital_0._060_.A_N digital_0._107_.RESET_B 0.01882f
C2534 a_12929_2562# VDPWR 0.42998f
C2535 digital_0._112_.D a_12391_412# 0.22499f
C2536 LELO_GR01_0.PWRUP_1V8 LELO_GR01_0.x8.x1.x5.x8.G 0.01558f
C2537 a_8361_n132# a_8361_n676# 0.02031f
C2538 a_7329_778# VDPWR 0.13239f
C2539 a_11931_3650# a_12189_3650# 0.22264f
C2540 a_4354_3834# digital_0._117_.RESET_B 0.01296f
C2541 a_4594_3650# digital_0._100_.RESET_B 0.01476f
C2542 digital_0.load_slew17.A a_12718_3676# 0.05028f
C2543 VDPWR uio_out<6> 2.20522f
C2544 uo_out<1> clk 1.85831f
C2545 ui_in<1> uo_out<0> 0.17156f
C2546 uio_out<3> uio_out<4> 3.5573f
C2547 uio_out<0> uio_out<1> 7.03238f
C2548 a_4512_2954# a_4726_2954# 0.09774f
C2549 a_4581_2825# a_5144_2954# 0.04983f
C2550 digital_0.load_slew15.X digital_0.load_slew17.X 0.06339f
C2551 digital_0.clkload0.A digital_0.clkload0.X 0.07299f
C2552 a_2478_15790# VDPWR 0.36633f
C2553 digital_0._114_.RESET_B a_9005_956# 0.15798f
C2554 digital_0._113_.RESET_B digital_0._112_.RESET_B 0.12568f
C2555 digital_0._101_.RESET_B clk 0.04204f
C2556 a_6761_930# a_6705_412# 0.01002f
C2557 a_6179_3132# VDPWR 0.50191f
C2558 a_8361_n132# a_8578_n132# 0.11296f
C2559 digital_0._060_.A_N VDPWR 1.08595f
C2560 LELO_GR01_0.x8.x1.x7.D a_23138_5627# 0.01243f
C2561 a_11007_n524# VDPWR 0.16801f
C2562 a_5974_n676# uo_out<0> 0.05898f
C2563 digital_0._111_.Q digital_0.input1.X 0.1283f
C2564 digital_0._116_.Q digital_0._110_.RESET_B 0.10541f
C2565 digital_0._109_.RESET_B a_8145_2562# 0.27859f
C2566 a_4833_3436# a_4512_2954# 0.0119f
C2567 digital_0._118_.RESET_B a_5661_1260# 0.27681f
C2568 a_4571_962# a_5486_1334# 0.11842f
C2569 a_13738_3834# VDPWR 0.23391f
C2570 digital_0.load_slew17.A uio_out<1> 0.01139f
C2571 digital_0._104_.D a_14157_962# 0.19514f
C2572 digital_0._112_.RESET_B a_14990_386# 0.05598f
C2573 digital_0._113_.Q a_13746_n524# 0.2042f
C2574 LELO_GR01_0.x7.x25.D a_2478_9750# 0.07869f
C2575 digital_0.output10.A a_14871_n524# 0.05511f
C2576 digital_0._106_.RESET_B VDPWR 0.37845f
C2577 a_14415_3650# a_14029_3510# 0.01674f
C2578 a_4311_3106# a_4093_3510# 0.20964f
C2579 a_3743_3138# a_4833_3436# 0.04251f
C2580 digital_0._109_.Q a_5785_1750# 0.04897f
C2581 digital_0.output13.A digital_0._115_.RESET_B 0.03636f
C2582 LELO_GR01_0.x7.x25.D clk 0.07644f
C2583 digital_0._063_.B a_12391_1500# 0.02126f
C2584 a_12225_1500# digital_0._113_.D 0.31715f
C2585 a_7961_386# a_7786_412# 0.23366f
C2586 digital_0._112_.D a_12225_412# 0.28454f
C2587 a_12189_2588# VDPWR 0.20843f
C2588 LELO_GR01_0.x7.x22.D a_2478_12370# 0.01255f
C2589 a_14121_246# a_14229_n132# 0.05722f
C2590 digital_0._105_.RESET_B digital_0.output10.A 0.02137f
C2591 a_7126_412# VDPWR 0.07762f
C2592 digital_0.load_slew17.A a_12501_3676# 0.05256f
C2593 VDPWR uio_out<5> 0.94839f
C2594 uio_out<0> clk 0.16381f
C2595 ui_in<1> uio_out<1> 0.06652f
C2596 uio_out<3> uio_out<2> 2.1337f
C2597 a_4425_2730# a_5144_2954# 0.09016f
C2598 a_4581_2825# a_4726_2954# 0.05722f
C2599 a_6636_17010# LELO_GR01_0.x7.x1.x5.x8.G 0.08382f
C2600 a_7155_930# VDPWR 0.22113f
C2601 LELO_GR01_0.x8.x1.x5.IBN a_24508_5627# 0.04366f
C2602 LELO_GR01_0.x8.x1.x7.D a_23138_6427# 0.03742f
C2603 a_24508_7487# LELO_GR01_0.x8.x7.D 0.01243f
C2604 a_10066_n524# VDPWR 0.11267f
C2605 digital_0.hold18.X uo_out<0> 0.2661f
C2606 digital_0.clkbuf_1_0__f_clk.X a_5834_2740# 0.0136f
C2607 digital_0._109_.RESET_B a_7405_2588# 0.16304f
C2608 digital_0.input1.X digital_0.input2.X 0.05681f
C2609 digital_0._118_.RESET_B a_4921_1334# 0.15235f
C2610 a_5139_930# a_4921_1334# 0.20964f
C2611 a_4405_962# a_5486_1334# 0.10236f
C2612 a_4571_962# a_5661_1260# 0.04182f
C2613 a_13612_3650# VDPWR 0.22323f
C2614 digital_0._116_.Q uo_out<0> 0.12463f
C2615 digital_0.load_slew15.A uio_out<1> 0.01106f
C2616 digital_0._112_.RESET_B a_14750_570# 0.05059f
C2617 a_13481_386# a_13306_412# 0.23366f
C2618 a_6793_n676# a_7214_n524# 0.01569f
C2619 digital_0.output10.A a_13746_n524# 0.07327f
C2620 a_10199_n158# VDPWR 0.20834f
C2621 a_3577_3138# a_4658_3510# 0.10236f
C2622 digital_0._103_.RESET_B digital_0._067_.A 0.01925f
C2623 digital_0.output7.A a_14769_3436# 0.10784f
C2624 a_3743_3138# a_4093_3510# 0.2298f
C2625 uio_oe<5> uio_oe<6> 0.04157f
C2626 digital_0.output13.A a_5785_1750# 0.01672f
C2627 digital_0.load_slew15.X digital_0._060_.A_N 0.15303f
C2628 a_18456_10309# VDPWR 0.42759f
C2629 digital_0._063_.B digital_0._113_.D 0.20707f
C2630 digital_0._113_.Q a_13771_n126# 0.04626f
C2631 digital_0._110_.RESET_B VDPWR 0.26963f
C2632 a_2478_13680# a_2478_13170# 0.02417f
C2633 a_11318_14986# a_11318_14728# 0.05264f
C2634 LELO_GR01_0.x7.x22.D LELO_GR01_0.x7.x23.D 0.57781f
C2635 LELO_GR01_0.x8.PWRUP_N_1V8 LELO_GR01_0.x8.x1.x5.IBN 0.16671f
C2636 LELO_GR01_0.x8.VREF_BG LELO_GR01_0.x8.x8.D 0.24927f
C2637 digital_0._107_.D a_7214_n524# 0.11551f
C2638 digital_0._105_.RESET_B a_14229_n132# 0.01234f
C2639 a_11835_3828# a_11931_3650# 0.41909f
C2640 digital_0.load_slew17.A digital_0.output8.A 0.18684f
C2641 VDPWR uio_out<7> 0.82091f
C2642 ui_in<0> uio_out<1> 0.02504f
C2643 a_4386_2856# a_5144_2954# 0.06121f
C2644 digital_0.output13.A a_5109_2348# 0.01895f
C2645 digital_0.hold19.X digital_0.output6.A 0.15532f
C2646 digital_0.load_slew17.A digital_0.output9.A 0.03145f
C2647 digital_0._116_.Q a_15662_2044# 0.01415f
C2648 LELO_GR01_0.x7.x1.x5.x9<2>.G ui_in<0> 0.16193f
C2649 digital_0._112_.Q a_11951_2146# 0.14687f
C2650 a_9734_16926# VDPWR 0.05074f
C2651 digital_0._065_.A2_N a_11388_956# 0.01442f
C2652 digital_0._113_.D a_12741_412# 0.01345f
C2653 LELO_GR01_0.PWRUP_1V8 a_11996_16042# 0.07044f
C2654 a_6761_930# VDPWR 0.27217f
C2655 LELO_GR01_0.x8.x1.x5.x9<2>.G a_19356_4659# 0.0124f
C2656 LELO_GR01_0.x8.x1.x5.IBN a_24508_6427# 0.04312f
C2657 a_5422_n702# uo_out<0> 0.19224f
C2658 digital_0.pwr li_19474_13804# 0.21685f
C2659 a_9417_n702# VDPWR 0.23393f
C2660 digital_0.clkbuf_1_0__f_clk.X a_5144_2954# 0.01376f
C2661 digital_0.hold28.A digital_0.input1.X 0.79051f
C2662 digital_0._109_.RESET_B a_7623_2830# 0.18284f
C2663 digital_0._067_.B a_11949_3132# 0.05839f
C2664 digital_0.output13.A digital_0.hold28.X 0.09624f
C2665 digital_0._118_.RESET_B a_5139_930# 0.15956f
C2666 a_4571_962# a_4921_1334# 0.21686f
C2667 a_4405_962# a_5661_1260# 0.04359f
C2668 digital_0.load_slew15.A clk 0.26639f
C2669 a_12829_3676# VDPWR 0.22119f
C2670 digital_0._113_.Q a_11388_956# 0.11853f
C2671 digital_0._112_.RESET_B a_14624_386# 0.055f
C2672 a_15773_2044# VDPWR 0.24441f
C2673 a_9631_n126# VDPWR 0.57626f
C2674 digital_0.output10.A a_12737_n676# 0.04042f
C2675 a_3577_3138# a_4833_3436# 0.04359f
C2676 digital_0._111_.Q a_10183_3138# 0.01035f
C2677 digital_0._103_.RESET_B a_11098_3510# 0.23669f
C2678 a_3743_3138# a_4311_3106# 0.18639f
C2679 digital_0.hold28.A digital_0.input3.X 0.03172f
C2680 a_14358_9800# VDPWR 0.40066f
C2681 digital_0._063_.B a_12225_1500# 0.12895f
C2682 digital_0._113_.Q digital_0._105_.D 0.21485f
C2683 a_7439_654# a_7786_412# 0.05116f
C2684 digital_0._108_.RESET_B clk 0.14285f
C2685 a_12407_2830# VDPWR 0.21706f
C2686 LELO_GR01_0.x7.x22.D a_2478_13170# 0.05206f
C2687 a_14339_n158# a_14229_n132# 0.09774f
C2688 digital_0.output5.A digital_0._100_.RESET_B 0.07313f
C2689 digital_0.load_slew17.A a_12189_3650# 0.05435f
C2690 ui_in<0> clk 0.16862f
C2691 ui_in<1> uio_out<4> 0.03186f
C2692 rst_n uio_out<1> 1.64785f
C2693 VDPWR uo_out<0> 3.14067f
C2694 a_4386_2856# a_4726_2954# 0.03462f
C2695 digital_0.load_slew17.A a_14762_2018# 0.20835f
C2696 digital_0._116_.Q a_15445_2044# 0.05468f
C2697 digital_0._111_.Q a_9465_2050# 0.01316f
C2698 digital_0.input1.X digital_0._080_.A2 0.02508f
C2699 a_9981_2422# a_8996_1500# 0.01201f
C2700 LELO_GR01_0.x7.x1.x5.x9<2>.G rst_n 0.0462f
C2701 LELO_GR01_0.x7.x20.D clk 0.08208f
C2702 digital_0._065_.A2_N digital_0._114_.Q 0.55858f
C2703 a_10438_3498# VDPWR 0.08323f
C2704 digital_0.input1.X a_5785_n426# 0.04141f
C2705 a_3492_930# uio_out<1> 0.09445f
C2706 a_6503_930# VDPWR 0.30119f
C2707 LELO_GR01_0.x8.x1.x5.x9<2>.G a_19356_5459# 0.03436f
C2708 LELO_GR01_0.x8.x1.x5.IBN a_23138_5627# 0.04924f
C2709 a_9151_n702# VDPWR 0.20143f
C2710 digital_0._109_.RESET_B a_7055_2588# 0.05867f
C2711 digital_0._101_.RESET_B digital_0._118_.RESET_B 0.40332f
C2712 digital_0._067_.A a_11949_3132# 0.09606f
C2713 digital_0._118_.RESET_B a_4571_962# 0.02494f
C2714 digital_0._113_.Q digital_0._114_.Q 0.3881f
C2715 a_4571_962# a_5139_930# 0.18122f
C2716 a_4405_962# a_4921_1334# 0.11053f
C2717 digital_0._116_.Q clk 0.19453f
C2718 a_12718_3676# VDPWR 0.22878f
C2719 digital_0._112_.RESET_B a_13306_412# 0.22575f
C2720 a_15662_2044# VDPWR 0.24525f
C2721 a_6687_n676# a_6793_n676# 0.41909f
C2722 digital_0._106_.D VDPWR 0.81819f
C2723 digital_0.output10.A a_12626_n676# 0.0456f
C2724 a_3577_3138# a_4093_3510# 0.11535f
C2725 digital_0._103_.RESET_B a_11273_3436# 0.27546f
C2726 digital_0._103_.D a_10533_3510# 0.03997f
C2727 digital_0._111_.Q a_10017_3138# 0.0202f
C2728 uio_oe<4> uio_oe<5> 0.04126f
C2729 digital_0._109_.Q a_5159_1474# 0.13541f
C2730 digital_0._116_.Q a_5486_1334# 0.01394f
C2731 a_4578_10200# VDPWR 0.01413f
C2732 digital_0.input1.X a_11673_412# 0.03529f
C2733 digital_0._104_.RESET_B a_14727_1474# 0.01089f
C2734 a_11397_1750# a_12225_1500# 0.01371f
C2735 digital_0._113_.Q a_13605_n126# 0.25134f
C2736 a_6871_412# a_7786_412# 0.11876f
C2737 a_11839_2588# VDPWR 0.58715f
C2738 digital_0._105_.D digital_0.output10.A 0.02499f
C2739 a_13771_n126# a_14229_n132# 0.02757f
C2740 digital_0.load_slew17.A a_11931_3650# 0.07848f
C2741 VDPWR uio_out<1> 1.54483f
C2742 rst_n clk 0.16951f
C2743 ui_in<1> uio_out<2> 0.0669f
C2744 uio_out<0> uio_out<3> 0.07605f
C2745 a_4581_2825# a_4512_2954# 0.20964f
C2746 a_4425_2730# digital_0._100_.D 0.24083f
C2747 digital_0._116_.Q digital_0.output9.A 0.19446f
C2748 digital_0.clkbuf_1_0__f_clk.X digital_0.output6.A 0.1337f
C2749 LELO_GR01_0.x7.x1.x5.x9<2>.G VDPWR 0.10119f
C2750 digital_0._065_.A2_N a_10253_930# 0.07749f
C2751 digital_0._114_.RESET_B digital_0._060_.B 0.01056f
C2752 a_7099_956# a_7826_956# 0.02665f
C2753 LELO_GR01_0.PWRUP_1V8 LELO_GR01_0.x7.x15.I2 0.23085f
C2754 a_6407_1188# VDPWR 0.20852f
C2755 LELO_GR01_0.x8.x1.x5.IBN a_23138_6427# 0.04626f
C2756 a_8689_n676# VDPWR 0.217f
C2757 digital_0._109_.RESET_B a_6889_2588# 0.3316f
C2758 a_4274_2410# digital_0.output6.A 0.01644f
C2759 digital_0._118_.RESET_B a_4405_962# 0.29772f
C2760 digital_0._113_.Q a_10253_930# 0.03129f
C2761 a_4405_962# a_5139_930# 0.07009f
C2762 digital_0._069_.A clk 0.15221f
C2763 a_12501_3676# VDPWR 0.24663f
C2764 digital_0.load_slew17.A uio_out<3> 0.07861f
C2765 digital_0._112_.RESET_B a_13481_386# 0.32475f
C2766 a_12959_654# a_13306_412# 0.05116f
C2767 a_15445_2044# VDPWR 0.34451f
C2768 a_9465_n126# VDPWR 0.45014f
C2769 digital_0.output10.A a_12409_n676# 0.05432f
C2770 a_3577_3138# a_4311_3106# 0.07009f
C2771 digital_0._103_.D a_10751_3106# 0.01402f
C2772 digital_0._103_.RESET_B a_10533_3510# 0.157f
C2773 digital_0._111_.Q digital_0.clkload0.A 0.02186f
C2774 a_14673_3650# a_13513_3138# 0.0135f
C2775 digital_0.hold19.X a_3743_3138# 0.27766f
C2776 digital_0._109_.Q digital_0.hold22.X 0.27301f
C2777 digital_0._111_.RESET_B digital_0._111_.D 0.20385f
C2778 digital_0._116_.Q a_5661_1260# 0.03125f
C2779 digital_0.load_slew15.X a_9151_n702# 0.02441f
C2780 a_2478_9750# VDPWR 0.36615f
C2781 a_11397_1750# digital_0._063_.B 0.09493f
C2782 digital_0._113_.Q a_12903_206# 0.19479f
C2783 a_6705_412# a_7786_412# 0.10236f
C2784 a_6871_412# a_7961_386# 0.04251f
C2785 a_7439_654# a_7221_412# 0.20964f
C2786 a_11673_2588# VDPWR 0.4584f
C2787 LELO_GR01_0.x8.PWRUP_N_1V8 LELO_GR01_0.x8.x1.x5.x9<2>.G 0.46803f
C2788 a_14121_246# a_14217_246# 0.01379f
C2789 a_7786_412# ui_in<0> 0.02017f
C2790 digital_0.load_slew17.A a_11835_3828# 0.04995f
C2791 VDPWR clk 3.73804f
C2792 uio_out<0> uo_out<1> 0.0194f
C2793 ui_in<1> uio_out<3> 0.06771f
C2794 rst_n uio_out<4> 0.29289f
C2795 a_4386_2856# digital_0._100_.D 0.22439f
C2796 a_4425_2730# a_4512_2954# 0.05348f
C2797 digital_0._116_.Q a_14762_2018# 0.04522f
C2798 digital_0.load_slew17.A digital_0._112_.Q 0.10061f
C2799 LELO_GR01_0.x7.x1.x5.x8.G ui_in<0> 0.13458f
C2800 digital_0.output6.A digital_0._115_.RESET_B 0.0225f
C2801 digital_0._113_.D a_12391_412# 0.03764f
C2802 a_14673_1334# a_14781_956# 0.05722f
C2803 LELO_GR01_0.PWRUP_1V8 LELO_GR01_0.x7.x1.x7.D 0.33964f
C2804 digital_0._107_.RESET_B a_8689_n132# 0.04501f
C2805 a_5486_1334# VDPWR 0.28202f
C2806 LELO_GR01_0.x8.x1.x5.IBN a_21558_5709# 0.01549f
C2807 a_8578_n676# VDPWR 0.22792f
C2808 digital_0._109_.D a_7055_2588# 0.31112f
C2809 digital_0.clkbuf_1_0__f_clk.X digital_0._100_.D 0.07483f
C2810 digital_0.load_slew17.A digital_0._111_.D 0.03874f
C2811 a_12635_3171# digital_0._110_.D 0.0229f
C2812 digital_0.hold28.A a_6263_2562# 0.22302f
C2813 a_4934_2422# digital_0.output6.A 0.0553f
C2814 LELO_GR01_0.x8.PWRUP_N_1V8 digital_0.pwr 0.24515f
C2815 a_15634_1474# a_15238_1334# 0.01257f
C2816 digital_0.input3.X a_15413_1260# 0.03121f
C2817 a_4405_962# a_4571_962# 0.8999f
C2818 digital_0.output8.A VDPWR 0.35483f
C2819 digital_0.load_slew15.X uio_out<1> 0.0166f
C2820 a_12391_412# a_13306_412# 0.11876f
C2821 digital_0.output9.A VDPWR 0.75992f
C2822 digital_0._112_.RESET_B a_12741_412# 0.15227f
C2823 a_6451_n676# a_6687_n676# 0.22264f
C2824 a_8689_n132# VDPWR 0.21541f
C2825 a_8361_n132# ui_in<0> 0.20084f
C2826 digital_0.output10.A a_12138_n702# 0.21927f
C2827 a_3577_3138# a_3743_3138# 0.88863f
C2828 digital_0._103_.D a_10183_3138# 0.23454f
C2829 digital_0._103_.RESET_B a_10751_3106# 0.16835f
C2830 digital_0._069_.A a_6455_3452# 0.01228f
C2831 uio_oe<3> uio_oe<4> 0.04126f
C2832 digital_0.output13.A digital_0.hold22.X 0.02676f
C2833 digital_0.clkload0.A digital_0.input2.X 0.04461f
C2834 digital_0._065_.A2_N a_10571_2588# 0.04285f
C2835 a_14358_10600# VDPWR 0.41173f
C2836 digital_0.load_slew17.X digital_0.hold23.X 0.343f
C2837 digital_0._113_.Q a_11758_188# 0.45f
C2838 a_6871_412# a_7221_412# 0.21686f
C2839 a_6705_412# a_7961_386# 0.04359f
C2840 LELO_GR01_0.x7.x22.D a_2478_13680# 0.0773f
C2841 a_14121_246# a_14026_234# 0.04983f
C2842 a_7961_386# ui_in<0> 0.0489f
C2843 digital_0.load_slew17.A a_10986_3828# 0.06939f
C2844 LELO_GR01_0.x8.PWRUP_N_1V8 a_17850_2665# 0.07043f
C2845 ui_in<1> uo_out<1> 3.4159f
C2846 VDPWR uio_out<4> 1.01333f
C2847 rst_n uio_out<2> 0.17232f
C2848 a_4386_2856# a_4512_2954# 0.17589f
C2849 a_4425_2730# a_4581_2825# 0.11082f
C2850 digital_0.output13.A digital_0._101_.D 0.05223f
C2851 LELO_GR01_0.x8.IBP_BG uo_out<0> 0.21582f
C2852 a_9465_2050# a_8996_1500# 0.02154f
C2853 LELO_GR01_0.x7.x1.x5.x8.G rst_n 0.188f
C2854 LELO_GR01_0.x8.VREF_BG uio_out<6> 0.82016f
C2855 digital_0._113_.D a_12225_412# 0.03512f
C2856 a_14891_930# a_14781_956# 0.09774f
C2857 LELO_GR01_0.x7.x18.G a_4578_15320# 0.01267f
C2858 LELO_GR01_0.PWRUP_1V8 a_11996_16842# 0.07815f
C2859 LELO_GR01_0.x8.PWRUP_N_1V8 a_2478_14990# 0.07785f
C2860 a_6962_n16# digital_0._107_.D 0.27543f
C2861 a_7157_n158# a_7088_n132# 0.20964f
C2862 digital_0._107_.RESET_B a_8578_n132# 0.04795f
C2863 a_5661_1260# VDPWR 0.42081f
C2864 LELO_GR01_0.x8.x1.x5.IBN a_21558_6509# 0.0318f
C2865 digital_0.pwr li_20574_17304# 0.15376f
C2866 a_8361_n676# VDPWR 0.33128f
C2867 digital_0.clkbuf_1_0__f_clk.X a_4512_2954# 0.04293f
C2868 digital_0._109_.D a_6889_2588# 0.21624f
C2869 digital_0.load_slew17.A digital_0._111_.RESET_B 0.18865f
C2870 digital_0._067_.B digital_0._110_.D 0.29553f
C2871 a_5109_2348# digital_0.output6.A 0.14268f
C2872 digital_0.input1.X a_6315_1474# 0.05359f
C2873 digital_0.load_slew15.X clk 0.23503f
C2874 a_12189_3650# VDPWR 0.26218f
C2875 a_12225_412# a_13306_412# 0.10236f
C2876 a_12391_412# a_13481_386# 0.04251f
C2877 a_14762_2018# VDPWR 0.30819f
C2878 a_12959_654# a_12741_412# 0.20964f
C2879 a_2478_10550# LELO_GR01_0.x7.x25.D 0.04279f
C2880 a_8578_n132# VDPWR 0.22691f
C2881 a_3577_3138# digital_0.hold19.X 0.17059f
C2882 digital_0._103_.RESET_B a_10183_3138# 0.02906f
C2883 digital_0._103_.D a_10017_3138# 0.28907f
C2884 digital_0._116_.Q digital_0._118_.RESET_B 0.12979f
C2885 digital_0._069_.A digital_0._108_.D 0.19325f
C2886 digital_0.hold28.A digital_0.clkload0.A 0.20811f
C2887 digital_0.hold28.A a_14298_1652# 0.32161f
C2888 a_10074_2562# a_10571_2588# 0.04867f
C2889 digital_0.load_slew15.X a_5486_1334# 0.01564f
C2890 a_9557_2838# digital_0._111_.RESET_B 0.15292f
C2891 a_14358_10740# VDPWR 0.41176f
C2892 digital_0.output6.A digital_0.hold28.X 0.01221f
C2893 digital_0.load_slew17.X digital_0._104_.D 0.21508f
C2894 a_6705_412# a_7221_412# 0.11535f
C2895 a_6871_412# a_7439_654# 0.18122f
C2896 LELO_GR01_0.x7.x15.I2 a_14358_13930# 0.04821f
C2897 LELO_GR01_0.x7.x7.S a_4578_14070# 0.08918f
C2898 a_9734_15074# a_9738_14810# 0.05091f
C2899 a_7786_412# VDPWR 0.27604f
C2900 a_7221_412# ui_in<0> 0.0122f
C2901 VDPWR uio_out<2> 1.01645f
C2902 ui_in<1> uio_out<0> 0.06863f
C2903 ui_in<0> uo_out<1> 1.71086f
C2904 rst_n uio_out<3> 0.44214f
C2905 a_4386_2856# a_4581_2825# 0.21963f
C2906 a_4108_2840# a_4512_2954# 0.05116f
C2907 digital_0._069_.A a_11951_2146# 0.12215f
C2908 digital_0._116_.Q digital_0._112_.Q 0.16413f
C2909 LELO_GR01_0.x8.IBP_BG uio_out<1> 0.06534f
C2910 LELO_GR01_0.x8.VREF_BG uio_out<5> 0.11334f
C2911 digital_0.load_slew15.X a_8689_n132# 0.03838f
C2912 digital_0._108_.D VDPWR 0.48344f
C2913 a_14323_962# a_14781_956# 0.03462f
C2914 LELO_GR01_0.x7.x18.G a_14358_16610# 0.07599f
C2915 LELO_GR01_0.x7.x18.D a_4578_15320# 0.07939f
C2916 a_6962_n16# a_7088_n132# 0.18639f
C2917 a_3618_1194# uo_out<1> 0.02462f
C2918 digital_0._107_.RESET_B a_8361_n132# 0.05303f
C2919 a_7001_110# digital_0._107_.D 0.16641f
C2920 a_4921_1334# VDPWR 0.19977f
C2921 digital_0.pwr li_16034_17304# 0.20115f
C2922 a_7214_n524# VDPWR 0.08888f
C2923 digital_0._067_.A digital_0._110_.D 0.14772f
C2924 a_4311_3106# a_3821_2562# 0.0119f
C2925 digital_0.clkbuf_1_0__f_clk.X a_4581_2825# 0.03349f
C2926 digital_0._116_.Q digital_0._111_.D 0.15825f
C2927 digital_0.load_slew17.A a_9557_2838# 0.06209f
C2928 a_4369_2422# digital_0.output6.A 0.02996f
C2929 digital_0._111_.RESET_B a_10089_2044# 0.0122f
C2930 a_15394_1658# a_15413_1260# 0.01365f
C2931 a_11931_3650# VDPWR 0.27114f
C2932 digital_0._116_.Q uo_out<1> 0.26078f
C2933 a_12225_412# a_13481_386# 0.04359f
C2934 a_12959_654# digital_0._112_.RESET_B 0.15941f
C2935 a_12391_412# a_12741_412# 0.20984f
C2936 a_11951_2146# VDPWR 0.29348f
C2937 a_14358_11680# a_14358_11540# 0.11733f
C2938 a_8361_n132# VDPWR 0.3265f
C2939 digital_0.clkbuf_1_0__f_clk.X digital_0.hold19.X 0.06948f
C2940 digital_0.load_slew15.X a_6455_3452# 0.05464f
C2941 digital_0._103_.RESET_B a_10017_3138# 0.30279f
C2942 digital_0.hold28.A digital_0._109_.Q 0.5474f
C2943 uio_oe<2> uio_oe<3> 0.04219f
C2944 digital_0.output13.A digital_0.input2.X 0.21738f
C2945 digital_0._110_.Q a_12517_2044# 0.14651f
C2946 digital_0.clkload0.A a_8996_1500# 0.03468f
C2947 a_14358_11540# VDPWR 0.41176f
C2948 digital_0.hold28.A digital_0.output11.A 0.55539f
C2949 digital_0.load_slew17.X digital_0._113_.Q 0.30514f
C2950 a_6705_412# a_7439_654# 0.07009f
C2951 LELO_GR01_0.x8.PWRUP_N_1V8 LELO_GR01_0.x8.x1.x5.x8.G 0.10125f
C2952 LELO_GR01_0.x7.x15.I2 a_14358_14730# 0.03295f
C2953 a_2478_14480# LELO_GR01_0.x7.x22.D 0.04278f
C2954 a_7961_386# VDPWR 0.38786f
C2955 a_7439_654# ui_in<0> 0.01316f
C2956 rst_n uo_out<1> 0.18773f
C2957 ui_in<0> uio_out<0> 0.01268f
C2958 VDPWR uio_out<3> 1.07246f
C2959 a_4386_2856# a_4425_2730# 0.5826f
C2960 digital_0._069_.A digital_0._112_.Q 0.55488f
C2961 digital_0.clkload0.A a_11673_412# 0.29151f
C2962 LELO_GR01_0.x8.VREF_BG uio_out<7> 0.15309f
C2963 digital_0._118_.RESET_B VDPWR 0.77402f
C2964 digital_0._115_.D a_7099_956# 0.12848f
C2965 a_6962_n16# a_7157_n158# 0.2298f
C2966 a_3492_930# uo_out<1> 0.01512f
C2967 digital_0._107_.RESET_B digital_0._107_.D 0.02736f
C2968 a_7001_110# a_7088_n132# 0.07009f
C2969 a_5139_930# VDPWR 0.20552f
C2970 LELO_GR01_0.x8.x1.x5.x9<2>.G a_21558_5709# 0.07064f
C2971 LELO_GR01_0.x8.x1.x7.D a_24508_6687# 0.07119f
C2972 a_6793_n676# VDPWR 0.18262f
C2973 digital_0.clkbuf_1_0__f_clk.X a_4425_2730# 0.84952f
C2974 digital_0._069_.A digital_0._111_.D 0.11545f
C2975 digital_0._116_.Q digital_0._111_.RESET_B 0.06315f
C2976 digital_0.output13.A a_4826_1322# 0.02486f
C2977 a_4587_2018# digital_0.output6.A 0.01866f
C2978 a_4369_2422# a_4477_2044# 0.05722f
C2979 digital_0._065_.A2_N digital_0._063_.A 0.01725f
C2980 LELO_GR01_0.x8.x1.x5.x8.S a_18456_9509# 0.04689f
C2981 digital_0._115_.RESET_B a_7099_956# 0.0164f
C2982 a_11835_3828# VDPWR 0.17909f
C2983 a_12225_412# a_12741_412# 0.10756f
C2984 a_12391_412# digital_0._112_.RESET_B 0.02394f
C2985 digital_0._112_.Q VDPWR 3.16593f
C2986 digital_0._107_.D VDPWR 0.90224f
C2987 digital_0.load_slew15.X digital_0._108_.D 0.18257f
C2988 digital_0.clkbuf_1_0__f_clk.X a_3577_3138# 0.25131f
C2989 digital_0.hold28.A digital_0.output13.A 0.27307f
C2990 a_13978_3650# a_13513_3138# 0.0146f
C2991 digital_0.output13.A digital_0._118_.D 0.38036f
C2992 LELO_GR01_0.x7.x28.e li_16454_13804# 0.38238f
C2993 LELO_GR01_0.x7.x15.I1 li_8044_11904# 0.03967f
C2994 a_4578_10610# VDPWR 0.3588f
C2995 digital_0._063_.A digital_0._113_.Q 0.67609f
C2996 digital_0._111_.D VDPWR 0.39819f
C2997 digital_0.load_slew17.X digital_0.output10.A 0.56578f
C2998 a_6705_412# a_6871_412# 0.88744f
C2999 LELO_GR01_0.x7.x15.I2 a_12688_13928# 0.09916f
C3000 LELO_GR01_0.x7.x18.G LELO_GR01_0.x7.x15.I1 0.36005f
C3001 a_7221_412# VDPWR 0.1928f
C3002 a_13771_n126# a_14026_234# 0.05936f
C3003 digital_0._116_.D uo_out<0> 0.03251f
C3004 a_6871_412# ui_in<0> 0.05784f
C3005 digital_0._116_.Q digital_0.load_slew17.A 1.44653f
C3006 rst_n uio_out<0> 1.08247f
C3007 ui_in<0> ui_in<1> 0.13016f
C3008 VDPWR uo_out<1> 2.25508f
C3009 a_4108_2840# a_4425_2730# 0.10236f
C3010 digital_0._065_.A2_N digital_0._060_.A_N 0.28392f
C3011 LELO_GR01_0.x8.IBP_BG uio_out<4> 0.22042f
C3012 digital_0.clkload0.A digital_0._057_.D 0.07254f
C3013 digital_0._101_.RESET_B VDPWR 0.50608f
C3014 LELO_GR01_0.x7.x18.G a_14358_16750# 0.07602f
C3015 LELO_GR01_0.x7.x20.D a_2478_16300# 0.07916f
C3016 digital_0._057_.D a_12116_188# 0.06224f
C3017 digital_0._107_.RESET_B a_7088_n132# 0.16649f
C3018 a_7001_110# a_7157_n158# 0.10748f
C3019 a_4571_962# VDPWR 0.26229f
C3020 LELO_GR01_0.x8.x1.x5.x9<2>.G a_21558_6509# 0.07542f
C3021 LELO_GR01_0.x8.x1.x7.D LELO_GR01_0.x8.x7.D 0.31296f
C3022 a_6687_n676# VDPWR 0.283f
C3023 digital_0.hold19.X a_3821_2562# 0.02437f
C3024 digital_0.load_slew15.A digital_0._108_.RESET_B 0.34851f
C3025 digital_0._116_.Q a_9557_2838# 0.11413f
C3026 digital_0.clkbuf_1_0__f_clk.X a_4386_2856# 0.58826f
C3027 digital_0._069_.A digital_0._111_.RESET_B 0.40185f
C3028 digital_0.output13.A digital_0._080_.A2 0.02f
C3029 a_4587_2018# a_4477_2044# 0.09774f
C3030 a_4019_2050# digital_0.output6.A 0.5521f
C3031 a_3618_1194# a_3858_930# 0.11296f
C3032 digital_0.load_slew17.A rst_n 0.0152f
C3033 a_10986_3828# VDPWR 0.10339f
C3034 digital_0.input2.X a_9005_956# 0.01646f
C3035 a_12391_412# a_12959_654# 0.17513f
C3036 a_12225_412# digital_0._112_.RESET_B 0.29503f
C3037 a_2478_11060# a_2478_10550# 0.02417f
C3038 digital_0.hold18.X a_5974_n676# 0.17687f
C3039 a_7088_n132# VDPWR 0.20734f
C3040 digital_0.load_slew15.X digital_0._118_.RESET_B 0.46938f
C3041 digital_0.hold28.A digital_0._108_.Q 0.11226f
C3042 uio_oe<1> uio_oe<2> 0.04126f
C3043 digital_0.clkload0.A digital_0.clkbuf_1_1__f_clk.A 0.08502f
C3044 digital_0._067_.B a_12517_2044# 0.1551f
C3045 digital_0.load_slew15.X a_5139_930# 0.01295f
C3046 digital_0._116_.Q a_3858_930# 0.01966f
C3047 digital_0._116_.Q a_5974_n676# 0.0434f
C3048 LELO_GR01_0.x7.x25.D VDPWR 0.46588f
C3049 digital_0._111_.RESET_B VDPWR 0.26191f
C3050 digital_0._113_.Q digital_0._106_.RESET_B 0.01161f
C3051 digital_0.load_slew17.X a_14229_n132# 0.03329f
C3052 LELO_GR01_0.x7.x15.I2 a_12688_14728# 0.07212f
C3053 a_7439_654# VDPWR 0.20151f
C3054 digital_0._105_.D a_14026_234# 0.15794f
C3055 a_6705_412# ui_in<0> 0.05158f
C3056 digital_0._116_.Q digital_0.load_slew15.A 1.4133f
C3057 digital_0._069_.A digital_0.load_slew17.A 0.08367f
C3058 VDPWR uio_out<0> 0.63116f
C3059 li_27050_5051# uio_out<6> 0.05514f
C3060 a_4108_2840# a_4386_2856# 0.12532f
C3061 a_3821_2562# a_4425_2730# 0.04359f
C3062 digital_0._110_.D digital_0.input1.X 0.03238f
C3063 digital_0.hold28.A a_6503_2050# 0.02569f
C3064 digital_0._110_.Q a_12754_2588# 0.05048f
C3065 digital_0.input1.X a_11388_956# 0.04636f
C3066 LELO_GR01_0.x8.IBP_BG uio_out<2> 0.28744f
C3067 LELO_GR01_0.x8.VREF_BG uio_out<1> 0.02427f
C3068 digital_0.clkload0.A a_10997_386# 0.07585f
C3069 digital_0.hold28.A digital_0.rst 0.03303f
C3070 LELO_GR01_0.PWRUP_1V8 uio_out<6> 0.01129f
C3071 a_4201_3132# VDPWR 0.1421f
C3072 digital_0._115_.D a_7375_1276# 0.08512f
C3073 a_14673_1334# a_14769_1334# 0.01379f
C3074 LELO_GR01_0.x7.x18.G LELO_GR01_0.x7.x15.I2 4.45319f
C3075 a_4405_962# VDPWR 0.45399f
C3076 digital_0._057_.D digital_0.output11.A 0.01745f
C3077 a_7001_110# a_6962_n16# 0.87924f
C3078 digital_0._107_.RESET_B a_7157_n158# 0.17382f
C3079 a_6684_0# a_7088_n132# 0.05116f
C3080 digital_0._113_.Q uio_out<5> 0.01692f
C3081 LELO_GR01_0.x8.x1.x5.x9<2>.G a_20156_5709# 0.08521f
C3082 LELO_GR01_0.x8.x1.x7.D a_24508_7487# 0.07449f
C3083 a_6451_n676# VDPWR 0.33039f
C3084 digital_0.output10.A uio_out<6> 0.04386f
C3085 digital_0.load_slew15.A a_8837_2838# 0.11178f
C3086 digital_0._116_.Q digital_0._108_.RESET_B 0.06544f
C3087 digital_0.clkbuf_1_0__f_clk.X a_4108_2840# 0.05828f
C3088 digital_0.hold28.A a_5834_2740# 0.31845f
C3089 digital_0._101_.D digital_0.output6.A 0.04718f
C3090 a_4019_2050# a_4477_2044# 0.02761f
C3091 LELO_GR01_0.x8.x1.x5.x8.S a_18456_10309# 0.0331f
C3092 digital_0.output4.A clk 0.0423f
C3093 digital_0._116_.Q ui_in<0> 0.0649f
C3094 digital_0._115_.RESET_B a_7375_1276# 0.01688f
C3095 digital_0.load_slew17.A VDPWR 3.49192f
C3096 digital_0.output13.A digital_0.pwr 0.03674f
C3097 a_12225_412# a_12959_654# 0.06225f
C3098 LELO_GR01_0.x7.x24.D a_2478_9750# 0.01255f
C3099 LELO_GR01_0.x7.x7.G LELO_GR01_0.x7.x15.I1 0.64545f
C3100 a_7157_n158# VDPWR 0.20209f
C3101 a_7001_110# ui_in<0> 0.02292f
C3102 digital_0.load_slew15.X digital_0._101_.RESET_B 0.52783f
C3103 digital_0._109_.RESET_B digital_0._109_.Q 0.05103f
C3104 digital_0._110_.Q digital_0._063_.A 0.05077f
C3105 a_8837_2838# digital_0._108_.RESET_B 0.15265f
C3106 digital_0.clkbuf_1_0__f_clk.X digital_0._115_.RESET_B 0.47971f
C3107 a_4425_2730# a_5109_2348# 0.01127f
C3108 digital_0.hold28.A digital_0._113_.RESET_B 0.06194f
C3109 digital_0.load_slew15.X a_4571_962# 0.03636f
C3110 digital_0._116_.Q a_3618_1194# 0.02312f
C3111 a_2478_10550# VDPWR 0.36657f
C3112 digital_0._116_.Q digital_0.hold18.X 0.10082f
C3113 LELO_GR01_0.x7.x24.D clk 0.08233f
C3114 digital_0.input1.X a_8895_412# 0.01523f
C3115 a_15413_1260# a_15427_386# 0.01412f
C3116 a_9557_2838# VDPWR 0.46834f
C3117 a_6209_386# a_6705_412# 0.02525f
C3118 a_6871_412# VDPWR 0.26037f
C3119 a_13605_n126# a_14026_234# 0.08813f
C3120 a_6209_386# ui_in<0> 0.02115f
C3121 a_6397_n158# a_6687_n676# 0.01412f
C3122 digital_0._069_.A digital_0.load_slew15.A 0.14422f
C3123 rst_n ui_in<0> 2.42169f
C3124 VDPWR ui_in<1> 0.23274f
C3125 li_27050_5051# uio_out<5> 0.22595f
C3126 a_3821_2562# a_4386_2856# 0.04251f
C3127 digital_0.hold28.A a_6337_2050# 0.03836f
C3128 digital_0._110_.Q a_12929_2562# 0.15429f
C3129 digital_0._067_.A a_10571_2588# 0.05273f
C3130 LELO_GR01_0.x8.IBP_BG uio_out<3> 4.32105f
C3131 digital_0.clkload0.A a_9810_412# 0.06764f
C3132 digital_0.hold28.A a_14990_386# 0.01066f
C3133 LELO_GR01_0.PWRUP_1V8 uio_out<5> 0.05978f
C3134 a_2478_16300# VDPWR 0.36615f
C3135 a_14673_1334# a_14578_1322# 0.04983f
C3136 a_4578_17200# a_4578_17060# 0.11733f
C3137 a_2478_17100# LELO_GR01_0.x7.x20.D 0.04279f
C3138 LELO_GR01_0.x7.x6<3>.G a_4578_15320# 0.08841f
C3139 LELO_GR01_0.x7.x18.G LELO_GR01_0.x7.x1.x7.D 0.3639f
C3140 a_3858_930# VDPWR 0.32382f
C3141 digital_0._107_.RESET_B a_6962_n16# 0.05444f
C3142 LELO_GR01_0.x8.x1.x5.x9<2>.G a_20156_6509# 0.12529f
C3143 LELO_GR01_0.x8.x1.x7.D a_23138_6685# 0.10753f
C3144 a_5974_n676# VDPWR 0.25346f
C3145 digital_0.output10.A uio_out<5> 0.02633f
C3146 a_10533_3510# a_10641_3132# 0.05722f
C3147 digital_0.hold25.X digital_0.input1.X 0.01397f
C3148 digital_0._116_.Q a_8837_2838# 0.09992f
C3149 digital_0._069_.A digital_0._108_.RESET_B 0.1311f
C3150 digital_0.clkbuf_1_0__f_clk.X a_3821_2562# 0.08211f
C3151 a_3853_2050# digital_0.output6.A 0.03779f
C3152 digital_0._116_.Q a_6209_386# 0.01249f
C3153 digital_0._116_.Q rst_n 0.01058f
C3154 digital_0._115_.RESET_B digital_0._115_.D 0.0605f
C3155 digital_0.load_slew15.A VDPWR 1.3447f
C3156 a_3492_930# a_3618_1194# 0.34134f
C3157 a_12225_412# a_12391_412# 0.69088f
C3158 a_10089_2044# VDPWR 0.1435f
C3159 digital_0._114_.Q a_12116_n132# 0.04965f
C3160 a_5422_n702# digital_0.hold18.X 0.05334f
C3161 a_6962_n16# VDPWR 0.58333f
C3162 digital_0._107_.RESET_B ui_in<0> 0.08022f
C3163 LELO_GR01_0.x8.x1.x5.x3.S uio_out<1> 0.01283f
C3164 uio_oe<0> uio_oe<1> 0.04126f
C3165 digital_0.load_slew15.X a_4405_962# 0.03052f
C3166 a_11107_2562# a_11673_2588# 0.01758f
C3167 a_4578_11410# VDPWR 0.35714f
C3168 digital_0._108_.RESET_B VDPWR 0.29391f
C3169 LELO_GR01_0.x8.PWRUP_N_1V8 a_2478_8440# 0.07043f
C3170 LELO_GR01_0.x7.x1.x7.D a_11318_13928# 0.01243f
C3171 LELO_GR01_0.x7.x15.I2 LELO_GR01_0.x7.x7.G 0.02302f
C3172 a_4580_14870# LELO_GR01_0.x7.x7.S 0.04272f
C3173 a_6705_412# VDPWR 0.40896f
C3174 a_5951_386# ui_in<0> 0.02448f
C3175 digital_0._069_.A digital_0._116_.Q 0.40126f
C3176 VDPWR ui_in<0> 1.26085f
C3177 li_27422_7487# uio_out<6> 0.03498f
C3178 li_27050_5051# uio_out<7> 0.02078f
C3179 a_3821_2562# a_4108_2840# 0.23366f
C3180 digital_0.clkbuf_1_0__f_clk.X a_5109_2348# 0.0143f
C3181 a_6853_2422# a_6315_1474# 0.01141f
C3182 LELO_GR01_0.x8.VREF_BG uio_out<4> 0.12189f
C3183 digital_0.clkload0.A a_9985_386# 0.06264f
C3184 digital_0.hold28.A a_14750_570# 0.02259f
C3185 digital_0.output6.A digital_0.input2.X 0.13132f
C3186 LELO_GR01_0.x7.x20.D VDPWR 0.47032f
C3187 a_14157_962# a_13513_956# 0.0129f
C3188 LELO_GR01_0.x8.PWRUP_N_1V8 LELO_GR01_0.x7.x15.I2 0.3419f
C3189 a_3618_1194# VDPWR 0.23773f
C3190 a_6684_0# a_6962_n16# 0.12532f
C3191 digital_0._107_.RESET_B a_7001_110# 0.66441f
C3192 LELO_GR01_0.x8.x1.x5.x9<2>.G a_18756_5709# 0.07336f
C3193 LELO_GR01_0.x8.x1.x7.D a_23138_7485# 0.098f
C3194 LELO_GR01_0.x8.x1.x5.IBN LELO_GR01_0.x8.x7.D 0.50701f
C3195 digital_0.hold21.X a_10495_n702# 0.11721f
C3196 a_15225_n702# a_15537_n426# 0.04406f
C3197 digital_0.hold18.X VDPWR 0.21734f
C3198 a_10751_3106# a_10641_3132# 0.09774f
C3199 digital_0._069_.A a_8837_2838# 0.01183f
C3200 digital_0.clkbuf_1_0__f_clk.X digital_0.hold28.X 0.28879f
C3201 a_4369_2422# a_4465_2422# 0.01379f
C3202 digital_0._111_.D a_9886_2410# 0.16138f
C3203 digital_0._116_.Q a_5951_386# 0.03522f
C3204 digital_0.hold28.A a_14175_n702# 0.23303f
C3205 digital_0._116_.Q VDPWR 5.51691f
C3206 a_7001_110# VDPWR 0.48002f
C3207 a_5182_n518# digital_0.hold18.X 0.04152f
C3208 digital_0._109_.RESET_B digital_0._108_.Q 0.08246f
C3209 digital_0._109_.D digital_0._109_.Q 0.02f
C3210 digital_0.hold28.A a_4833_3436# 0.10128f
C3211 digital_0.input1.X a_12094_2588# 0.02185f
C3212 digital_0._109_.Q a_4730_1652# 0.19077f
C3213 digital_0._067_.B digital_0._063_.A 0.05164f
C3214 LELO_GR01_0.x7.x1.x5.x3.S a_8336_16210# 0.39909f
C3215 a_2478_11060# VDPWR 0.36637f
C3216 digital_0.input1.X a_8729_412# 0.27488f
C3217 a_5785_1750# digital_0._115_.RESET_B 0.1524f
C3218 a_8837_2838# VDPWR 0.45973f
C3219 a_5951_386# a_6209_386# 0.22264f
C3220 LELO_GR01_0.x8.PWRUP_N_1V8 a_23824_9183# 0.07045f
C3221 LELO_GR01_0.x7.x1.x5.IBN a_12688_13928# 0.04366f
C3222 LELO_GR01_0.x7.x1.x7.D LELO_GR01_0.x7.x7.G 0.32129f
C3223 a_6209_386# VDPWR 0.34653f
C3224 a_5855_564# ui_in<0> 0.01682f
C3225 digital_0.load_slew15.X digital_0.load_slew15.A 0.2211f
C3226 VDPWR rst_n 1.07488f
C3227 li_27422_7487# uio_out<5> 0.03737f
C3228 digital_0._109_.D a_6853_2422# 0.01073f
C3229 digital_0.hold28.A digital_0.output6.A 0.47557f
C3230 digital_0._110_.Q digital_0._110_.RESET_B 0.30578f
C3231 LELO_GR01_0.PWRUP_1V8 uo_out<0> 0.90832f
C3232 digital_0.output6.A digital_0._118_.D 0.10602f
C3233 LELO_GR01_0.x8.VREF_BG uio_out<2> 0.02376f
C3234 LELO_GR01_0.x8.IBP_BG uio_out<0> 0.06568f
C3235 digital_0.clkload0.A a_9245_412# 0.04177f
C3236 digital_0.hold28.A a_14624_386# 0.01997f
C3237 a_2478_17100# VDPWR 0.36635f
C3238 a_14323_962# a_14578_1322# 0.06418f
C3239 LELO_GR01_0.x8.PWRUP_N_1V8 LELO_GR01_0.x7.x1.x7.D 0.61217f
C3240 a_3492_930# VDPWR 0.22844f
C3241 digital_0.rst a_14861_172# 0.02095f
C3242 a_6397_n158# a_6962_n16# 0.04251f
C3243 a_6684_0# a_7001_110# 0.10236f
C3244 LELO_GR01_0.x8.x1.x5.x9<2>.G a_18756_6509# 0.0876f
C3245 a_5422_n702# VDPWR 0.32557f
C3246 a_10183_3138# a_10641_3132# 0.03462f
C3247 digital_0.load_slew15.X digital_0._108_.RESET_B 0.0316f
C3248 a_5109_2348# a_4934_2422# 0.23366f
C3249 a_4369_2422# a_4274_2410# 0.04983f
C3250 digital_0.clkload0.A a_14157_962# 0.2481f
C3251 digital_0._116_.Q a_5855_564# 0.02974f
C3252 digital_0.load_slew15.X ui_in<0> 0.12154f
C3253 digital_0.hold28.A digital_0.hold27.X 0.06978f
C3254 digital_0._104_.RESET_B a_14781_956# 0.0122f
C3255 digital_0._069_.A VDPWR 3.76096f
C3256 digital_0.output5.A uio_out<1> 0.0148f
C3257 digital_0.clkload0.X a_12225_412# 0.01846f
C3258 a_4578_11670# a_4578_11410# 0.05215f
C3259 digital_0._107_.RESET_B VDPWR 0.44087f
C3260 a_5056_n702# digital_0.hold18.X 0.05247f
C3261 a_5182_n518# a_5422_n702# 0.11296f
C3262 a_6397_n158# ui_in<0> 0.01036f
C3263 digital_0._109_.D digital_0.output13.A 0.09898f
C3264 digital_0._065_.A2_N a_11673_2588# 0.02135f
C3265 digital_0.output13.A a_4730_1652# 0.01941f
C3266 LELO_GR01_0.x7.x1.x5.x3.S LELO_GR01_0.x7.x1.x5.x9<2>.G 0.83136f
C3267 a_14358_11680# VDPWR 0.41176f
C3268 digital_0.load_slew15.X digital_0.hold18.X 0.01308f
C3269 LELO_GR01_0.x8.PWRUP_N_1V8 LELO_GR01_0.x8.x8.D 0.33775f
C3270 LELO_GR01_0.x7.x1.x5.x9<2>.G a_7536_12960# 0.0124f
C3271 LELO_GR01_0.x7.x1.x5.IBN a_12688_14728# 0.04351f
C3272 LELO_GR01_0.x7.x1.x7.D a_11318_14728# 0.03662f
C3273 a_5951_386# VDPWR 0.31503f
C3274 a_11758_188# a_12116_n132# 0.27101f
C3275 digital_0.load_slew15.X digital_0._116_.Q 0.44422f
C3276 digital_0._069_.B digital_0._069_.A 0.17689f
C3277 digital_0._067_.B a_12189_2588# 0.0178f
C3278 digital_0._110_.Q a_12407_2830# 0.01009f
C3279 a_6503_2050# a_6315_1474# 0.02009f
C3280 LELO_GR01_0.x8.VREF_BG uio_out<3> 0.08748f
C3281 LELO_GR01_0.PWRUP_1V8 uio_out<1> 0.04151f
C3282 LELO_GR01_0.x8.IBP_BG ui_in<1> 0.02064f
C3283 digital_0.clkload0.A a_9463_654# 0.05511f
C3284 a_14358_17550# VDPWR 0.41661f
C3285 LELO_GR01_0.x7.x15.I2 li_16034_17304# 0.02996f
C3286 a_14157_962# a_14578_1322# 0.09313f
C3287 LELO_GR01_0.x7.x18.G LELO_GR01_0.x7.x1.x5.IBN 0.52888f
C3288 a_6684_0# digital_0._107_.RESET_B 0.2366f
C3289 a_6397_n158# a_7001_110# 0.04359f
C3290 a_5182_n518# VDPWR 0.2188f
C3291 digital_0.hold25.X a_6263_2562# 0.03829f
C3292 digital_0.hold28.A digital_0._100_.D 0.05039f
C3293 LELO_GR01_0.x8.x7.D LELO_GR01_0.x8.x4.G 0.14779f
C3294 digital_0.hold28.A digital_0._060_.B 0.22298f
C3295 digital_0.clkload0.A a_11388_956# 1.63614f
C3296 digital_0.output5.A clk 0.04539f
C3297 digital_0._069_.B VDPWR 0.12249f
C3298 digital_0.output4.A uo_out<1> 0.0734f
C3299 digital_0.input2.X a_7826_956# 0.01419f
C3300 a_6684_0# VDPWR 0.29839f
C3301 a_4585_n676# digital_0.hold18.X 0.13412f
C3302 digital_0._109_.D digital_0._108_.Q 0.28004f
C3303 digital_0.output13.A a_4369_1474# 0.29895f
C3304 digital_0.clkbuf_1_0__f_clk.X a_5159_1474# 0.04734f
C3305 LELO_GR01_0.x7.x1.x5.x3.S a_8336_17010# 0.43586f
C3306 digital_0._112_.Q a_14727_1474# 0.10179f
C3307 a_14358_12480# VDPWR 0.41154f
C3308 digital_0._104_.RESET_B digital_0.input3.X 0.01169f
C3309 digital_0.load_slew17.X a_14026_234# 0.01781f
C3310 a_5855_564# a_5951_386# 0.41909f
C3311 LELO_GR01_0.x8.PWRUP_N_1V8 LELO_GR01_0.x7.x25.S 0.53552f
C3312 LELO_GR01_0.x7.x1.x5.x9<2>.G a_7536_13760# 0.03436f
C3313 LELO_GR01_0.x7.x1.x5.IBN a_11318_13928# 0.04924f
C3314 LELO_GR01_0.x7.x15.I2 a_14358_14870# 0.03279f
C3315 a_5855_564# VDPWR 0.19415f
C3316 a_11758_188# a_11673_n132# 0.15521f
C3317 digital_0.load_slew15.X digital_0._069_.A 0.06805f
C3318 li_19474_13804# uio_out<6> 0.05194f
C3319 digital_0.hold19.X a_3853_2050# 0.03043f
C3320 digital_0._067_.B digital_0._110_.RESET_B 0.04137f
C3321 digital_0._110_.Q a_11839_2588# 0.04463f
C3322 digital_0.clkload0.A a_8895_412# 0.34733f
C3323 a_6337_2050# a_6315_1474# 0.0213f
C3324 digital_0.load_slew15.X digital_0._107_.RESET_B 0.2566f
C3325 a_3998_3498# VDPWR 0.08228f
C3326 a_14157_962# digital_0._112_.D 0.01008f
C3327 a_6636_17810# a_6636_17010# 0.0149f
C3328 LELO_GR01_0.x7.x18.G LELO_GR01_0.x7.x21.D 0.0959f
C3329 a_6397_n158# digital_0._107_.RESET_B 0.27892f
C3330 LELO_GR01_0.x8.x1.x5.x8.G a_18756_5709# 0.01247f
C3331 a_5056_n702# VDPWR 0.20741f
C3332 digital_0.load_slew15.X a_5951_386# 0.02179f
C3333 digital_0.hold28.A a_7826_956# 0.01254f
C3334 a_4587_2018# a_4934_2422# 0.05116f
C3335 digital_0.clkload0.A digital_0._114_.Q 0.2557f
C3336 a_4019_2050# a_4274_2410# 0.05639f
C3337 digital_0.input1.X digital_0.load_slew17.X 0.03512f
C3338 digital_0.input2.X a_7099_956# 0.01707f
C3339 digital_0.load_slew15.X VDPWR 2.81313f
C3340 LELO_GR01_0.x7.x24.D LELO_GR01_0.x7.x25.D 0.56743f
C3341 a_6397_n158# VDPWR 0.43116f
C3342 a_4479_n676# digital_0.hold18.X 0.01017f
C3343 a_5056_n702# a_5182_n518# 0.34134f
C3344 digital_0.load_slew17.A digital_0._102_.RESET_B 0.12537f
C3345 digital_0._109_.D a_6235_3106# 0.01436f
C3346 uo_out<6> uo_out<7> 0.04002f
C3347 digital_0.hold19.X digital_0.input2.X 0.03513f
C3348 digital_0.output13.A a_4111_1474# 0.06875f
C3349 digital_0.clkbuf_1_0__f_clk.X digital_0.hold22.X 0.25958f
C3350 digital_0._112_.Q digital_0.hold23.X 0.29752f
C3351 a_4578_11670# VDPWR 0.03731f
C3352 digital_0.load_slew17.X digital_0.input3.X 0.07283f
C3353 digital_0.clkload0.A a_13605_n126# 0.25797f
C3354 a_7970_2588# clk 0.01477f
C3355 digital_0.load_slew17.X a_12116_n132# 0.14202f
C3356 LELO_GR01_0.x8.PWRUP_N_1V8 a_2478_9240# 0.08228f
C3357 LELO_GR01_0.x7.x1.x5.IBN LELO_GR01_0.x7.x7.G 0.71167f
C3358 a_5218_778# VDPWR 0.1013f
C3359 digital_0.load_slew15.X digital_0._069_.B 0.19832f
C3360 li_27050_5051# uio_out<4> 0.01608f
C3361 li_19474_13804# uio_out<5> 0.05812f
C3362 digital_0._110_.Q a_11673_2588# 0.0417f
C3363 digital_0._067_.B a_12407_2830# 0.01661f
C3364 digital_0.clkbuf_1_0__f_clk.X digital_0._101_.D 0.02324f
C3365 digital_0.clkload0.A digital_0._114_.D 0.02722f
C3366 LELO_GR01_0.PWRUP_1V8 uio_out<4> 0.08395f
C3367 LELO_GR01_0.x8.VREF_BG uio_out<0> 0.0319f
C3368 LELO_GR01_0.x8.IBP_BG rst_n 0.01345f
C3369 a_17668_17950# VDPWR 0.40365f
C3370 digital_0.input1.X digital_0._115_.Q 0.13125f
C3371 digital_0._113_.D digital_0._057_.D 0.05052f
C3372 a_14594_3510# VDPWR 0.28596f
C3373 a_11388_956# digital_0._112_.D 0.01208f
C3374 LELO_GR01_0.x8.PWRUP_N_1V8 LELO_GR01_0.x7.x1.x5.IBN 0.37056f
C3375 digital_0._116_.D a_6451_n676# 0.01657f
C3376 a_14990_386# digital_0._105_.RESET_B 0.01301f
C3377 a_6397_n158# a_6684_0# 0.23366f
C3378 LELO_GR01_0.x8.x1.x5.x8.G a_18756_6509# 0.0438f
C3379 LELO_GR01_0.x8.x1.x5.IBN a_21554_6773# 0.03188f
C3380 a_21554_7825# a_21554_7573# 0.05415f
C3381 a_4585_n676# VDPWR 0.18878f
C3382 digital_0.hold28.A a_7099_956# 0.12518f
C3383 digital_0._101_.D a_4274_2410# 0.17124f
C3384 a_4019_2050# a_4934_2422# 0.11876f
C3385 digital_0._108_.RESET_B a_6961_2044# 0.0122f
C3386 digital_0.input1.X digital_0._063_.A 0.66668f
C3387 digital_0._065_.A2_N a_11951_2146# 0.23344f
C3388 a_5321_3676# VDPWR 0.18692f
C3389 digital_0._114_.Q digital_0.output11.A 0.0114f
C3390 LELO_GR01_0.x7.x24.D a_2478_10550# 0.05011f
C3391 a_4696_n132# VDPWR 0.20676f
C3392 digital_0.output11.A a_12409_n676# 0.2312f
C3393 digital_0.hold25.X digital_0._109_.Q 0.14024f
C3394 digital_0.output13.A a_4015_1652# 0.03631f
C3395 digital_0.load_slew17.A a_14727_1474# 0.09843f
C3396 digital_0.clkload0.A a_12977_2044# 0.01228f
C3397 LELO_GR01_0.x7.x1.x5.x8.S a_6636_16210# 0.3991f
C3398 LELO_GR01_0.x7.x1.x5.x3.S LELO_GR01_0.x7.x1.x5.x8.G 2.32397f
C3399 digital_0._112_.Q digital_0._104_.D 0.09994f
C3400 a_14358_12620# VDPWR 0.4112f
C3401 digital_0.hold28.A a_7720_n132# 0.01372f
C3402 digital_0.input1.X a_7329_778# 0.02646f
C3403 digital_0.clkload0.A a_12903_206# 0.03663f
C3404 digital_0._114_.RESET_B a_9353_778# 0.02006f
C3405 a_8145_2562# clk 0.02838f
C3406 digital_0._063_.A a_12116_n132# 0.03053f
C3407 digital_0.load_slew17.X a_11673_n132# 0.1139f
C3408 LELO_GR01_0.x8.PWRUP_N_1V8 a_23824_9983# 0.0783f
C3409 LELO_GR01_0.x7.x18.G a_4578_9400# 0.07043f
C3410 LELO_GR01_0.x7.x1.x5.IBN a_11318_14728# 0.04626f
C3411 a_14358_15810# a_14358_15670# 0.11733f
C3412 li_26594_13804# uo_out<0> 0.03366f
C3413 li_26138_5135# uio_out<4> 0.01595f
C3414 li_19474_13804# uio_out<7> 0.0392f
C3415 digital_0._067_.B a_11839_2588# 0.04654f
C3416 digital_0.clkbuf_1_0__f_clk.X a_3853_2050# 0.26359f
C3417 digital_0.clkload0.A a_8729_412# 0.32466f
C3418 digital_0.output6.A a_6315_1474# 0.02082f
C3419 digital_0.hold28.A digital_0._112_.RESET_B 0.02994f
C3420 LELO_GR01_0.PWRUP_1V8 uio_out<2> 0.03887f
C3421 LELO_GR01_0.x8.IBP_BG VDPWR 2.00045f
C3422 digital_0.load_slew15.X a_6397_n158# 0.01065f
C3423 a_14769_3436# VDPWR 0.42614f
C3424 LELO_GR01_0.x7.x18.G a_4578_16120# 0.02712f
C3425 LELO_GR01_0.x8.PWRUP_N_1V8 LELO_GR01_0.x7.x21.D 1.01745f
C3426 digital_0._116_.D a_5974_n676# 0.20373f
C3427 LELO_GR01_0.x8.x1.x5.IBN a_21554_7573# 0.03042f
C3428 LELO_GR01_0.x8.x1.x7.D a_23816_7741# 0.04055f
C3429 a_4479_n676# VDPWR 0.29259f
C3430 digital_0.hold28.A a_4425_2730# 0.031f
C3431 digital_0._065_.A2_N digital_0._112_.Q 0.29321f
C3432 a_4587_2018# a_4369_2422# 0.20964f
C3433 digital_0.clkload0.A a_9930_930# 0.02558f
C3434 a_3853_2050# a_4274_2410# 0.09016f
C3435 a_4019_2050# a_5109_2348# 0.04242f
C3436 a_4228_3650# uo_out<1> 0.09047f
C3437 digital_0.output4.A ui_in<0> 0.03944f
C3438 a_5215_3676# VDPWR 0.29162f
C3439 a_9886_2410# VDPWR 0.0848f
C3440 a_14358_12620# a_14358_12480# 0.11733f
C3441 digital_0._105_.RESET_B a_14175_n702# 0.01405f
C3442 a_4765_n158# VDPWR 0.20598f
C3443 a_4585_n676# a_5056_n702# 0.01251f
C3444 a_4609_110# ui_in<0> 0.01111f
C3445 digital_0.output11.A a_12138_n702# 0.05536f
C3446 digital_0.hold25.X digital_0.output13.A 0.05899f
C3447 digital_0.load_slew17.A a_13679_3138# 0.01236f
C3448 LELO_GR01_0.x8.x1.x5.x3.S uio_out<0> 0.15995f
C3449 uo_out<5> uo_out<6> 0.04002f
C3450 a_10285_2910# digital_0._111_.RESET_B 0.01417f
C3451 digital_0._108_.D a_6758_2410# 0.15797f
C3452 digital_0.input1.X a_12189_2588# 0.01298f
C3453 digital_0._065_.A2_N digital_0._111_.D 0.01862f
C3454 digital_0.clkbuf_1_0__f_clk.X digital_0.input2.X 0.3598f
C3455 LELO_GR01_0.x7.x1.x5.x8.S LELO_GR01_0.x7.x1.x5.x8.G 3.06086f
C3456 digital_0._112_.Q digital_0._113_.Q 0.60249f
C3457 a_14358_13420# VDPWR 0.43103f
C3458 digital_0._104_.RESET_B a_15268_1474# 0.01467f
C3459 digital_0.input1.X a_7126_412# 0.01824f
C3460 a_7405_2588# clk 0.0127f
C3461 digital_0._063_.A a_11673_n132# 0.01995f
C3462 LELO_GR01_0.x8.PWRUP_N_1V8 a_18456_9509# 0.08225f
C3463 LELO_GR01_0.x7.x18.D a_4578_9400# 0.05066f
C3464 LELO_GR01_0.x7.x1.x5.IBN a_9738_14010# 0.01549f
C3465 digital_0._116_.D ui_in<0> 0.01751f
C3466 a_11758_188# a_12116_188# 0.01892f
C3467 a_4696_n132# a_5056_n702# 0.01068f
C3468 a_5321_3676# digital_0.load_slew15.X 0.01599f
C3469 digital_0.output4.A digital_0._116_.Q 0.02618f
C3470 li_27422_7487# uio_out<4> 0.03316f
C3471 digital_0._067_.B a_11673_2588# 0.03952f
C3472 LELO_GR01_0.PWRUP_1V8 uio_out<3> 0.0443f
C3473 a_17668_18750# VDPWR 0.4254f
C3474 digital_0.load_slew15.X a_4696_n132# 0.04311f
C3475 LELO_GR01_0.x8.PWRUP_N_1V8 uio_out<6> 0.02039f
C3476 a_14029_3510# VDPWR 0.18853f
C3477 LELO_GR01_0.x7.x18.D a_4578_16120# 0.07864f
C3478 LELO_GR01_0.x8.PWRUP_N_1V8 a_2478_15790# 0.08228f
C3479 a_14871_n524# digital_0.hold27.X 0.13553f
C3480 a_4243_n676# VDPWR 0.28366f
C3481 digital_0._069_.A a_7513_2954# 0.02672f
C3482 digital_0.hold28.A a_4386_2856# 0.03581f
C3483 digital_0._116_.Q digital_0._116_.D 0.02774f
C3484 digital_0.clkload0.A a_9690_1194# 0.01896f
C3485 a_4019_2050# a_4369_2422# 0.20984f
C3486 a_3853_2050# a_4934_2422# 0.10236f
C3487 digital_0.input2.X digital_0._115_.D 0.04459f
C3488 digital_0.hold22.X digital_0.hold28.X 0.01557f
C3489 digital_0.output5.A uo_out<1> 0.17996f
C3490 a_4979_3676# VDPWR 0.27789f
C3491 digital_0.hold28.X a_5328_n132# 0.15761f
C3492 a_6961_2044# VDPWR 0.14264f
C3493 LELO_GR01_0.x7.x24.D a_2478_11060# 0.0791f
C3494 digital_0._105_.RESET_B digital_0.hold27.X 0.04646f
C3495 a_4570_n16# VDPWR 0.57918f
C3496 digital_0._119_.RESET_B ui_in<0> 0.01381f
C3497 digital_0.output11.A a_11898_n518# 0.04489f
C3498 digital_0.hold28.A digital_0.clkbuf_1_0__f_clk.X 0.29616f
C3499 digital_0._117_.RESET_B a_4658_3510# 0.24269f
C3500 digital_0.hold25.X digital_0._108_.Q 0.29922f
C3501 digital_0.load_slew17.A digital_0._102_.D 0.01949f
C3502 digital_0.output8.A digital_0._067_.B 0.05923f
C3503 LELO_GR01_0.x8.x1.x5.x8.S uio_out<0> 0.05123f
C3504 digital_0.clkbuf_1_0__f_clk.X digital_0._118_.D 0.39504f
C3505 a_3821_2562# a_3853_2050# 0.01127f
C3506 a_10074_2562# digital_0._111_.D 0.13689f
C3507 digital_0._065_.A2_N digital_0._111_.RESET_B 0.13394f
C3508 digital_0.input1.X digital_0._110_.RESET_B 0.01407f
C3509 digital_0._110_.Q a_11951_2146# 0.06036f
C3510 LELO_GR01_0.x7.x1.x5.x8.S a_6636_17010# 0.45344f
C3511 a_11988_12620# VDPWR 0.39903f
C3512 digital_0.input2.X digital_0._115_.RESET_B 0.03306f
C3513 a_7623_2830# clk 0.01451f
C3514 a_7513_2954# VDPWR 0.13343f
C3515 LELO_GR01_0.x7.x18.G a_14358_9800# 0.07393f
C3516 a_4746_412# ui_in<0> 0.01209f
C3517 li_19474_13804# uio_out<1> 0.05698f
C3518 li_20574_17304# uio_out<6> 0.0957f
C3519 LELO_GR01_0.x7.x18.G uo_out<0> 0.63651f
C3520 a_16018_17950# VDPWR 0.40582f
C3521 digital_0.load_slew15.X a_4765_n158# 0.0342f
C3522 LELO_GR01_0.x8.PWRUP_N_1V8 uio_out<5> 0.04392f
C3523 digital_0.input1.X a_6761_930# 0.03798f
C3524 digital_0._102_.RESET_B VDPWR 0.81347f
C3525 a_10253_930# a_10555_956# 0.06889f
C3526 LELO_GR01_0.x8.IBP_BG a_17668_17950# 0.02831f
C3527 digital_0._116_.D a_5422_n702# 0.02506f
C3528 LELO_GR01_0.x8.x1.x5.x9<2>.G a_21554_6773# 0.07821f
C3529 a_23816_8541# LELO_GR01_0.x8.x1.x7.D 0.01242f
C3530 a_13746_n524# digital_0.hold27.X 0.05505f
C3531 a_3858_n702# VDPWR 0.26991f
C3532 a_14769_3436# a_14594_3510# 0.23366f
C3533 a_10533_3510# a_10629_3510# 0.01379f
C3534 digital_0.hold25.X a_5834_2740# 0.11401f
C3535 digital_0._069_.A a_7310_2588# 0.01733f
C3536 digital_0.clkbuf_1_0__f_clk.X digital_0._080_.A2 0.43503f
C3537 digital_0.clkload0.A a_9564_930# 0.01027f
C3538 digital_0.hold28.A digital_0._115_.D 0.23905f
C3539 a_4019_2050# a_4587_2018# 0.17513f
C3540 a_3853_2050# a_5109_2348# 0.04359f
C3541 digital_0._101_.D a_4369_2422# 0.03056f
C3542 digital_0._063_.A a_13513_956# 0.08935f
C3543 digital_0.hold28.A a_10495_n702# 0.24806f
C3544 a_3858_3650# uo_out<1> 0.19376f
C3545 digital_0.output4.A VDPWR 0.78485f
C3546 digital_0._112_.D a_11758_188# 0.01104f
C3547 a_4609_110# VDPWR 0.45473f
C3548 a_4479_n676# a_4585_n676# 0.41909f
C3549 digital_0.output11.A a_11772_n702# 0.06953f
C3550 digital_0.hold28.A digital_0.hold24.X 0.12063f
C3551 digital_0._100_.RESET_B a_4658_3510# 0.02939f
C3552 digital_0._117_.RESET_B a_4833_3436# 0.34077f
C3553 digital_0.output8.A digital_0._067_.A 0.12235f
C3554 a_12189_3650# digital_0._067_.B 0.02069f
C3555 uo_out<4> uo_out<5> 0.04002f
C3556 digital_0.hold28.A digital_0._115_.RESET_B 0.19886f
C3557 digital_0.clkload0.A digital_0.load_slew17.X 0.48212f
C3558 a_10074_2562# digital_0._111_.RESET_B 0.01815f
C3559 digital_0._110_.Q digital_0._112_.Q 0.0282f
C3560 LELO_GR01_0.x7.x24.D VDPWR 0.47401f
C3561 digital_0.load_slew17.X a_14298_1652# 0.02193f
C3562 a_7055_2588# clk 0.05579f
C3563 a_7310_2588# VDPWR 0.0798f
C3564 digital_0._060_.B a_9985_386# 0.02474f
C3565 digital_0.input1.X uo_out<0> 0.07221f
C3566 LELO_GR01_0.x8.PWRUP_N_1V8 a_18456_10309# 0.07206f
C3567 LELO_GR01_0.x7.x18.G a_4578_10200# 0.07078f
C3568 LELO_GR01_0.x7.x1.x5.IBN a_9738_14810# 0.0318f
C3569 a_4610_386# ui_in<0> 0.01523f
C3570 digital_0._116_.D VDPWR 0.95735f
C3571 a_4609_110# a_5182_n518# 0.01087f
C3572 a_5215_3676# a_5321_3676# 0.41909f
C3573 li_16034_17304# uio_out<6> 0.04149f
C3574 li_20574_17304# uio_out<5> 0.05238f
C3575 li_25094_17304# uio_out<7> 0.12917f
C3576 digital_0.clkload0.A a_12754_2588# 0.01422f
C3577 digital_0.hold28.A a_4934_2422# 0.02285f
C3578 LELO_GR01_0.PWRUP_1V8 uio_out<0> 0.12936f
C3579 LELO_GR01_0.x8.VREF_BG VDPWR 2.41559f
C3580 digital_0.load_slew15.X a_4570_n16# 0.6009f
C3581 digital_0.input1.X a_6503_930# 0.02391f
C3582 a_14247_3106# VDPWR 0.19913f
C3583 a_14727_1474# VDPWR 0.15359f
C3584 digital_0._116_.D a_5182_n518# 0.03341f
C3585 a_4765_n158# a_4696_n132# 0.20964f
C3586 LELO_GR01_0.x8.x1.x5.x9<2>.G a_21554_7573# 0.07745f
C3587 a_3618_n518# VDPWR 0.24122f
C3588 a_10533_3510# a_10438_3498# 0.04983f
C3589 digital_0._109_.Q a_7349_3132# 0.15831f
C3590 digital_0._100_.RESET_B a_4726_2954# 0.02f
C3591 digital_0.load_slew17.A a_10074_2562# 0.01558f
C3592 digital_0._069_.A a_11107_2562# 0.18407f
C3593 a_3853_2050# a_4369_2422# 0.11238f
C3594 digital_0._101_.D a_4587_2018# 0.03284f
C3595 uio_oe<7> VGND 0.0768f
C3596 uio_oe<6> VGND 0.03897f
C3597 uio_oe<5> VGND 0.03918f
C3598 uio_oe<4> VGND 0.03876f
C3599 uio_oe<3> VGND 0.03938f
C3600 uio_oe<2> VGND 0.04022f
C3601 uio_oe<1> VGND 0.03876f
C3602 uio_oe<0> VGND 0.03918f
C3603 uo_out<7> VGND 0.04641f
C3604 uo_out<6> VGND 0.04764f
C3605 uo_out<5> VGND 0.04771f
C3606 uo_out<4> VGND 0.04771f
C3607 uo_out<3> VGND 0.04592f
C3608 uo_out<2> VGND 0.04645f
C3609 uio_in<7> VGND 0.03939f
C3610 uio_in<6> VGND 0.04046f
C3611 uio_in<5> VGND 0.03907f
C3612 uio_in<4> VGND 0.04184f
C3613 uio_in<3> VGND 0.04184f
C3614 uio_in<2> VGND 0.04012f
C3615 uio_in<1> VGND 0.03934f
C3616 uio_in<0> VGND 0.04106f
C3617 ui_in<7> VGND 0.04106f
C3618 ui_in<6> VGND 0.04106f
C3619 ui_in<5> VGND 0.04106f
C3620 ui_in<4> VGND 0.04106f
C3621 ui_in<3> VGND 0.04244f
C3622 ui_in<2> VGND 0.03697f
C3623 ena VGND 0.06012f
C3624 uio_out<6> VGND 10.0029f
C3625 uio_out<5> VGND 6.68924f
C3626 uio_out<7> VGND 10.9334f
C3627 uo_out<0> VGND 21.5744f
C3628 uio_out<1> VGND 6.12117f
C3629 clk VGND 7.0214f
C3630 uio_out<4> VGND 7.94799f
C3631 uio_out<2> VGND 3.31493f
C3632 uio_out<3> VGND 7.11027f
C3633 uo_out<1> VGND 12.6986f
C3634 uio_out<0> VGND 11.7136f
C3635 ui_in<1> VGND 5.41224f
C3636 ui_in<0> VGND 7.06024f
C3637 rst_n VGND 8.99912f
C3638 VDPWR VGND 0.41156p
C3639 m4_29318_19972# VGND 0.01451f $ **FLOATING
C3640 m1_7720_5850# VGND 0.13621f $ **FLOATING
C3641 li_27050_5051# VGND 1.09457f $ **FLOATING
C3642 li_26138_5135# VGND 0.67842f $ **FLOATING
C3643 li_27422_7487# VGND 1.06592f $ **FLOATING
C3644 li_6344_7564# VGND 1.38844f $ **FLOATING
C3645 li_26594_13804# VGND 1.52282f $ **FLOATING
C3646 li_19474_13804# VGND 7.6242f $ **FLOATING
C3647 li_8044_11904# VGND 1.50292f $ **FLOATING
C3648 li_16454_13804# VGND 6.65547f $ **FLOATING
C3649 li_25094_17304# VGND 5.1073f $ **FLOATING
C3650 li_20574_17304# VGND 6.96929f $ **FLOATING
C3651 li_16034_17304# VGND 6.67477f $ **FLOATING
C3652 li_28516_19376# VGND 2.04939f
C3653 a_15537_n426# VGND 0.01494f
C3654 a_14175_n702# VGND 0.3147f
C3655 digital_0.hold27.X VGND 0.59107f
C3656 a_10495_n702# VGND 0.31404f
C3657 digital_0.hold21.X VGND 0.47222f
C3658 a_7643_n702# VGND 0.36371f
C3659 digital_0.hold26.X VGND 0.46166f
C3660 a_5785_n426# VGND 0.01076f
C3661 digital_0.pwr VGND 10.9369f
C3662 a_15225_n702# VGND 0.42479f
C3663 a_14967_n702# VGND 0.39137f
C3664 a_14871_n524# VGND 0.23649f
C3665 a_13746_n524# VGND 0.27032f
C3666 a_12737_n676# VGND 0.28608f
C3667 a_12626_n676# VGND 0.27917f
C3668 a_12409_n676# VGND 0.2787f
C3669 a_12138_n702# VGND 0.29021f
C3670 a_11898_n518# VGND 0.29295f
C3671 a_11772_n702# VGND 0.2875f
C3672 a_11361_n702# VGND 0.36858f
C3673 a_11103_n702# VGND 0.37303f
C3674 a_11007_n524# VGND 0.22498f
C3675 a_10066_n524# VGND 0.28231f
C3676 a_9417_n702# VGND 0.24798f
C3677 a_9151_n702# VGND 0.33481f
C3678 a_8689_n676# VGND 0.27576f
C3679 a_8578_n676# VGND 0.27679f
C3680 a_8361_n676# VGND 0.33145f
C3681 a_7214_n524# VGND 0.278f
C3682 a_6793_n676# VGND 0.27569f
C3683 a_6687_n676# VGND 0.40523f
C3684 a_6451_n676# VGND 0.38575f
C3685 a_5974_n676# VGND 0.32421f
C3686 digital_0.hold18.X VGND 0.34102f
C3687 a_5422_n702# VGND 0.34104f
C3688 a_5182_n518# VGND 0.29265f
C3689 a_5056_n702# VGND 0.28906f
C3690 a_4585_n676# VGND 0.24548f
C3691 a_4479_n676# VGND 0.40189f
C3692 a_4243_n676# VGND 0.39528f
C3693 a_3858_n702# VGND 0.30651f
C3694 a_3618_n518# VGND 0.30174f
C3695 a_3492_n702# VGND 0.3124f
C3696 a_15537_n132# VGND 0.01142f
C3697 digital_0.output10.A VGND 1.55595f
C3698 a_14026_234# VGND 0.07881f
C3699 a_12116_188# VGND 0.30385f
C3700 digital_0.output11.A VGND 0.56779f
C3701 a_9886_234# VGND 0.08173f
C3702 a_7720_n132# VGND 0.08081f
C3703 digital_0.output12.A VGND 0.75099f
C3704 a_5328_n132# VGND 0.07467f
C3705 a_14686_246# VGND 0.27529f
C3706 a_14861_172# VGND 0.60564f
C3707 a_14121_246# VGND 0.2656f
C3708 digital_0._105_.RESET_B VGND 0.6992f
C3709 a_14339_n158# VGND 0.18923f
C3710 a_13771_n126# VGND 0.31384f
C3711 digital_0._105_.D VGND 0.33255f
C3712 a_13605_n126# VGND 0.60689f
C3713 a_12903_206# VGND 0.33203f
C3714 a_11758_188# VGND 0.47541f
C3715 a_10546_246# VGND 0.27746f
C3716 a_10721_172# VGND 0.59147f
C3717 a_9981_246# VGND 0.26437f
C3718 digital_0._106_.RESET_B VGND 0.78864f
C3719 a_10199_n158# VGND 0.18517f
C3720 a_9631_n126# VGND 0.30651f
C3721 digital_0._106_.D VGND 0.36472f
C3722 a_9465_n126# VGND 0.68929f
C3723 a_8689_n132# VGND 0.27577f
C3724 a_8578_n132# VGND 0.27413f
C3725 a_8361_n132# VGND 0.32769f
C3726 digital_0._107_.D VGND 0.29978f
C3727 a_7088_n132# VGND 0.19661f
C3728 a_7157_n158# VGND 0.27362f
C3729 a_6962_n16# VGND 0.33794f
C3730 a_7001_110# VGND 0.60301f
C3731 digital_0._107_.RESET_B VGND 1.28428f
C3732 a_6684_0# VGND 0.31601f
C3733 a_6397_n158# VGND 0.62005f
C3734 a_4696_n132# VGND 0.18571f
C3735 a_4765_n158# VGND 0.25986f
C3736 a_4570_n16# VGND 0.29681f
C3737 a_4609_110# VGND 0.54783f
C3738 digital_0._119_.RESET_B VGND 0.769f
C3739 a_4292_0# VGND 0.2707f
C3740 a_4005_n158# VGND 0.58534f
C3741 a_12646_412# VGND 0.07397f
C3742 a_15685_386# VGND 0.40086f
C3743 a_15427_386# VGND 0.37199f
C3744 a_15331_564# VGND 0.21632f
C3745 digital_0.rst VGND 2.18014f
C3746 a_14990_386# VGND 0.27022f
C3747 a_14750_570# VGND 0.27166f
C3748 a_14624_386# VGND 0.27946f
C3749 a_13306_412# VGND 0.26074f
C3750 a_13481_386# VGND 0.59282f
C3751 a_12741_412# VGND 0.27053f
C3752 digital_0._112_.RESET_B VGND 1.51988f
C3753 a_12959_654# VGND 0.17859f
C3754 a_12391_412# VGND 0.30061f
C3755 a_12225_412# VGND 0.57364f
C3756 digital_0.clkload0.X VGND 0.23313f
C3757 a_9150_412# VGND 0.07837f
C3758 a_11673_412# VGND 0.52256f
C3759 digital_0._057_.D VGND 1.69529f
C3760 a_10997_386# VGND 0.36441f
C3761 a_9810_412# VGND 0.25807f
C3762 a_9985_386# VGND 0.57268f
C3763 a_9245_412# VGND 0.25789f
C3764 a_9463_654# VGND 0.17911f
C3765 a_8895_412# VGND 0.30005f
C3766 digital_0._114_.D VGND 0.45346f
C3767 a_8729_412# VGND 0.61442f
C3768 a_7126_412# VGND 0.0958f
C3769 a_7786_412# VGND 0.26279f
C3770 a_7961_386# VGND 0.60533f
C3771 a_7221_412# VGND 0.26714f
C3772 a_7439_654# VGND 0.17973f
C3773 a_6871_412# VGND 0.32456f
C3774 a_6705_412# VGND 0.6975f
C3775 a_6209_386# VGND 0.38951f
C3776 a_5951_386# VGND 0.37918f
C3777 a_5855_564# VGND 0.23837f
C3778 a_5218_778# VGND 0.09916f
C3779 digital_0._116_.D VGND 0.32309f
C3780 a_4746_412# VGND 0.18058f
C3781 a_4610_386# VGND 0.43371f
C3782 a_4438_386# VGND 0.54991f
C3783 a_4530_626# VGND 0.49968f
C3784 a_4118_412# VGND 0.17894f
C3785 digital_0._116_.SET_B VGND 1.48737f
C3786 a_3982_386# VGND 0.40804f
C3787 a_3814_386# VGND 0.3194f
C3788 a_14578_1322# VGND 0.08f
C3789 digital_0._112_.D VGND 1.26793f
C3790 a_10555_956# VGND 0.01346f
C3791 digital_0._060_.B VGND 0.35144f
C3792 a_7099_956# VGND 0.01146f
C3793 digital_0._114_.RESET_B VGND 0.61671f
C3794 a_7375_1276# VGND 0.32549f
C3795 digital_0._115_.D VGND 0.46648f
C3796 digital_0.hold28.X VGND 0.45262f
C3797 a_4826_1322# VGND 0.07386f
C3798 digital_0._080_.A2 VGND 0.50629f
C3799 a_15238_1334# VGND 0.27003f
C3800 a_15413_1260# VGND 0.60407f
C3801 a_14673_1334# VGND 0.26568f
C3802 a_14891_930# VGND 0.18283f
C3803 a_14323_962# VGND 0.3019f
C3804 a_14157_962# VGND 0.68261f
C3805 a_11388_956# VGND 2.01117f
C3806 digital_0._114_.Q VGND 1.58957f
C3807 a_10253_930# VGND 0.59813f
C3808 a_9930_930# VGND 0.32958f
C3809 a_9690_1194# VGND 0.27908f
C3810 a_9564_930# VGND 0.27435f
C3811 digital_0._115_.Q VGND 1.39174f
C3812 digital_0._060_.A_N VGND 1.84623f
C3813 a_7155_930# VGND 0.52435f
C3814 a_6761_930# VGND 0.39811f
C3815 a_6503_930# VGND 0.3832f
C3816 a_6407_1188# VGND 0.23339f
C3817 a_5486_1334# VGND 0.25799f
C3818 a_5661_1260# VGND 0.58045f
C3819 a_4921_1334# VGND 0.2593f
C3820 a_5139_930# VGND 0.17482f
C3821 a_4571_962# VGND 0.29447f
C3822 a_4405_962# VGND 0.54087f
C3823 a_3858_930# VGND 0.31529f
C3824 a_3618_1194# VGND 0.27795f
C3825 a_3492_930# VGND 0.2902f
C3826 a_14727_1474# VGND 0.28053f
C3827 digital_0.hold23.X VGND 0.35651f
C3828 digital_0._104_.D VGND 0.52659f
C3829 digital_0._113_.Q VGND 1.89821f
C3830 a_12646_1500# VGND 0.07386f
C3831 digital_0.input3.X VGND 0.714f
C3832 a_15634_1474# VGND 0.30025f
C3833 a_15394_1658# VGND 0.26926f
C3834 a_15268_1474# VGND 0.27598f
C3835 a_14298_1652# VGND 0.25891f
C3836 a_13306_1500# VGND 0.2588f
C3837 a_13481_1474# VGND 0.59514f
C3838 a_12741_1500# VGND 0.25707f
C3839 digital_0._113_.RESET_B VGND 1.75366f
C3840 a_12959_1742# VGND 0.17772f
C3841 a_12391_1500# VGND 0.28801f
C3842 digital_0._113_.D VGND 0.51112f
C3843 a_12225_1500# VGND 0.52413f
C3844 digital_0._063_.B VGND 1.69791f
C3845 a_11397_1750# VGND 0.01068f
C3846 digital_0._115_.RESET_B VGND 1.73693f
C3847 a_5159_1474# VGND 0.2988f
C3848 digital_0.hold22.X VGND 0.45366f
C3849 digital_0.input2.X VGND 1.35668f
C3850 digital_0._118_.D VGND 0.71168f
C3851 a_8996_1500# VGND 1.99162f
C3852 a_8085_1500# VGND 0.54976f
C3853 digital_0.clkbuf_1_1__f_clk.A VGND 2.68776f
C3854 a_6315_1474# VGND 1.97756f
C3855 a_4730_1652# VGND 0.26363f
C3856 a_4369_1474# VGND 0.35882f
C3857 a_4111_1474# VGND 0.36806f
C3858 a_4015_1652# VGND 0.2204f
C3859 a_3471_1474# VGND 0.33905f
C3860 a_12977_2044# VGND 0.01014f
C3861 digital_0._104_.RESET_B VGND 0.80996f
C3862 digital_0.load_slew17.X VGND 2.57793f
C3863 digital_0._063_.A VGND 1.28681f
C3864 a_15773_2044# VGND 0.29274f
C3865 a_15662_2044# VGND 0.28215f
C3866 a_15445_2044# VGND 0.31595f
C3867 digital_0.output9.A VGND 0.68989f
C3868 a_14762_2018# VGND 0.32527f
C3869 a_11951_2146# VGND 0.34239f
C3870 digital_0._112_.Q VGND 1.20052f
C3871 a_9886_2410# VGND 0.08003f
C3872 a_6961_2044# VGND 0.01231f
C3873 a_6949_2422# VGND 0.01372f
C3874 a_6758_2410# VGND 0.0749f
C3875 a_11431_2382# VGND 0.33066f
C3876 a_10546_2422# VGND 0.27312f
C3877 a_10721_2348# VGND 0.60086f
C3878 a_9981_2422# VGND 0.26369f
C3879 a_10199_2018# VGND 0.1866f
C3880 a_9631_2050# VGND 0.30281f
C3881 a_9465_2050# VGND 0.68547f
C3882 a_7418_2422# VGND 0.26269f
C3883 a_7593_2348# VGND 0.58583f
C3884 a_6853_2422# VGND 0.2882f
C3885 a_7071_2018# VGND 0.19382f
C3886 a_6503_2050# VGND 0.31952f
C3887 a_6337_2050# VGND 0.61584f
C3888 a_5787_2146# VGND 0.34218f
C3889 digital_0.output6.A VGND 0.66596f
C3890 a_4274_2410# VGND 0.08f
C3891 a_4934_2422# VGND 0.26861f
C3892 a_5109_2348# VGND 0.57989f
C3893 a_4369_2422# VGND 0.26192f
C3894 a_4587_2018# VGND 0.18626f
C3895 a_4019_2050# VGND 0.3041f
C3896 digital_0._101_.D VGND 0.29628f
C3897 a_3853_2050# VGND 0.67211f
C3898 a_26146_2651# VGND 0.49333f $ **FLOATING
C3899 LELO_GR01_0.x8.x4.G VGND 4.87558f
C3900 a_26146_3451# VGND 0.53112f $ **FLOATING
C3901 a_17850_2665# VGND 0.49317f $ **FLOATING
C3902 a_12094_2588# VGND 0.07966f
C3903 a_10571_2588# VGND 0.17588f
C3904 a_12754_2588# VGND 0.26698f
C3905 a_12929_2562# VGND 0.59871f
C3906 a_12189_2588# VGND 0.26714f
C3907 digital_0._110_.RESET_B VGND 0.91123f
C3908 a_12407_2830# VGND 0.19162f
C3909 a_11839_2588# VGND 0.30403f
C3910 a_11673_2588# VGND 0.54377f
C3911 digital_0._111_.D VGND 0.70223f
C3912 digital_0._111_.RESET_B VGND 1.02944f
C3913 a_9557_2838# VGND 0.0161f
C3914 digital_0._108_.RESET_B VGND 1.42947f
C3915 a_8837_2838# VGND 0.01556f
C3916 a_7310_2588# VGND 0.07501f
C3917 a_11107_2562# VGND 0.3138f
C3918 a_10285_2910# VGND 0.18339f
C3919 digital_0._065_.A2_N VGND 2.49966f
C3920 a_10074_2562# VGND 0.25831f
C3921 a_7970_2588# VGND 0.28385f
C3922 a_8145_2562# VGND 0.6205f
C3923 a_7405_2588# VGND 0.26624f
C3924 a_7623_2830# VGND 0.1891f
C3925 a_7055_2588# VGND 0.33316f
C3926 a_6889_2588# VGND 0.63503f
C3927 digital_0.input1.X VGND 2.70783f
C3928 a_6263_2562# VGND 0.34707f
C3929 a_5834_2740# VGND 0.26785f
C3930 a_5144_2954# VGND 0.08098f
C3931 digital_0._100_.D VGND 0.62059f
C3932 a_4512_2954# VGND 0.18654f
C3933 a_4581_2825# VGND 0.26382f
C3934 a_4425_2730# VGND 0.63717f
C3935 a_4386_2856# VGND 0.30239f
C3936 a_4108_2840# VGND 0.2756f
C3937 a_3821_2562# VGND 0.59997f
C3938 a_17850_3465# VGND 0.53142f $ **FLOATING
C3939 a_13934_3498# VGND 0.08366f
C3940 a_11949_3132# VGND 0.0165f
C3941 digital_0._110_.D VGND 0.52772f
C3942 a_7349_3132# VGND 0.02304f
C3943 a_6906_3132# VGND 0.01859f
C3944 a_10438_3498# VGND 0.07768f
C3945 a_6455_3452# VGND 0.32408f
C3946 digital_0._108_.D VGND 0.45497f
C3947 digital_0._118_.RESET_B VGND 0.64471f
C3948 digital_0._101_.RESET_B VGND 0.85322f
C3949 a_3998_3498# VGND 0.08293f
C3950 a_14594_3510# VGND 0.2911f
C3951 a_14769_3436# VGND 0.6552f
C3952 a_14029_3510# VGND 0.28204f
C3953 digital_0._102_.RESET_B VGND 0.86315f
C3954 a_14247_3106# VGND 0.20789f
C3955 a_13679_3138# VGND 0.33273f
C3956 digital_0._102_.D VGND 0.63467f
C3957 a_13513_3138# VGND 0.66587f
C3958 a_12889_3171# VGND 0.2821f
C3959 digital_0._110_.Q VGND 1.41336f
C3960 a_12635_3171# VGND 0.31586f
C3961 digital_0._067_.B VGND 0.7224f
C3962 digital_0._067_.A VGND 0.63269f
C3963 a_11098_3510# VGND 0.28501f
C3964 a_11273_3436# VGND 0.60287f
C3965 a_10533_3510# VGND 0.26896f
C3966 a_10751_3106# VGND 0.19472f
C3967 a_10183_3138# VGND 0.32624f
C3968 a_10017_3138# VGND 0.62941f
C3969 digital_0.clkload0.A VGND 3.18996f
C3970 digital_0._109_.Q VGND 0.97286f
C3971 digital_0.output13.A VGND 2.95977f
C3972 digital_0._108_.Q VGND 2.80325f
C3973 a_6235_3106# VGND 0.52695f
C3974 a_4658_3510# VGND 0.28137f
C3975 a_4833_3436# VGND 0.5991f
C3976 a_4093_3510# VGND 0.27292f
C3977 a_4311_3106# VGND 0.19443f
C3978 a_3743_3138# VGND 0.33152f
C3979 digital_0.hold19.X VGND 0.40925f
C3980 a_3577_3138# VGND 0.70748f
C3981 digital_0.clkbuf_1_0__f_clk.X VGND 3.25609f
C3982 digital_0.hold24.X VGND 1.17441f
C3983 a_11415_3650# VGND 0.28084f
C3984 digital_0._111_.Q VGND 0.83911f
C3985 digital_0.hold20.X VGND 0.42303f
C3986 digital_0.hold28.A VGND 4.04699f
C3987 digital_0._103_.D VGND 0.85559f
C3988 digital_0._103_.RESET_B VGND 0.84156f
C3989 digital_0._109_.RESET_B VGND 1.07575f
C3990 a_7717_3926# VGND 0.0175f
C3991 digital_0._109_.D VGND 0.71886f
C3992 a_7181_3926# VGND 0.01811f
C3993 digital_0._117_.RESET_B VGND 1.2875f
C3994 digital_0._100_.RESET_B VGND 1.15642f
C3995 digital_0.hold25.X VGND 0.69049f
C3996 a_14673_3650# VGND 0.42747f
C3997 a_14415_3650# VGND 0.39523f
C3998 a_14319_3828# VGND 0.2339f
C3999 digital_0.output7.A VGND 1.07161f
C4000 a_13978_3650# VGND 0.27636f
C4001 a_13738_3834# VGND 0.28304f
C4002 a_13612_3650# VGND 0.28408f
C4003 a_12829_3676# VGND 0.2867f
C4004 a_12718_3676# VGND 0.28848f
C4005 a_12501_3676# VGND 0.28769f
C4006 digital_0.output8.A VGND 0.93677f
C4007 a_12189_3650# VGND 0.37903f
C4008 a_11931_3650# VGND 0.39671f
C4009 a_11835_3828# VGND 0.24197f
C4010 a_10986_3828# VGND 0.28049f
C4011 digital_0.load_slew17.A VGND 3.09864f
C4012 digital_0.load_slew15.A VGND 2.0967f
C4013 digital_0._116_.Q VGND 6.93461f
C4014 digital_0._069_.A VGND 3.38523f
C4015 digital_0._069_.B VGND 0.7629f
C4016 digital_0.load_slew15.X VGND 4.48124f
C4017 a_5321_3676# VGND 0.23464f
C4018 a_5215_3676# VGND 0.3956f
C4019 a_4979_3676# VGND 0.39129f
C4020 digital_0.output4.A VGND 1.08679f
C4021 a_4594_3650# VGND 0.29994f
C4022 a_4354_3834# VGND 0.28931f
C4023 a_4228_3650# VGND 0.28669f
C4024 digital_0.output5.A VGND 0.55079f
C4025 a_3858_3650# VGND 0.28193f
C4026 a_3618_3834# VGND 0.2801f
C4027 a_3492_3650# VGND 0.2936f
C4028 a_24510_4435# VGND 0.53194f $ **FLOATING
C4029 a_24510_5235# VGND 0.47456f $ **FLOATING
C4030 a_19356_4659# VGND 0.53212f $ **FLOATING
C4031 a_19356_5459# VGND 0.52649f $ **FLOATING
C4032 a_24508_5627# VGND 0.42031f $ **FLOATING
C4033 a_24508_6427# VGND 0.36179f $ **FLOATING
C4034 a_23138_5627# VGND 0.49653f $ **FLOATING
C4035 a_23138_6427# VGND 0.36615f $ **FLOATING
C4036 a_21558_5709# VGND 0.52382f $ **FLOATING
C4037 a_21558_6509# VGND 0.48005f $ **FLOATING
C4038 a_20156_5709# VGND 0.54389f $ **FLOATING
C4039 a_20156_6509# VGND 0.51027f $ **FLOATING
C4040 a_18756_5709# VGND 0.53141f $ **FLOATING
C4041 a_18756_6509# VGND 0.51605f $ **FLOATING
C4042 a_24508_6687# VGND 0.04117f $ **FLOATING
C4043 LELO_GR01_0.x8.x7.D VGND 1.70205f
C4044 a_24508_7487# VGND 0.05153f $ **FLOATING
C4045 a_23138_6685# VGND 0.04601f $ **FLOATING
C4046 a_23138_7485# VGND 0.0513f $ **FLOATING
C4047 a_21554_6773# VGND 0.4626f $ **FLOATING
C4048 a_21554_7573# VGND 0.45888f $ **FLOATING
C4049 a_19706_6759# VGND 0.45452f $ **FLOATING
C4050 a_19706_7559# VGND 0.40836f $ **FLOATING
C4051 a_23816_7741# VGND 0.0145f $ **FLOATING
C4052 LELO_GR01_0.x8.x1.x7.D VGND 1.24428f
C4053 a_23816_8541# VGND 0.07127f $ **FLOATING
C4054 a_21554_7825# VGND 0.45836f $ **FLOATING
C4055 LELO_GR01_0.x8.x1.x5.IBN VGND 4.42682f
C4056 a_21554_8625# VGND 0.49211f $ **FLOATING
C4057 a_20156_7909# VGND 0.08019f $ **FLOATING
C4058 LELO_GR01_0.x8.x1.x5.x9<2>.G VGND 17.5111f
C4059 a_20156_8709# VGND 0.09303f $ **FLOATING
C4060 a_18456_7909# VGND 0.09539f $ **FLOATING
C4061 LELO_GR01_0.x8.x1.x5.x8.G VGND 5.04446f
C4062 a_18456_8709# VGND 0.07526f $ **FLOATING
C4063 LELO_GR01_0.x7.x28.e VGND 7.87313f
C4064 LELO_GR01_0.x7.x15.I1 VGND 23.7323f
C4065 a_2478_8440# VGND 0.11211f $ **FLOATING
C4066 a_23824_9183# VGND 0.0716f $ **FLOATING
C4067 LELO_GR01_0.x8.x8.D VGND 1.68417f
C4068 LELO_GR01_0.x7.x25.S VGND 1.12162f
C4069 a_2478_9240# VGND 0.06512f $ **FLOATING
C4070 a_23824_9983# VGND 0.09578f $ **FLOATING
C4071 a_18456_9509# VGND 0.0764f $ **FLOATING
C4072 a_4578_9400# VGND 0.51395f $ **FLOATING
C4073 a_18456_10309# VGND 0.0984f $ **FLOATING
C4074 a_14358_9800# VGND 0.09768f $ **FLOATING
C4075 a_4578_10200# VGND 0.48809f $ **FLOATING
C4076 a_2478_9750# VGND 0.06306f $ **FLOATING
C4077 a_4578_10610# VGND 0.11512f $ **FLOATING
C4078 LELO_GR01_0.x7.x25.D VGND 0.39206f
C4079 a_2478_10550# VGND 0.0622f $ **FLOATING
C4080 a_4578_11410# VGND 0.05678f $ **FLOATING
C4081 a_2478_11060# VGND 0.06174f $ **FLOATING
C4082 a_14358_12480# VGND 0.0105f $ **FLOATING
C4083 a_4578_11670# VGND 0.36509f $ **FLOATING
C4084 a_14358_12620# VGND 0.0135f $ **FLOATING
C4085 a_14358_13420# VGND 0.06371f $ **FLOATING
C4086 a_11988_12620# VGND 0.11547f $ **FLOATING
C4087 LELO_GR01_0.x7.x24.D VGND 0.16253f
C4088 a_2478_11860# VGND 0.06196f $ **FLOATING
C4089 a_4578_12470# VGND 0.38763f $ **FLOATING
C4090 a_11988_13420# VGND 0.10723f $ **FLOATING
C4091 a_7536_12960# VGND 0.53212f $ **FLOATING
C4092 a_7536_13760# VGND 0.52717f $ **FLOATING
C4093 a_4578_13270# VGND 0.3874f $ **FLOATING
C4094 a_14358_13930# VGND 0.06286f $ **FLOATING
C4095 a_12688_13928# VGND 0.43748f $ **FLOATING
C4096 a_12688_14728# VGND 0.36061f $ **FLOATING
C4097 a_11318_13928# VGND 0.48356f $ **FLOATING
C4098 LELO_GR01_0.x7.x7.G VGND 10.7372f
C4099 a_11318_14728# VGND 0.36615f $ **FLOATING
C4100 a_9738_14010# VGND 0.52514f $ **FLOATING
C4101 a_9738_14810# VGND 0.48005f $ **FLOATING
C4102 a_8336_14010# VGND 0.54416f $ **FLOATING
C4103 a_8336_14810# VGND 0.51027f $ **FLOATING
C4104 a_6936_14010# VGND 0.53615f $ **FLOATING
C4105 a_2478_12370# VGND 0.06248f $ **FLOATING
C4106 LELO_GR01_0.x7.x23.D VGND 0.15069f
C4107 a_2478_13170# VGND 0.06248f $ **FLOATING
C4108 a_6936_14810# VGND 0.51609f $ **FLOATING
C4109 a_4578_14070# VGND 0.38915f $ **FLOATING
C4110 a_2478_13680# VGND 0.06196f $ **FLOATING
C4111 LELO_GR01_0.x7.x22.D VGND 0.15244f
C4112 a_2478_14480# VGND 0.06196f $ **FLOATING
C4113 LELO_GR01_0.x7.x7.S VGND 1.26725f
C4114 a_4580_14870# VGND 0.42944f $ **FLOATING
C4115 a_12688_14988# VGND 0.04043f $ **FLOATING
C4116 a_12688_15788# VGND 0.05055f $ **FLOATING
C4117 a_11318_14986# VGND 0.04601f $ **FLOATING
C4118 a_11318_15786# VGND 0.04997f $ **FLOATING
C4119 a_9734_15074# VGND 0.4626f $ **FLOATING
C4120 a_9734_15874# VGND 0.45888f $ **FLOATING
C4121 a_7886_15060# VGND 0.45452f $ **FLOATING
C4122 a_2478_14990# VGND 0.06248f $ **FLOATING
C4123 a_7886_15860# VGND 0.40836f $ **FLOATING
C4124 a_4578_15320# VGND 0.42975f $ **FLOATING
C4125 a_11996_16042# VGND 0.0144f $ **FLOATING
C4126 LELO_GR01_0.x7.x15.I2 VGND 11.4726f
C4127 LELO_GR01_0.x7.x1.x7.D VGND 1.10877f
C4128 a_11996_16842# VGND 0.09281f $ **FLOATING
C4129 a_9734_16126# VGND 0.45836f $ **FLOATING
C4130 LELO_GR01_0.x7.x1.x5.IBN VGND 4.25179f
C4131 LELO_GR01_0.x7.x21.D VGND 0.15545f
C4132 a_2478_15790# VGND 0.06196f $ **FLOATING
C4133 a_4578_16120# VGND 0.35453f $ **FLOATING
C4134 a_9734_16926# VGND 0.49201f $ **FLOATING
C4135 a_8336_16210# VGND 0.08019f $ **FLOATING
C4136 LELO_GR01_0.x7.x1.x5.x9<2>.G VGND 17.417f
C4137 a_8336_17010# VGND 0.09303f $ **FLOATING
C4138 a_6636_16210# VGND 0.09526f $ **FLOATING
C4139 LELO_GR01_0.x7.x1.x5.x8.G VGND 4.86917f
C4140 a_6636_17010# VGND 0.07525f $ **FLOATING
C4141 a_4578_16260# VGND 0.35417f $ **FLOATING
C4142 a_4578_17060# VGND 0.35369f $ **FLOATING
C4143 a_2478_16300# VGND 0.06248f $ **FLOATING
C4144 LELO_GR01_0.x7.x20.D VGND 0.1527f
C4145 a_2478_17100# VGND 0.06248f $ **FLOATING
C4146 a_14358_17550# VGND 0.09414f $ **FLOATING
C4147 a_4578_17200# VGND 0.35396f $ **FLOATING
C4148 a_17668_17950# VGND 0.09294f $ **FLOATING
C4149 LELO_GR01_0.x8.IBP_BG VGND 20.9257f
C4150 a_17668_18750# VGND 0.09294f $ **FLOATING
C4151 a_16018_17950# VGND 0.09294f $ **FLOATING
C4152 LELO_GR01_0.x8.VREF_BG VGND 8.57812f
C4153 a_6636_17810# VGND 0.07582f $ **FLOATING
C4154 a_16018_18750# VGND 0.09294f $ **FLOATING
C4155 a_12688_18180# VGND 0.09274f $ **FLOATING
C4156 LELO_GR01_0.PWRUP_1V8 VGND 10.7692f
C4157 a_4578_18000# VGND 0.35276f $ **FLOATING
C4158 a_2478_17610# VGND 0.06196f $ **FLOATING
C4159 a_6636_18610# VGND 0.09427f $ **FLOATING
C4160 a_4578_18140# VGND 0.35276f $ **FLOATING
C4161 a_12688_18980# VGND 0.09414f $ **FLOATING
C4162 LELO_GR01_0.x7.x18.G VGND 25.2054f
C4163 LELO_GR01_0.x7.x18.D VGND 13.0047f
C4164 LELO_GR01_0.x8.PWRUP_N_1V8 VGND 38.2502f
C4165 LELO_GR01_0.x7.x19.D VGND 0.17422f
C4166 a_2478_18410# VGND 0.09367f $ **FLOATING
C4167 LELO_GR01_0.x7.x6<3>.G VGND 10.1994f
C4168 a_4578_18940# VGND 0.4503f $ **FLOATING
C4169 LELO_GR01_0.x8.x1.x5.x3.S VGND 5.35641f
C4170 LELO_GR01_0.x8.x1.x5.x8.S VGND 5.67293f
C4171 LELO_GR01_0.x7.x1.x5.x3.S VGND 5.35626f
C4172 LELO_GR01_0.x7.x1.x5.x8.S VGND 5.51838f
.ends
