* NGSPICE file created from tt_um_lelo_gr01_analogicus.ext - technology: sky130A

* Replacing the lpe port list (../tech/scripts/fixlpe)
.subckt tt_um_lelo_gr01_analogicus uo_out<7> uo_out<6> uo_out<5> uo_out<4> uo_out<3> uo_out<2>
+ uio_out<7> uio_out<6> uio_out<5> uio_out<4> uio_out<3> uio_out<2> uio_out<1> uio_out<0> uio_oe<7> uio_oe<6> uio_oe<5> uio_oe<4> uio_oe<3> uio_oe<2> uio_oe<1> uio_oe<0> VDPWR VGND
+ ui_in<7> ui_in<6> ui_in<5> ui_in<4> ui_in<3> ui_in<2> ui_in<1> ui_in<0> uio_in<7> uio_in<6> uio_in<5> uio_in<4> uio_in<3> uio_in<2> uio_in<1> uio_in<0> ena rst_n clk uo_out<0> uo_out<1>
*.subckt tt_um_lelo_gr01_analogicus uio_oe<6> uio_oe<7> uio_oe<5> uio_oe<4> uio_oe<3>
*+ uio_oe<2> uio_oe<1> uio_oe<0> uio_out<7> uio_out<6> uio_out<5> uio_out<4> uio_out<3>
*+ uio_out<2> uio_out<1> uio_out<0> uo_out<7> uo_out<6> uo_out<5> ui_in<4> ui_in<3>
*+ ui_in<2> ui_in<1> ui_in<0> rst_n clk ena uio_in<4> uio_in<3> uio_in<2> uio_in<1>
*+ uio_in<0> ui_in<7> ui_in<6> ui_in<5> uo_out<4> uo_out<3> uo_out<2> uo_out<1> uo_out<0>
*+ uio_in<7> uio_in<6> uio_in<5> VDPWR VGND
X0 digital_0.output4.A a_14797_2172# VDPWR VDPWR sky130_fd_pr__pfet_01v8_hvt ad=0.135 pd=1.27 as=0.3012 ps=2.66 w=1 l=0.15
X1 LELO_GR01_0.x8.x1.x5.x9<2>.G LELO_GR01_0.x8.x1.x5.x8.G LELO_GR01_0.x8.x1.x5.x8.G VGND sky130_fd_pr__nfet_01v8_lvt ad=0.5088 pd=2.98 as=0.3168 ps=1.62 w=0.96 l=0.94
X2 digital_0.clkbuf_1_0__f_clk.X a_11416_3500# VDPWR VDPWR sky130_fd_pr__pfet_01v8_hvt ad=0.14 pd=1.28 as=0.1375 ps=1.275 w=1 l=0.15
X3 a_6968_4276# digital_0._112_.Q a_7288_4404# VGND sky130_fd_pr__nfet_01v8 ad=0.1092 pd=1.36 as=0.0441 ps=0.63 w=0.42 l=0.15
X4 digital_0._101_.RESET_B digital_0.load_slew15.X VGND VGND sky130_fd_pr__nfet_01v8 ad=0.08775 pd=0.92 as=0.169 ps=1.82 w=0.65 l=0.15
X5 VGND digital_0._116_.Q digital_0._114_.RESET_B VGND sky130_fd_pr__nfet_01v8 ad=0.182 pd=1.86 as=0.08775 ps=0.92 w=0.65 l=0.15
X6 a_3951_3322# a_3389_2930# VGND VGND sky130_fd_pr__nfet_01v8 ad=0.0669 pd=0.75 as=0.12495 ps=1.015 w=0.42 l=0.15
X7 VGND LELO_GR01_0.x8.x1.x5.x9<2>.G LELO_GR01_0.x8.x1.x5.IBN VGND sky130_fd_pr__nfet_01v8_lvt ad=0.5088 pd=2.98 as=0.3168 ps=1.62 w=0.96 l=0.94
X8 digital_0.hold19.X a_15101_3500# VGND VGND sky130_fd_pr__nfet_01v8 ad=0.169 pd=1.82 as=0.097 ps=0.975 w=0.65 l=0.15
X9 VDPWR LELO_GR01_0.x8.x1.x7.D LELO_GR01_0.x8.x7.D VDPWR sky130_fd_pr__pfet_01v8_lvt ad=0.5088 pd=2.98 as=0.3168 ps=1.62 w=0.96 l=0.94
X10 VDPWR a_8793_4562# a_8739_4910# VDPWR sky130_fd_pr__pfet_01v8_hvt ad=0.2272 pd=1.35 as=0.0928 ps=0.93 w=0.64 l=0.15
X11 VDPWR digital_0.hold28.A a_5403_1651# VDPWR sky130_fd_pr__pfet_01v8_hvt ad=0.15835 pd=1.395 as=0.07665 ps=0.785 w=0.42 l=0.15
X12 digital_0._119_.RESET_B digital_0.load_slew15.X VGND VGND sky130_fd_pr__nfet_01v8 ad=0.08775 pd=0.92 as=0.169 ps=1.82 w=0.65 l=0.15
X13 digital_0._113_.D a_6631_1842# VGND VGND sky130_fd_pr__nfet_01v8 ad=0.08775 pd=0.92 as=0.169 ps=1.82 w=0.65 l=0.15
X14 VGND a_7226_1324# a_7337_1324# VGND sky130_fd_pr__nfet_01v8 ad=0.1856 pd=1.26 as=0.17225 ps=1.83 w=0.65 l=0.25
X15 a_6644_2778# a_5925_2554# a_6081_2649# VGND sky130_fd_pr__special_nfet_01v8 ad=0.066 pd=0.745 as=0.0594 ps=0.69 w=0.36 l=0.15
X16 VGND a_12405_2172# digital_0.output12.A VGND sky130_fd_pr__nfet_01v8 ad=0.169 pd=1.82 as=0.08775 ps=0.92 w=0.65 l=0.15
X17 VDPWR a_8841_4018# a_8772_4044# VDPWR sky130_fd_pr__pfet_01v8_hvt ad=0.2184 pd=2.2 as=0.12915 ps=1.185 w=0.84 l=0.15
X18 VGND a_14729_5106# a_14660_5132# VGND sky130_fd_pr__nfet_01v8 ad=0.1346 pd=1.15 as=0.0999 ps=0.985 w=0.64 l=0.15
X19 VGND digital_0.hold28.A a_5410_1324# VGND sky130_fd_pr__nfet_01v8 ad=0.11285 pd=1.045 as=0.0693 ps=0.75 w=0.42 l=0.15
X20 VGND VDPWR VGND VGND sky130_fd_pr__nfet_01v8 ad=0.143 pd=1.62 as=177.20654 ps=1.38017k w=0.55 l=0.59
X21 a_14214_4044# a_13693_4018# VDPWR VDPWR sky130_fd_pr__pfet_01v8_hvt ad=0.0567 pd=0.69 as=0.0819 ps=0.81 w=0.42 l=0.15
X22 a_5018_8824# a_5234_6904# VGND sky130_fd_pr__res_high_po w=0.36 l=7.36
X23 VDPWR digital_0._111_.D a_9404_4044# VDPWR sky130_fd_pr__pfet_01v8_hvt ad=0.1092 pd=1.36 as=0.0651 ps=0.73 w=0.42 l=0.15
X24 VGND VDPWR VGND VGND sky130_fd_pr__nfet_01v8 ad=0.143 pd=1.62 as=0 ps=0 w=0.55 l=0.59
X25 VDPWR digital_0.output7.A a_4455_5676# VDPWR sky130_fd_pr__pfet_01v8_hvt ad=0.0567 pd=0.69 as=0.1092 ps=1.36 w=0.42 l=0.15
X26 VDPWR digital_0.load_slew15.X digital_0._107_.RESET_B VDPWR sky130_fd_pr__pfet_01v8_hvt ad=0.26 pd=2.52 as=0.135 ps=1.27 w=1 l=0.15
X27 a_14731_2246# a_13541_1874# a_14622_2246# VGND sky130_fd_pr__special_nfet_01v8 ad=0.0669 pd=0.75 as=0.0711 ps=0.755 w=0.36 l=0.15
X28 VDPWR digital_0._063_.A a_6575_1868# VDPWR sky130_fd_pr__pfet_01v8_hvt ad=0.1625 pd=1.325 as=0.26 ps=2.52 w=1 l=0.15
X29 a_14350_2386# digital_0._116_.SET_B VDPWR VDPWR sky130_fd_pr__pfet_01v8_hvt ad=0.0567 pd=0.69 as=0.0798 ps=0.8 w=0.42 l=0.15
X30 VDPWR digital_0._111_.Q a_7547_4018# VDPWR sky130_fd_pr__pfet_01v8_hvt ad=0.1176 pd=1.4 as=0.0567 ps=0.69 w=0.42 l=0.15
X31 digital_0._109_.Q a_10657_4562# VGND VGND sky130_fd_pr__nfet_01v8 ad=0.08775 pd=0.92 as=0.169 ps=1.82 w=0.65 l=0.15
X32 a_5403_1651# digital_0.hold27.X a_5189_1651# VDPWR sky130_fd_pr__pfet_01v8_hvt ad=0.07665 pd=0.785 as=0.1932 ps=1.34 w=0.42 l=0.15
X33 a_18168_18564# a_17952_16644# VGND sky130_fd_pr__res_high_po w=0.36 l=7.36
X34 a_12584_2234# digital_0._107_.RESET_B VGND VGND sky130_fd_pr__nfet_01v8 ad=0.06405 pd=0.725 as=0.12495 ps=1.015 w=0.42 l=0.15
X35 VGND VDPWR VGND VGND sky130_fd_pr__nfet_01v8 ad=0.143 pd=1.62 as=0 ps=0 w=0.55 l=0.59
X36 a_28934_15064# a_28718_13144# VGND sky130_fd_pr__res_high_po w=0.36 l=7.36
X37 a_4637_3500# a_4383_3827# VGND VGND sky130_fd_pr__nfet_01v8 ad=0.0693 pd=0.75 as=0.1449 ps=1.11 w=0.42 l=0.15
X38 VGND VDPWR VGND VGND sky130_fd_pr__nfet_01v8 ad=0.143 pd=1.62 as=0 ps=0 w=0.55 l=0.59
X39 digital_0._112_.Q a_5321_2386# VDPWR VDPWR sky130_fd_pr__pfet_01v8_hvt ad=0.135 pd=1.27 as=0.26 ps=2.52 w=1 l=0.15
X40 a_20372_11699# a_22292_11483# VGND sky130_fd_pr__res_high_po w=0.36 l=7.36
X41 LELO_GR01_0.x8.x5.XA7.MP1.S LELO_GR01_0.x8.x5.Q LELO_GR01_0.x8.x5.XA7.MN0.S VGND sky130_fd_pr__nfet_01v8 ad=0.288 pd=1.54 as=0.288 ps=1.54 w=0.9 l=0.16
X42 a_6391_2412# a_6012_2778# a_6319_2412# VGND sky130_fd_pr__nfet_01v8 ad=0.1401 pd=1.1 as=0.0441 ps=0.63 w=0.42 l=0.15
X43 VGND VDPWR VGND VGND sky130_fd_pr__nfet_01v8 ad=0.143 pd=1.62 as=0 ps=0 w=0.55 l=0.59
X44 LELO_GR01_0.x7.x7.S LELO_GR01_0.x7.x6<3>.G LELO_GR01_0.x7.x6<3>.G VGND sky130_fd_pr__nfet_01v8_lvt ad=0.5088 pd=2.98 as=0.3168 ps=1.62 w=0.96 l=0.94
X45 a_11601_2649# a_11445_2554# a_11746_2778# VDPWR sky130_fd_pr__pfet_01v8_hvt ad=0.07245 pd=0.765 as=0.1155 ps=0.97 w=0.42 l=0.15
X46 a_13745_3198# digital_0.clkbuf_1_0__f_clk.X VGND VGND sky130_fd_pr__nfet_01v8 ad=0.1092 pd=1.36 as=0.0567 ps=0.69 w=0.42 l=0.15
X47 VGND a_14981_4562# digital_0.output5.A VGND sky130_fd_pr__nfet_01v8 ad=0.169 pd=1.82 as=0.08775 ps=0.92 w=0.65 l=0.15
X48 VDPWR a_11416_3500# digital_0.clkbuf_1_0__f_clk.X VDPWR sky130_fd_pr__pfet_01v8_hvt ad=0.14 pd=1.28 as=0.14 ps=1.28 w=1 l=0.15
X49 a_7816_5264# a_8133_5374# a_8091_5498# VGND sky130_fd_pr__special_nfet_01v8 ad=0.0711 pd=0.755 as=0.0669 ps=0.75 w=0.36 l=0.15
X50 VDPWR a_9434_2956# a_9545_2956# VDPWR sky130_fd_pr__pfet_01v8_hvt ad=0.2726 pd=1.61 as=0.2173 ps=2.17 w=0.82 l=0.25
X51 VDPWR digital_0._108_.Q a_12512_5132# VDPWR sky130_fd_pr__pfet_01v8_hvt ad=0.1625 pd=1.325 as=0.135 ps=1.27 w=1 l=0.15
X52 digital_0.output12.A a_12405_2172# VDPWR VDPWR sky130_fd_pr__pfet_01v8_hvt ad=0.135 pd=1.27 as=0.3012 ps=2.66 w=1 l=0.15
X53 digital_0.clkload0.A a_6343_2930# VGND VGND sky130_fd_pr__nfet_01v8 ad=0.0588 pd=0.7 as=0.0588 ps=0.7 w=0.42 l=0.15
X54 digital_0.clkbuf_1_1__f_clk.A a_8735_3474# VGND VGND sky130_fd_pr__nfet_01v8 ad=0.0588 pd=0.7 as=0.1113 ps=1.37 w=0.42 l=0.15
X55 LELO_GR01_0.x7.x7.S LELO_GR01_0.x7.x7.G VGND VDPWR sky130_fd_pr__pfet_01v8_lvt ad=0.5088 pd=2.98 as=0.3168 ps=1.62 w=0.96 l=0.94
X56 a_10420_1298# a_10546_1482# VDPWR VDPWR sky130_fd_pr__pfet_01v8_hvt ad=0.2173 pd=2.17 as=0.2726 ps=1.61 w=0.82 l=0.25
X57 LELO_GR01_0.PWRUP_1V8 JNWTR_ORX1_CV_0.XA2.A VGND VGND sky130_fd_pr__nfet_01v8 ad=0.468 pd=2.84 as=0.468 ps=2.84 w=0.9 l=0.16
X58 digital_0._100_.D a_13101_4915# VGND VGND sky130_fd_pr__nfet_01v8 ad=0.169 pd=1.82 as=0.11285 ps=1.045 w=0.65 l=0.15
X59 a_9417_4838# digital_0.load_slew17.A digital_0._111_.RESET_B VDPWR sky130_fd_pr__pfet_01v8_hvt ad=0.135 pd=1.27 as=0.135 ps=1.27 w=1 l=0.15
X60 VGND VDPWR VGND VGND sky130_fd_pr__nfet_01v8 ad=0.143 pd=1.62 as=0 ps=0 w=0.55 l=0.59
X61 VDPWR VGND VDPWR VDPWR sky130_fd_pr__pfet_01v8_hvt ad=0.2262 pd=2.26 as=144.64371 ps=1.26674k w=0.87 l=0.59
X62 digital_0._115_.RESET_B digital_0.load_slew17.X a_13189_3750# VDPWR sky130_fd_pr__pfet_01v8_hvt ad=0.135 pd=1.27 as=0.26 ps=2.52 w=1 l=0.15
X63 VDPWR digital_0._069_.A a_7385_3750# VDPWR sky130_fd_pr__pfet_01v8_hvt ad=0.14 pd=1.28 as=0.14 ps=1.28 w=1 l=0.15
X64 a_12512_5452# digital_0.output13.A VGND VGND sky130_fd_pr__nfet_01v8 ad=0.08775 pd=0.92 as=0.08775 ps=0.92 w=0.65 l=0.15
X65 VGND ui_in<0> sky130_fd_pr__diode_pw2nd_05v5 perim=1.8e+06 area=2.025e+11
X66 LELO_GR01_0.x8.IBP_BG VGND sky130_fd_pr__cap_mim_m3_1 l=5 w=5
X67 LELO_GR01_0.x8.x5.CK LELO_GR01_0.x8.x3.A VDPWR VDPWR sky130_fd_pr__pfet_01v8 ad=0.468 pd=2.84 as=0.468 ps=2.84 w=0.9 l=0.16
X68 a_12164_2778# a_11406_2680# a_11601_2649# VDPWR sky130_fd_pr__pfet_01v8_hvt ad=0.0651 pd=0.73 as=0.07245 ps=0.765 w=0.42 l=0.15
X69 VGND a_15506_5676# a_15617_5676# VGND sky130_fd_pr__nfet_01v8 ad=0.1856 pd=1.26 as=0.17225 ps=1.83 w=0.65 l=0.25
X70 LELO_GR01_0.x7.xd1<4>.A LELO_GR01_0.x7.x15.I2 LELO_GR01_0.x7.x1.x5.IBN VGND sky130_fd_pr__nfet_01v8_lvt ad=0.3168 pd=1.62 as=0.5088 ps=2.98 w=0.96 l=0.94
X71 a_26374_18564# a_26158_16644# VGND sky130_fd_pr__res_high_po w=0.36 l=7.36
X72 digital_0._103_.RESET_B digital_0.load_slew17.A VDPWR VDPWR sky130_fd_pr__pfet_01v8_hvt ad=0.135 pd=1.27 as=0.26 ps=2.52 w=1 l=0.15
X73 VGND a_5925_3642# a_5886_3768# VGND sky130_fd_pr__nfet_01v8 ad=0.0567 pd=0.69 as=0.1092 ps=1.36 w=0.42 l=0.15
X74 VDPWR VGND VDPWR VDPWR sky130_fd_pr__pfet_01v8_hvt ad=0.2262 pd=2.26 as=0 ps=0 w=0.87 l=0.59
X75 a_7385_3750# digital_0._112_.Q digital_0._063_.B VDPWR sky130_fd_pr__pfet_01v8_hvt ad=0.135 pd=1.27 as=0.135 ps=1.27 w=1 l=0.15
X76 a_22698_18564# a_22914_16644# VGND sky130_fd_pr__res_high_po w=0.36 l=7.36
X77 VGND digital_0._113_.D a_6644_3866# VGND sky130_fd_pr__nfet_01v8 ad=0.2205 pd=1.89 as=0.066 ps=0.745 w=0.42 l=0.15
X78 VDPWR digital_0._101_.RESET_B a_13693_4018# VDPWR sky130_fd_pr__pfet_01v8_hvt ad=0.0819 pd=0.81 as=0.0567 ps=0.69 w=0.42 l=0.15
X79 a_14297_4286# digital_0.clkbuf_1_0__f_clk.X VDPWR VDPWR sky130_fd_pr__pfet_01v8_hvt ad=0.1664 pd=1.8 as=0.0864 ps=0.91 w=0.64 l=0.15
X80 a_17304_18564# a_17520_16644# VGND sky130_fd_pr__res_high_po w=0.36 l=7.36
X81 VDPWR VGND VDPWR VDPWR sky130_fd_pr__pfet_01v8_hvt ad=0.2262 pd=2.26 as=0 ps=0 w=0.87 l=0.59
X82 VDPWR LELO_GR01_0.x8.PWRUP_N_1V8 LELO_GR01_0.x8.x1.x5.x8.S VDPWR sky130_fd_pr__pfet_01v8_lvt ad=0.5088 pd=2.98 as=0.3168 ps=1.62 w=0.96 l=0.94
X83 a_6343_2930# digital_0.clkbuf_1_1__f_clk.A VGND VGND sky130_fd_pr__nfet_01v8 ad=0.0588 pd=0.7 as=0.0588 ps=0.7 w=0.42 l=0.15
X84 a_6575_1868# digital_0._063_.A VDPWR VDPWR sky130_fd_pr__pfet_01v8_hvt ad=0.135 pd=1.27 as=0.1625 ps=1.325 w=1 l=0.15
X85 a_6075_1842# digital_0._113_.Q VDPWR VDPWR sky130_fd_pr__pfet_01v8_hvt ad=0.0567 pd=0.69 as=0.16655 ps=1.39 w=0.42 l=0.15
X86 VGND a_8003_1324# a_8109_1324# VGND sky130_fd_pr__nfet_01v8 ad=0.097 pd=0.975 as=0.1092 ps=1.36 w=0.42 l=0.5
X87 a_14174_2412# a_13891_2412# a_14079_2412# VDPWR sky130_fd_pr__pfet_01v8_hvt ad=0.0567 pd=0.69 as=0.12495 ps=1.175 w=0.42 l=0.15
X88 a_12154_5452# digital_0._108_.Q VGND VGND sky130_fd_pr__nfet_01v8 ad=0.08775 pd=0.92 as=0.08775 ps=0.92 w=0.65 l=0.15
X89 VGND digital_0._114_.RESET_B a_9139_2412# VGND sky130_fd_pr__nfet_01v8 ad=0.12495 pd=1.015 as=0.06405 ps=0.725 w=0.42 l=0.15
X90 VDPWR VGND VDPWR VDPWR sky130_fd_pr__pfet_01v8_hvt ad=0.2262 pd=2.26 as=0 ps=0 w=0.87 l=0.59
X91 a_10082_13154# a_10298_11234# VGND sky130_fd_pr__res_high_po w=0.36 l=7.36
X92 VGND digital_0.load_slew17.A a_4341_4052# VGND sky130_fd_pr__nfet_01v8 ad=0.097 pd=0.975 as=0.1092 ps=1.36 w=0.42 l=0.15
X93 a_3336_4018# a_3462_4282# VGND VGND sky130_fd_pr__nfet_01v8 ad=0.17225 pd=1.83 as=0.1856 ps=1.26 w=0.65 l=0.25
X94 a_8091_5498# a_7529_5106# VGND VGND sky130_fd_pr__nfet_01v8 ad=0.0669 pd=0.75 as=0.12495 ps=1.015 w=0.42 l=0.15
X95 a_8797_1651# a_8615_1651# VDPWR VDPWR sky130_fd_pr__pfet_01v8_hvt ad=0.0441 pd=0.63 as=0.0693 ps=0.75 w=0.42 l=0.15
X96 digital_0._112_.RESET_B digital_0._116_.Q VGND VGND sky130_fd_pr__nfet_01v8 ad=0.08775 pd=0.92 as=0.08775 ps=0.92 w=0.65 l=0.15
X97 LELO_GR01_0.x7.x1.x5.x8.G LELO_GR01_0.x7.x1.x5.x9<2>.G VGND VGND sky130_fd_pr__nfet_01v8_lvt ad=0.3168 pd=1.62 as=0.5088 ps=2.98 w=0.96 l=0.94
X98 a_12512_5132# a_12154_5452# digital_0._108_.D VDPWR sky130_fd_pr__pfet_01v8_hvt ad=0.28 pd=2.56 as=0.135 ps=1.27 w=1 l=0.15
X99 digital_0._060_.B a_8389_3276# VGND VGND sky130_fd_pr__nfet_01v8 ad=0.08775 pd=0.92 as=0.169 ps=1.82 w=0.65 l=0.15
X100 VGND LELO_GR01_0.x7.xd1<4>.A LELO_GR01_0.x7.x18.D VGND sky130_fd_pr__nfet_01v8_lvt ad=0.5088 pd=2.98 as=0.3168 ps=1.62 w=0.96 l=0.94
X101 VDPWR LELO_GR01_0.x7.xd1<4>.A LELO_GR01_0.x7.x15.I2 VDPWR sky130_fd_pr__pfet_01v8_lvt ad=0.5088 pd=2.98 as=0.3168 ps=1.62 w=0.96 l=0.94
X102 a_14834_2778# a_13891_2412# a_14726_2778# VDPWR sky130_fd_pr__pfet_01v8_hvt ad=0.0441 pd=0.63 as=0.0819 ps=0.81 w=0.42 l=0.15
X103 VGND digital_0._115_.RESET_B a_11163_2412# VGND sky130_fd_pr__nfet_01v8 ad=0.12495 pd=1.015 as=0.06405 ps=0.725 w=0.42 l=0.15
X104 a_4545_2110# digital_0.clkload0.A VDPWR VDPWR sky130_fd_pr__pfet_01v8_hvt ad=0.1664 pd=1.8 as=0.0864 ps=0.91 w=0.64 l=0.15
X105 a_12603_2956# a_12367_2956# VGND VGND sky130_fd_pr__nfet_01v8 ad=0.1092 pd=1.36 as=0.0567 ps=0.69 w=0.42 l=0.5
X106 a_4586_8824# a_4802_6904# VGND sky130_fd_pr__res_high_po w=0.36 l=7.36
X107 VGND digital_0.load_slew15.X digital_0._116_.SET_B VGND sky130_fd_pr__nfet_01v8 ad=0.169 pd=1.82 as=0.08775 ps=0.92 w=0.65 l=0.15
X108 a_14459_4830# a_14241_4588# VGND VGND sky130_fd_pr__nfet_01v8 ad=0.0999 pd=0.985 as=0.1346 ps=1.15 w=0.64 l=0.15
X109 VGND digital_0.hold28.A a_7695_6003# VGND sky130_fd_pr__nfet_01v8 ad=0.1449 pd=1.11 as=0.1092 ps=1.36 w=0.42 l=0.15
X110 VGND a_6343_2930# digital_0.clkload0.A VGND sky130_fd_pr__nfet_01v8 ad=0.0588 pd=0.7 as=0.0588 ps=0.7 w=0.42 l=0.15
X111 a_14729_5106# a_14573_5374# a_14874_5132# VDPWR sky130_fd_pr__pfet_01v8_hvt ad=0.07245 pd=0.765 as=0.1155 ps=0.97 w=0.42 l=0.15
X112 digital_0._108_.RESET_B digital_0._116_.Q VGND VGND sky130_fd_pr__nfet_01v8 ad=0.08775 pd=0.92 as=0.182 ps=1.86 w=0.65 l=0.15
X113 VDPWR digital_0.clkbuf_1_0__f_clk.X a_13725_2412# VDPWR sky130_fd_pr__pfet_01v8_hvt ad=0.0864 pd=0.91 as=0.1664 ps=1.8 w=0.64 l=0.15
X114 a_4149_2930# a_3993_3198# a_4294_2956# VDPWR sky130_fd_pr__pfet_01v8_hvt ad=0.07245 pd=0.765 as=0.1155 ps=0.97 w=0.42 l=0.15
X115 VGND a_14726_2778# a_15300_2412# VGND sky130_fd_pr__nfet_01v8 ad=0.08775 pd=0.92 as=0.169 ps=1.82 w=0.65 l=0.15
X116 VGND digital_0._109_.D a_11980_4954# VGND sky130_fd_pr__nfet_01v8 ad=0.2205 pd=1.89 as=0.066 ps=0.745 w=0.42 l=0.15
X117 VDPWR digital_0._109_.D a_11980_4954# VDPWR sky130_fd_pr__pfet_01v8_hvt ad=0.1092 pd=1.36 as=0.0651 ps=0.73 w=0.42 l=0.15
X118 a_6943_4588# a_6564_4954# a_6871_4588# VGND sky130_fd_pr__nfet_01v8 ad=0.1401 pd=1.1 as=0.0441 ps=0.63 w=0.42 l=0.15
X119 a_7580_13154# a_7796_11234# VGND sky130_fd_pr__res_high_po w=0.36 l=7.36
X120 a_28070_15064# a_27854_13144# VGND sky130_fd_pr__res_high_po w=0.36 l=7.36
X121 a_6435_4588# a_5873_4562# VGND VGND sky130_fd_pr__nfet_01v8 ad=0.0669 pd=0.75 as=0.12495 ps=1.015 w=0.42 l=0.15
X122 VGND VDPWR VGND VGND sky130_fd_pr__nfet_01v8 ad=0.143 pd=1.62 as=0 ps=0 w=0.55 l=0.59
X123 digital_0._112_.D digital_0._063_.B a_5461_2956# VDPWR sky130_fd_pr__pfet_01v8_hvt ad=0.135 pd=1.27 as=0.26 ps=2.52 w=1 l=0.15
X124 VDPWR a_13141_2930# digital_0.output13.A VDPWR sky130_fd_pr__pfet_01v8_hvt ad=0.3012 pd=2.66 as=0.135 ps=1.27 w=1 l=0.15
X125 VGND clk a_8735_3474# VGND sky130_fd_pr__nfet_01v8 ad=0.0588 pd=0.7 as=0.0588 ps=0.7 w=0.42 l=0.15
X126 a_13962_2234# digital_0.hold28.X VGND VGND sky130_fd_pr__nfet_01v8 ad=0.066 pd=0.745 as=0.2205 ps=1.89 w=0.42 l=0.15
X127 VDPWR a_14622_2246# a_14797_2172# VDPWR sky130_fd_pr__pfet_01v8_hvt ad=0.1134 pd=1.38 as=0.0567 ps=0.69 w=0.42 l=0.15
X128 VGND a_6968_4276# digital_0._063_.A VGND sky130_fd_pr__nfet_01v8 ad=0.1304 pd=1.105 as=0.08775 ps=0.92 w=0.65 l=0.15
X129 digital_0._116_.D a_13042_1476# VGND VGND sky130_fd_pr__nfet_01v8 ad=0.091 pd=0.93 as=0.17225 ps=1.83 w=0.65 l=0.15
X130 digital_0._108_.D a_12154_5452# VGND VGND sky130_fd_pr__nfet_01v8 ad=0.08775 pd=0.92 as=0.169 ps=1.82 w=0.65 l=0.15
X131 VDPWR LELO_GR01_0.PWRUP_1V8 LELO_GR01_0.x7.xd1<4>.A VDPWR sky130_fd_pr__pfet_01v8_lvt ad=0.5088 pd=2.98 as=0.3168 ps=1.62 w=0.96 l=0.94
X132 digital_0._110_.Q a_5873_4562# VDPWR VDPWR sky130_fd_pr__pfet_01v8_hvt ad=0.135 pd=1.27 as=0.26 ps=2.52 w=1 l=0.15
X133 VGND digital_0.output6.A a_15289_2956# VGND sky130_fd_pr__nfet_01v8 ad=0.1228 pd=1.065 as=0.1134 ps=1.38 w=0.42 l=0.15
R0 uio_oe<5> JNWTR_TIEH_CV_0.Y sky130_fd_pr__res_generic_m4 w=0.3 l=0.3
X134 a_15292_5132# a_14534_5248# a_14729_5106# VDPWR sky130_fd_pr__pfet_01v8_hvt ad=0.0651 pd=0.73 as=0.07245 ps=0.765 w=0.42 l=0.15
X135 digital_0._107_.RESET_B digital_0.load_slew15.X VGND VGND sky130_fd_pr__nfet_01v8 ad=0.08775 pd=0.92 as=0.169 ps=1.82 w=0.65 l=0.15
X136 VDPWR LELO_GR01_0.x7.xd1<4>.A sky130_fd_pr__cap_mim_m3_1 l=5 w=5
X137 LELO_GR01_0.x7.xd1<4>.A LELO_GR01_0.x7.x18.D LELO_GR01_0.x7.x6<3>.G VGND sky130_fd_pr__nfet_01v8_lvt ad=0.3168 pd=1.62 as=0.5088 ps=2.98 w=0.96 l=0.94
X138 a_5018_8824# a_4802_6904# VGND sky130_fd_pr__res_high_po w=0.36 l=7.36
X139 a_4712_2956# a_3954_3072# a_4149_2930# VDPWR sky130_fd_pr__pfet_01v8_hvt ad=0.0651 pd=0.73 as=0.07245 ps=0.765 w=0.42 l=0.15
X140 LELO_GR01_0.x7.x10.P a_23778_16644# VGND sky130_fd_pr__res_high_po w=0.36 l=7.36
X141 LELO_GR01_0.x7.x1.x5.x9<2>.G LELO_GR01_0.x8.PWRUP_N_1V8 VGND VGND sky130_fd_pr__nfet_01v8_lvt ad=0.3168 pd=1.62 as=0.5088 ps=2.98 w=0.96 l=0.94
X142 a_10979_4588# a_10944_4840# a_10657_4562# VGND sky130_fd_pr__nfet_01v8 ad=0.06405 pd=0.725 as=0.1092 ps=1.36 w=0.42 l=0.15
X143 a_8133_5374# digital_0.clkload0.A VDPWR VDPWR sky130_fd_pr__pfet_01v8_hvt ad=0.1664 pd=1.8 as=0.0864 ps=0.91 w=0.64 l=0.15
X144 VDPWR digital_0._060_.A_N a_9677_1690# VDPWR sky130_fd_pr__pfet_01v8_hvt ad=0.07665 pd=0.785 as=0.1092 ps=1.36 w=0.42 l=0.15
X145 VDPWR digital_0.hold28.A a_13315_4915# VDPWR sky130_fd_pr__pfet_01v8_hvt ad=0.15835 pd=1.395 as=0.07665 ps=0.785 w=0.42 l=0.15
X146 digital_0.clkload0.A a_6343_2930# VGND VGND sky130_fd_pr__nfet_01v8 ad=0.0588 pd=0.7 as=0.1113 ps=1.37 w=0.42 l=0.15
X147 VDPWR VGND VDPWR VDPWR sky130_fd_pr__pfet_01v8_hvt ad=0.2262 pd=2.26 as=0 ps=0 w=0.87 l=0.59
X148 VDPWR a_10657_4562# digital_0._109_.Q VDPWR sky130_fd_pr__pfet_01v8_hvt ad=0.3012 pd=2.66 as=0.135 ps=1.27 w=1 l=0.15
X149 a_4459_3322# a_4080_2956# a_4387_3322# VGND sky130_fd_pr__nfet_01v8 ad=0.1401 pd=1.1 as=0.0441 ps=0.63 w=0.42 l=0.15
X150 VDPWR digital_0.hold28.A a_13951_3827# VDPWR sky130_fd_pr__pfet_01v8_hvt ad=0.0693 pd=0.75 as=0.1176 ps=1.4 w=0.42 l=0.15
X151 digital_0._067_.B digital_0._069_.A VGND VGND sky130_fd_pr__nfet_01v8 ad=0.08775 pd=0.92 as=0.08775 ps=0.92 w=0.65 l=0.15
X152 VDPWR digital_0._109_.RESET_B a_11562_4954# VDPWR sky130_fd_pr__pfet_01v8_hvt ad=0.07035 pd=0.755 as=0.1092 ps=1.36 w=0.42 l=0.15
X153 VDPWR a_11416_3500# digital_0.clkbuf_1_0__f_clk.X VDPWR sky130_fd_pr__pfet_01v8_hvt ad=0.14 pd=1.28 as=0.14 ps=1.28 w=1 l=0.15
X154 VGND digital_0._111_.RESET_B a_8403_4410# VGND sky130_fd_pr__nfet_01v8 ad=0.12495 pd=1.015 as=0.06405 ps=0.725 w=0.42 l=0.15
X155 LELO_GR01_0.x8.IBP_BG LELO_GR01_0.x8.PWRUP_N_1V8 VGND VGND sky130_fd_pr__nfet_01v8_lvt ad=0.3168 pd=1.62 as=0.5088 ps=2.98 w=0.96 l=0.94
X156 a_21834_18564# a_22050_16644# VGND sky130_fd_pr__res_high_po w=0.36 l=7.36
X157 VGND digital_0._067_.B digital_0._110_.D VGND sky130_fd_pr__nfet_01v8 ad=0.08775 pd=0.92 as=0.08775 ps=0.92 w=0.65 l=0.15
X158 VDPWR a_6343_2930# digital_0.clkload0.A VDPWR sky130_fd_pr__pfet_01v8_hvt ad=0.14 pd=1.28 as=0.14 ps=1.28 w=1 l=0.15
X159 a_13315_4915# digital_0.hold25.X a_13101_4915# VDPWR sky130_fd_pr__pfet_01v8_hvt ad=0.07665 pd=0.785 as=0.1932 ps=1.34 w=0.42 l=0.15
X160 a_4793_5106# a_4637_5374# a_4938_5132# VDPWR sky130_fd_pr__pfet_01v8_hvt ad=0.07245 pd=0.765 as=0.1155 ps=0.97 w=0.42 l=0.15
X161 VDPWR a_8081_4018# digital_0._111_.Q VDPWR sky130_fd_pr__pfet_01v8_hvt ad=0.3012 pd=2.66 as=0.135 ps=1.27 w=1 l=0.15
X162 VGND VDPWR VGND VGND sky130_fd_pr__nfet_01v8 ad=0.143 pd=1.62 as=0 ps=0 w=0.55 l=0.59
X163 a_3437_1868# digital_0._116_.Q VDPWR VDPWR sky130_fd_pr__pfet_01v8_hvt ad=0.28 pd=2.56 as=0.135 ps=1.27 w=1 l=0.15
X164 a_8050_5132# a_7529_5106# VDPWR VDPWR sky130_fd_pr__pfet_01v8_hvt ad=0.0567 pd=0.69 as=0.0819 ps=0.81 w=0.42 l=0.15
X165 VDPWR VGND VDPWR VDPWR sky130_fd_pr__pfet_01v8_hvt ad=0.2262 pd=2.26 as=0 ps=0 w=0.87 l=0.59
X166 a_5925_2554# digital_0.input1.X VDPWR VDPWR sky130_fd_pr__pfet_01v8_hvt ad=0.1664 pd=1.8 as=0.0864 ps=0.91 w=0.64 l=0.15
X167 a_14806_4588# a_13891_4588# a_14459_4830# VGND sky130_fd_pr__special_nfet_01v8 ad=0.0711 pd=0.755 as=0.0999 ps=0.985 w=0.36 l=0.15
X168 LELO_GR01_0.x8.x1.x5.x9<2>.G LELO_GR01_0.x8.PWRUP_N_1V8 VGND VGND sky130_fd_pr__nfet_01v8_lvt ad=0.3168 pd=1.62 as=0.5088 ps=2.98 w=0.96 l=0.94
X169 LELO_GR01_0.x7.x6<3>.G LELO_GR01_0.x7.x6<3>.G LELO_GR01_0.x7.x7.S VGND sky130_fd_pr__nfet_01v8_lvt ad=0.3168 pd=1.62 as=0.5088 ps=2.98 w=0.96 l=0.94
X170 digital_0._109_.RESET_B digital_0._116_.Q VGND VGND sky130_fd_pr__nfet_01v8 ad=0.08775 pd=0.92 as=0.08775 ps=0.92 w=0.65 l=0.15
X171 LELO_GR01_0.x7.x1.x5.x8.S LELO_GR01_0.x7.x1.x5.x8.G LELO_GR01_0.x7.x1.x5.x8.G LELO_GR01_0.x7.x1.x5.x8.S sky130_fd_pr__pfet_01v8_lvt ad=0.5088 pd=2.98 as=0.3168 ps=1.62 w=0.96 l=0.94
X172 a_14494_2412# digital_0._116_.SET_B VGND VGND sky130_fd_pr__nfet_01v8 ad=0.0441 pd=0.63 as=0.0882 ps=0.84 w=0.42 l=0.15
X173 VGND digital_0.hold28.A a_4383_3827# VGND sky130_fd_pr__nfet_01v8 ad=0.1449 pd=1.11 as=0.1092 ps=1.36 w=0.42 l=0.15
X174 digital_0._102_.RESET_B digital_0.load_slew17.A VGND VGND sky130_fd_pr__nfet_01v8 ad=0.08775 pd=0.92 as=0.169 ps=1.82 w=0.65 l=0.15
X175 VGND LELO_GR01_0.x8.PWRUP_N_1V8 LELO_GR01_0.x8.x7.D VGND sky130_fd_pr__nfet_01v8_lvt ad=0.5088 pd=2.98 as=0.3168 ps=1.62 w=0.96 l=0.94
X176 a_5356_5132# a_4598_5248# a_4793_5106# VDPWR sky130_fd_pr__pfet_01v8_hvt ad=0.0651 pd=0.73 as=0.07245 ps=0.765 w=0.42 l=0.15
X177 LELO_GR01_0.x7.x26.P a_26350_13144# VGND sky130_fd_pr__res_high_po w=0.36 l=7.36
X178 VDPWR digital_0._115_.Q a_11149_2956# VDPWR sky130_fd_pr__pfet_01v8_hvt ad=0.135 pd=1.27 as=0.275 ps=2.55 w=1 l=0.15
X179 VDPWR VGND VDPWR VDPWR sky130_fd_pr__pfet_01v8_hvt ad=0.2262 pd=2.26 as=0 ps=0 w=0.87 l=0.59
X180 a_6280_5650# a_6406_5834# VDPWR VDPWR sky130_fd_pr__pfet_01v8_hvt ad=0.2173 pd=2.17 as=0.2726 ps=1.61 w=0.82 l=0.25
X181 VGND digital_0._106_.D a_9404_1868# VGND sky130_fd_pr__nfet_01v8 ad=0.2205 pd=1.89 as=0.066 ps=0.745 w=0.42 l=0.15
X182 VGND digital_0.clkload0.A a_11149_1874# VGND sky130_fd_pr__nfet_01v8 ad=0.0567 pd=0.69 as=0.1092 ps=1.36 w=0.42 l=0.15
X183 digital_0.output9.A a_3389_2930# VDPWR VDPWR sky130_fd_pr__pfet_01v8_hvt ad=0.135 pd=1.27 as=0.26 ps=2.52 w=1 l=0.15
X184 VDPWR digital_0.load_slew15.X digital_0._118_.RESET_B VDPWR sky130_fd_pr__pfet_01v8_hvt ad=0.26 pd=2.52 as=0.135 ps=1.27 w=1 l=0.15
X185 VDPWR a_6475_5430# a_6505_5171# VDPWR sky130_fd_pr__pfet_01v8_hvt ad=0.0693 pd=0.75 as=0.0441 ps=0.63 w=0.42 l=0.15
X186 a_26806_18564# a_27022_16644# VGND sky130_fd_pr__res_high_po w=0.36 l=7.36
X187 VGND digital_0._069_.A digital_0._109_.D VGND sky130_fd_pr__nfet_01v8 ad=0.08775 pd=0.92 as=0.08775 ps=0.92 w=0.65 l=0.15
X188 digital_0._116_.Q a_15300_2412# VDPWR VDPWR sky130_fd_pr__pfet_01v8_hvt ad=0.135 pd=1.27 as=0.135 ps=1.27 w=1 l=0.15
X189 a_4228_2000# a_4506_1984# a_4462_1868# VDPWR sky130_fd_pr__pfet_01v8_hvt ad=0.0588 pd=0.7 as=0.0567 ps=0.69 w=0.42 l=0.15
X190 VDPWR digital_0.output13.A a_12512_5132# VDPWR sky130_fd_pr__pfet_01v8_hvt ad=0.135 pd=1.27 as=0.26 ps=2.52 w=1 l=0.15
X191 a_11570_2234# digital_0._107_.D VDPWR VDPWR sky130_fd_pr__pfet_01v8_hvt ad=0.0651 pd=0.73 as=0.1092 ps=1.36 w=0.42 l=0.15
X192 VGND VDPWR VGND VGND sky130_fd_pr__nfet_01v8 ad=0.143 pd=1.62 as=0 ps=0 w=0.55 l=0.59
X193 VGND VDPWR VGND VGND sky130_fd_pr__nfet_01v8 ad=0.143 pd=1.62 as=0 ps=0 w=0.55 l=0.59
X194 a_11883_1842# a_11665_2246# VDPWR VDPWR sky130_fd_pr__pfet_01v8_hvt ad=0.12915 pd=1.185 as=0.2184 ps=2.2 w=0.84 l=0.15
X195 VDPWR a_10420_1298# uio_out<7> VDPWR sky130_fd_pr__pfet_01v8_hvt ad=0.2726 pd=1.61 as=0.495 ps=2.99 w=1 l=0.15
X196 VGND a_6343_2930# digital_0.clkload0.A VGND sky130_fd_pr__nfet_01v8 ad=0.05775 pd=0.695 as=0.0588 ps=0.7 w=0.42 l=0.15
X197 VGND a_8735_3474# digital_0.clkbuf_1_1__f_clk.A VGND sky130_fd_pr__nfet_01v8 ad=0.0588 pd=0.7 as=0.0588 ps=0.7 w=0.42 l=0.15
X198 VDPWR a_8735_3474# digital_0.clkbuf_1_1__f_clk.A VDPWR sky130_fd_pr__pfet_01v8_hvt ad=0.1375 pd=1.275 as=0.14 ps=1.28 w=1 l=0.15
X199 VGND digital_0._118_.RESET_B a_13463_3322# VGND sky130_fd_pr__nfet_01v8 ad=0.12495 pd=1.015 as=0.06405 ps=0.725 w=0.42 l=0.15
X200 VDPWR LELO_GR01_0.PWRUP_1V8 LELO_GR01_0.x7.x1.x7.D VDPWR sky130_fd_pr__pfet_01v8_lvt ad=0.5088 pd=2.98 as=0.3168 ps=1.62 w=0.96 l=0.94
X201 a_11601_2649# a_11406_2680# a_11911_2412# VGND sky130_fd_pr__special_nfet_01v8 ad=0.0594 pd=0.69 as=0.1401 ps=1.1 w=0.36 l=0.15
X202 VDPWR digital_0._116_.SET_B a_14726_2778# VDPWR sky130_fd_pr__pfet_01v8_hvt ad=0.12075 pd=1.165 as=0.1092 ps=1.36 w=0.42 l=0.15
X203 uio_out<1> a_15617_2956# VGND VGND sky130_fd_pr__nfet_01v8 ad=0.2079 pd=1.83 as=0.1856 ps=1.26 w=0.42 l=0.15
X204 a_9104_2664# a_9421_2554# a_9379_2412# VGND sky130_fd_pr__special_nfet_01v8 ad=0.0711 pd=0.755 as=0.0669 ps=0.75 w=0.36 l=0.15
X205 VGND a_7175_5676# a_7281_5676# VGND sky130_fd_pr__nfet_01v8 ad=0.097 pd=0.975 as=0.1092 ps=1.36 w=0.42 l=0.5
X206 a_11969_4018# a_11813_4286# a_12114_4044# VDPWR sky130_fd_pr__pfet_01v8_hvt ad=0.07245 pd=0.765 as=0.1155 ps=0.97 w=0.42 l=0.15
X207 a_7385_3750# digital_0._065_.A2_N VDPWR VDPWR sky130_fd_pr__pfet_01v8_hvt ad=0.28 pd=2.56 as=0.14 ps=1.28 w=1 l=0.15
X208 a_11261_4730# digital_0.input1.X VDPWR VDPWR sky130_fd_pr__pfet_01v8_hvt ad=0.1664 pd=1.8 as=0.0864 ps=0.91 w=0.64 l=0.15
X209 a_14729_5106# a_14534_5248# a_15039_5498# VGND sky130_fd_pr__special_nfet_01v8 ad=0.0594 pd=0.69 as=0.1401 ps=1.1 w=0.36 l=0.15
X210 VGND a_8133_5374# a_8094_5248# VGND sky130_fd_pr__nfet_01v8 ad=0.0567 pd=0.69 as=0.1092 ps=1.36 w=0.42 l=0.15
X211 a_5031_5498# digital_0._102_.RESET_B VGND VGND sky130_fd_pr__nfet_01v8 ad=0.0441 pd=0.63 as=0.1346 ps=1.15 w=0.42 l=0.15
X212 a_6343_2930# digital_0.clkbuf_1_1__f_clk.A VDPWR VDPWR sky130_fd_pr__pfet_01v8_hvt ad=0.14 pd=1.28 as=0.14 ps=1.28 w=1 l=0.15
X213 a_9151_2234# a_8772_1868# a_9079_2234# VGND sky130_fd_pr__nfet_01v8 ad=0.1401 pd=1.1 as=0.0441 ps=0.63 w=0.42 l=0.15
X214 a_6226_3866# a_6012_3866# VDPWR VDPWR sky130_fd_pr__pfet_01v8_hvt ad=0.1155 pd=0.97 as=0.07035 ps=0.755 w=0.42 l=0.15
X215 digital_0._118_.RESET_B digital_0.load_slew15.X VGND VGND sky130_fd_pr__nfet_01v8 ad=0.08775 pd=0.92 as=0.169 ps=1.82 w=0.65 l=0.15
X216 a_12677_1298# digital_0.output12.A VDPWR VDPWR sky130_fd_pr__pfet_01v8_hvt ad=0.1092 pd=1.36 as=0.0567 ps=0.69 w=0.42 l=0.15
X217 a_11128_2664# a_11445_2554# a_11403_2412# VGND sky130_fd_pr__special_nfet_01v8 ad=0.0711 pd=0.755 as=0.0669 ps=0.75 w=0.36 l=0.15
X218 a_13795_5828# a_13891_5650# VDPWR VDPWR sky130_fd_pr__pfet_01v8_hvt ad=0.1092 pd=1.36 as=0.14075 ps=1.325 w=0.42 l=0.5
X219 VGND a_8081_1842# digital_0.output11.A VGND sky130_fd_pr__nfet_01v8 ad=0.2087 pd=2.02 as=0.08775 ps=0.92 w=0.65 l=0.15
X220 a_12230_2246# a_11149_1874# a_11883_1842# VDPWR sky130_fd_pr__pfet_01v8_hvt ad=0.0588 pd=0.7 as=0.12915 ps=1.185 w=0.42 l=0.15
X221 a_12339_2246# a_11149_1874# a_12230_2246# VGND sky130_fd_pr__special_nfet_01v8 ad=0.0669 pd=0.75 as=0.0711 ps=0.755 w=0.36 l=0.15
X222 LELO_GR01_0.x7.x7.S LELO_GR01_0.x7.x6<3>.G LELO_GR01_0.x7.x6<3>.G VGND sky130_fd_pr__nfet_01v8_lvt ad=0.5088 pd=2.98 as=0.3168 ps=1.62 w=0.96 l=0.94
X223 JNWTR_IVX1_CV_0.Y rst_n VDPWR VDPWR sky130_fd_pr__pfet_01v8 ad=0.468 pd=2.84 as=0.468 ps=2.84 w=0.9 l=0.16
X224 a_14046_2956# a_13832_2956# VDPWR VDPWR sky130_fd_pr__pfet_01v8_hvt ad=0.1155 pd=0.97 as=0.07035 ps=0.755 w=0.42 l=0.15
X225 a_14256_5264# a_14573_5374# a_14531_5498# VGND sky130_fd_pr__special_nfet_01v8 ad=0.0711 pd=0.755 as=0.0669 ps=0.75 w=0.36 l=0.15
X226 VGND VGND LELO_GR01_0.x7.x28.e sky130_fd_pr__pnp_05v5_W3p40L3p40
**devattr s=462400,2720
X227 VGND LELO_GR01_0.x7.x1.x5.x9<2>.G LELO_GR01_0.x7.x1.x5.x9<2>.G VGND sky130_fd_pr__nfet_01v8_lvt ad=0.5088 pd=2.98 as=0.3168 ps=1.62 w=0.96 l=0.94
X228 a_4724_5132# a_4598_5248# a_4320_5264# VGND sky130_fd_pr__special_nfet_01v8 ad=0.0999 pd=0.985 as=0.0711 ps=0.755 w=0.36 l=0.15
X229 LELO_GR01_0.x8.x1.x5.x9<2>.G LELO_GR01_0.x8.x1.x5.x8.G LELO_GR01_0.x8.x1.x5.x6.N LELO_GR01_0.x8.x1.x5.x6.N sky130_fd_pr__pfet_01v8_lvt ad=0.3168 pd=1.62 as=0.5088 ps=2.98 w=0.96 l=0.94
X230 digital_0._112_.RESET_B digital_0.load_slew17.X VGND VGND sky130_fd_pr__nfet_01v8 ad=0.08775 pd=0.92 as=0.169 ps=1.82 w=0.65 l=0.15
X231 VGND VDPWR VGND VGND sky130_fd_pr__nfet_01v8 ad=0.143 pd=1.62 as=0 ps=0 w=0.55 l=0.59
X232 a_12532_4044# a_11774_4160# a_11969_4018# VDPWR sky130_fd_pr__pfet_01v8_hvt ad=0.0651 pd=0.73 as=0.07245 ps=0.765 w=0.42 l=0.15
X233 VGND VDPWR VGND VGND sky130_fd_pr__nfet_01v8 ad=0.143 pd=1.62 as=0 ps=0 w=0.55 l=0.59
X234 digital_0.clkload0.A a_6343_2930# VGND VGND sky130_fd_pr__nfet_01v8 ad=0.0588 pd=0.7 as=0.0588 ps=0.7 w=0.42 l=0.15
X235 digital_0.clkbuf_1_1__f_clk.A a_8735_3474# VDPWR VDPWR sky130_fd_pr__pfet_01v8_hvt ad=0.14 pd=1.28 as=0.14 ps=1.28 w=1 l=0.15
X236 a_8573_4588# digital_0._111_.Q VGND VGND sky130_fd_pr__nfet_01v8 ad=0.0567 pd=0.69 as=0.0567 ps=0.69 w=0.42 l=0.15
X237 VGND a_6477_4730# a_6438_4856# VGND sky130_fd_pr__nfet_01v8 ad=0.0567 pd=0.69 as=0.1092 ps=1.36 w=0.42 l=0.15
X238 VDPWR a_11416_3500# digital_0.clkbuf_1_0__f_clk.X VDPWR sky130_fd_pr__pfet_01v8_hvt ad=0.14 pd=1.28 as=0.14 ps=1.28 w=1 l=0.15
X239 VGND digital_0.output9.A a_3443_2412# VGND sky130_fd_pr__nfet_01v8 ad=0.0567 pd=0.69 as=0.1092 ps=1.36 w=0.42 l=0.15
X240 VGND VDPWR VGND VGND sky130_fd_pr__nfet_01v8 ad=0.143 pd=1.62 as=0 ps=0 w=0.55 l=0.59
X241 a_7175_5676# a_6939_5676# VGND VGND sky130_fd_pr__nfet_01v8 ad=0.1092 pd=1.36 as=0.0567 ps=0.69 w=0.42 l=0.5
X242 digital_0.hold27.X a_4245_1324# VDPWR VDPWR sky130_fd_pr__pfet_01v8_hvt ad=0.26 pd=2.52 as=0.14075 ps=1.325 w=1 l=0.15
X243 VDPWR a_11417_4825# a_11348_4954# VDPWR sky130_fd_pr__pfet_01v8_hvt ad=0.2184 pd=2.2 as=0.12915 ps=1.185 w=0.84 l=0.15
X244 a_14797_2172# digital_0._119_.RESET_B VDPWR VDPWR sky130_fd_pr__pfet_01v8_hvt ad=0.0567 pd=0.69 as=0.0819 ps=0.81 w=0.42 l=0.15
X245 VGND a_10861_3474# digital_0.load_slew15.X VGND sky130_fd_pr__nfet_01v8 ad=0.08775 pd=0.92 as=0.08775 ps=0.92 w=0.65 l=0.15
X246 VGND VDPWR VGND VGND sky130_fd_pr__nfet_01v8 ad=0.143 pd=1.62 as=0 ps=0 w=0.55 l=0.59
X247 digital_0.clkbuf_1_0__f_clk.X a_11416_3500# VGND VGND sky130_fd_pr__nfet_01v8 ad=0.0588 pd=0.7 as=0.0588 ps=0.7 w=0.42 l=0.15
X248 LELO_GR01_0.x7.x20.D LELO_GR01_0.x8.PWRUP_N_1V8 LELO_GR01_0.x7.x19.D VDPWR sky130_fd_pr__pfet_01v8_lvt ad=0.5088 pd=2.98 as=0.3168 ps=1.62 w=0.96 l=0.94
X249 a_13707_1874# a_13541_1874# VDPWR VDPWR sky130_fd_pr__pfet_01v8_hvt ad=0.1664 pd=1.8 as=0.0864 ps=0.91 w=0.64 l=0.15
X250 VGND a_8841_1842# a_8772_1868# VGND sky130_fd_pr__nfet_01v8 ad=0.1346 pd=1.15 as=0.0999 ps=0.985 w=0.64 l=0.15
X251 LELO_GR01_0.x7.x29.N a_20744_13144# VGND sky130_fd_pr__res_high_po w=0.36 l=7.36
X252 LELO_GR01_0.x7.x7.S LELO_GR01_0.x7.x6<3>.G LELO_GR01_0.x7.x6<3>.G VGND sky130_fd_pr__nfet_01v8_lvt ad=0.5088 pd=2.98 as=0.3168 ps=1.62 w=0.96 l=0.94
X253 a_13101_4588# a_12847_4915# VGND VGND sky130_fd_pr__nfet_01v8 ad=0.0693 pd=0.75 as=0.1449 ps=1.11 w=0.42 l=0.15
X254 a_21402_18564# a_21618_16644# VGND sky130_fd_pr__res_high_po w=0.36 l=7.36
X255 digital_0.output11.A a_8081_1842# VDPWR VDPWR sky130_fd_pr__pfet_01v8_hvt ad=0.135 pd=1.27 as=0.26 ps=2.52 w=1 l=0.15
X256 a_5608_3752# a_5886_3768# a_5842_3866# VDPWR sky130_fd_pr__pfet_01v8_hvt ad=0.0588 pd=0.7 as=0.0567 ps=0.69 w=0.42 l=0.15
X257 a_11433_5132# digital_0._108_.Q VDPWR VDPWR sky130_fd_pr__pfet_01v8_hvt ad=0.28 pd=2.56 as=0.14 ps=1.28 w=1 l=0.15
X258 VGND LELO_GR01_0.x7.x1.x5.x9<2>.G LELO_GR01_0.x7.x1.x5.IBN VGND sky130_fd_pr__nfet_01v8_lvt ad=0.5088 pd=2.98 as=0.3168 ps=1.62 w=0.96 l=0.94
X259 LELO_GR01_0.x7.x10.P a_16224_16644# VGND sky130_fd_pr__res_high_po w=0.36 l=7.36
X260 VGND digital_0._065_.A2_N a_8671_3276# VGND sky130_fd_pr__nfet_01v8 ad=0.08775 pd=0.92 as=0.08775 ps=0.92 w=0.65 l=0.15
X261 a_4793_5106# a_4598_5248# a_5103_5498# VGND sky130_fd_pr__special_nfet_01v8 ad=0.0594 pd=0.69 as=0.1401 ps=1.1 w=0.36 l=0.15
X262 a_6081_2649# a_5925_2554# a_6226_2778# VDPWR sky130_fd_pr__pfet_01v8_hvt ad=0.07245 pd=0.765 as=0.1155 ps=0.97 w=0.42 l=0.15
X263 a_8735_3474# clk VGND VGND sky130_fd_pr__nfet_01v8 ad=0.0588 pd=0.7 as=0.0588 ps=0.7 w=0.42 l=0.15
X264 VDPWR VGND VDPWR VDPWR sky130_fd_pr__pfet_01v8_hvt ad=0.2262 pd=2.26 as=0 ps=0 w=0.87 l=0.59
X265 VDPWR digital_0.load_slew17.X a_9217_2956# VDPWR sky130_fd_pr__pfet_01v8_hvt ad=0.19265 pd=1.415 as=0.27 ps=2.54 w=1 l=0.15
X266 a_10786_1842# ui_in<0> VGND VGND sky130_fd_pr__nfet_01v8 ad=0.1134 pd=1.38 as=0.1228 ps=1.065 w=0.42 l=0.15
X267 VGND a_13042_1476# digital_0._116_.D VGND sky130_fd_pr__nfet_01v8 ad=0.1105 pd=0.99 as=0.091 ps=0.93 w=0.65 l=0.15
X268 VDPWR a_12323_1476# digital_0.hold26.X VDPWR sky130_fd_pr__pfet_01v8_hvt ad=0.14075 pd=1.325 as=0.26 ps=2.52 w=1 l=0.15
X269 a_10420_1298# a_10546_1482# VGND VGND sky130_fd_pr__nfet_01v8 ad=0.17225 pd=1.83 as=0.1856 ps=1.26 w=0.65 l=0.25
X270 digital_0._113_.RESET_B digital_0._116_.Q VGND VGND sky130_fd_pr__nfet_01v8 ad=0.08775 pd=0.92 as=0.08775 ps=0.92 w=0.65 l=0.15
X271 a_22902_15064# a_23118_13144# VGND sky130_fd_pr__res_high_po w=0.36 l=7.36
X272 JNWTR_ORX1_CV_0.XA2.A ui_in<1> JNWTR_ORX1_CV_0.XA1.MP1.S VDPWR sky130_fd_pr__pfet_01v8 ad=0.468 pd=2.84 as=0.288 ps=1.54 w=0.9 l=0.16
X273 a_7025_5132# digital_0._067_.A VDPWR VDPWR sky130_fd_pr__pfet_01v8_hvt ad=0.28 pd=2.56 as=0.135 ps=1.27 w=1 l=0.15
X274 VDPWR digital_0.load_slew17.A digital_0._102_.RESET_B VDPWR sky130_fd_pr__pfet_01v8_hvt ad=0.26 pd=2.52 as=0.135 ps=1.27 w=1 l=0.15
X275 digital_0.clkbuf_1_0__f_clk.X a_11416_3500# VDPWR VDPWR sky130_fd_pr__pfet_01v8_hvt ad=0.14 pd=1.28 as=0.14 ps=1.28 w=1 l=0.15
X276 a_13029_4915# a_12847_4915# VDPWR VDPWR sky130_fd_pr__pfet_01v8_hvt ad=0.0441 pd=0.63 as=0.0693 ps=0.75 w=0.42 l=0.15
X277 a_11362_2778# a_10841_2386# VDPWR VDPWR sky130_fd_pr__pfet_01v8_hvt ad=0.0567 pd=0.69 as=0.0819 ps=0.81 w=0.42 l=0.15
X278 a_6409_5498# digital_0.hold24.X a_6046_5364# VGND sky130_fd_pr__nfet_01v8 ad=0.0693 pd=0.75 as=0.09975 ps=0.895 w=0.42 l=0.15
X279 VDPWR digital_0.load_slew15.X digital_0._117_.RESET_B VDPWR sky130_fd_pr__pfet_01v8_hvt ad=0.26 pd=2.52 as=0.135 ps=1.27 w=1 l=0.15
X280 LELO_GR01_0.x7.x1.x5.x8.S a_10472_20216# VGND sky130_fd_pr__res_high_po w=0.36 l=7.36
X281 digital_0._108_.Q a_11209_4018# VDPWR VDPWR sky130_fd_pr__pfet_01v8_hvt ad=0.135 pd=1.27 as=0.26 ps=2.52 w=1 l=0.15
X282 a_6644_2778# a_5886_2680# a_6081_2649# VDPWR sky130_fd_pr__pfet_01v8_hvt ad=0.0651 pd=0.73 as=0.07245 ps=0.765 w=0.42 l=0.15
X283 a_9815_2412# digital_0._114_.RESET_B VGND VGND sky130_fd_pr__nfet_01v8 ad=0.0441 pd=0.63 as=0.1346 ps=1.15 w=0.42 l=0.15
X284 a_11257_5926# digital_0._116_.Q VDPWR VDPWR sky130_fd_pr__pfet_01v8_hvt ad=0.28 pd=2.56 as=0.135 ps=1.27 w=1 l=0.15
X285 LELO_GR01_0.x7.x24.D LELO_GR01_0.x8.PWRUP_N_1V8 LELO_GR01_0.x7.x23.D VDPWR sky130_fd_pr__pfet_01v8_lvt ad=0.5088 pd=2.98 as=0.3168 ps=1.62 w=0.96 l=0.94
X286 LELO_GR01_0.x8.x1.x5.IBN LELO_GR01_0.x8.IBP_BG LELO_GR01_0.x8.x1.x7.D VGND sky130_fd_pr__nfet_01v8_lvt ad=0.5088 pd=2.98 as=0.3168 ps=1.62 w=0.96 l=0.94
X287 VGND digital_0.load_slew17.A digital_0._103_.RESET_B VGND sky130_fd_pr__nfet_01v8 ad=0.169 pd=1.82 as=0.08775 ps=0.92 w=0.65 l=0.15
X288 VDPWR digital_0.hold28.A a_4851_3827# VDPWR sky130_fd_pr__pfet_01v8_hvt ad=0.15835 pd=1.395 as=0.07665 ps=0.785 w=0.42 l=0.15
X289 LELO_GR01_0.x7.x21.D LELO_GR01_0.x8.PWRUP_N_1V8 LELO_GR01_0.x7.x22.D VDPWR sky130_fd_pr__pfet_01v8_lvt ad=0.3168 pd=1.62 as=0.5088 ps=2.98 w=0.96 l=0.94
X290 VDPWR digital_0._069_.A a_8389_2956# VDPWR sky130_fd_pr__pfet_01v8_hvt ad=0.135 pd=1.27 as=0.215 ps=1.43 w=1 l=0.15
X291 VDPWR digital_0._069_.A a_7745_2412# VDPWR sky130_fd_pr__pfet_01v8_hvt ad=0.0777 pd=0.79 as=0.07455 ps=0.775 w=0.42 l=0.15
X292 VDPWR a_4139_1324# a_4245_1324# VDPWR sky130_fd_pr__pfet_01v8_hvt ad=0.14075 pd=1.325 as=0.1092 ps=1.36 w=0.42 l=0.5
X293 digital_0._107_.D a_11721_1651# VDPWR VDPWR sky130_fd_pr__pfet_01v8_hvt ad=0.26 pd=2.52 as=0.15835 ps=1.395 w=1 l=0.15
X294 a_11417_4825# a_11261_4730# a_11562_4954# VDPWR sky130_fd_pr__pfet_01v8_hvt ad=0.07245 pd=0.765 as=0.1155 ps=0.97 w=0.42 l=0.15
X295 VGND a_8289_5106# a_8220_5132# VGND sky130_fd_pr__nfet_01v8 ad=0.1346 pd=1.15 as=0.0999 ps=0.985 w=0.64 l=0.15
X296 VDPWR VGND VDPWR VDPWR sky130_fd_pr__pfet_01v8_hvt ad=0.2262 pd=2.26 as=0 ps=0 w=0.87 l=0.59
X297 VDPWR a_14797_2172# a_14784_1868# VDPWR sky130_fd_pr__pfet_01v8_hvt ad=0.0819 pd=0.81 as=0.0567 ps=0.69 w=0.42 l=0.15
X298 digital_0.clkload0.A a_6343_2930# VDPWR VDPWR sky130_fd_pr__pfet_01v8_hvt ad=0.14 pd=1.28 as=0.14 ps=1.28 w=1 l=0.15
X299 a_4149_2930# a_3954_3072# a_4459_3322# VGND sky130_fd_pr__special_nfet_01v8 ad=0.0594 pd=0.69 as=0.1401 ps=1.1 w=0.36 l=0.15
X300 VGND a_3336_4018# uio_out<4> VGND sky130_fd_pr__nfet_01v8 ad=0.1856 pd=1.26 as=0.2079 ps=1.83 w=0.42 l=0.15
X301 a_15160_4588# digital_0._100_.RESET_B VGND VGND sky130_fd_pr__nfet_01v8 ad=0.06405 pd=0.725 as=0.12495 ps=1.015 w=0.42 l=0.15
X302 a_3437_1868# digital_0.input3.X digital_0._113_.RESET_B VDPWR sky130_fd_pr__pfet_01v8_hvt ad=0.135 pd=1.27 as=0.135 ps=1.27 w=1 l=0.15
X303 VDPWR VGND VDPWR VDPWR sky130_fd_pr__pfet_01v8_hvt ad=0.2262 pd=2.26 as=0 ps=0 w=0.87 l=0.59
X304 digital_0._101_.D a_14205_3827# VDPWR VDPWR sky130_fd_pr__pfet_01v8_hvt ad=0.26 pd=2.52 as=0.15835 ps=1.395 w=1 l=0.15
X305 VGND VDPWR VGND VGND sky130_fd_pr__nfet_01v8 ad=0.143 pd=1.62 as=0 ps=0 w=0.55 l=0.59
X306 a_11969_4018# a_11774_4160# a_12279_4410# VGND sky130_fd_pr__special_nfet_01v8 ad=0.0594 pd=0.69 as=0.1401 ps=1.1 w=0.36 l=0.15
X307 digital_0._111_.D a_8739_4910# VGND VGND sky130_fd_pr__nfet_01v8 ad=0.08775 pd=0.92 as=0.09862 ps=0.98 w=0.65 l=0.15
X308 LELO_GR01_0.x7.x15.I2 LELO_GR01_0.x7.xd1<4>.A VDPWR VDPWR sky130_fd_pr__pfet_01v8_lvt ad=0.3168 pd=1.62 as=0.5088 ps=2.98 w=0.96 l=0.94
X309 a_4851_3827# digital_0.hold23.X a_4637_3827# VDPWR sky130_fd_pr__pfet_01v8_hvt ad=0.07665 pd=0.785 as=0.1932 ps=1.34 w=0.42 l=0.15
X310 VGND digital_0._112_.RESET_B a_5643_2412# VGND sky130_fd_pr__nfet_01v8 ad=0.12495 pd=1.015 as=0.06405 ps=0.725 w=0.42 l=0.15
X311 VGND VGND LELO_GR01_0.x7.x15.I1 sky130_fd_pr__pnp_05v5_W3p40L3p40
**devattr s=462400,2720
X312 a_22698_18564# a_22482_16644# VGND sky130_fd_pr__res_high_po w=0.36 l=7.36
X313 a_4595_5498# a_4033_5106# VGND VGND sky130_fd_pr__nfet_01v8 ad=0.0669 pd=0.75 as=0.12495 ps=1.015 w=0.42 l=0.15
X314 VDPWR digital_0._102_.RESET_B a_4938_5132# VDPWR sky130_fd_pr__pfet_01v8_hvt ad=0.07035 pd=0.755 as=0.1092 ps=1.36 w=0.42 l=0.15
X315 a_14297_4286# digital_0.clkbuf_1_0__f_clk.X VGND VGND sky130_fd_pr__nfet_01v8 ad=0.1092 pd=1.36 as=0.0567 ps=0.69 w=0.42 l=0.15
X316 VDPWR a_13693_4018# digital_0.output6.A VDPWR sky130_fd_pr__pfet_01v8_hvt ad=0.3012 pd=2.66 as=0.135 ps=1.27 w=1 l=0.15
X317 VDPWR VGND VDPWR VDPWR sky130_fd_pr__pfet_01v8_hvt ad=0.2262 pd=2.26 as=0 ps=0 w=0.87 l=0.59
X318 a_11980_4954# a_11222_4856# a_11417_4825# VDPWR sky130_fd_pr__pfet_01v8_hvt ad=0.0651 pd=0.73 as=0.07245 ps=0.765 w=0.42 l=0.15
X319 VDPWR digital_0._114_.RESET_B a_8817_2386# VDPWR sky130_fd_pr__pfet_01v8_hvt ad=0.0819 pd=0.81 as=0.0567 ps=0.69 w=0.42 l=0.15
X320 a_11496_4176# a_11813_4286# a_11771_4410# VGND sky130_fd_pr__special_nfet_01v8 ad=0.0711 pd=0.755 as=0.0669 ps=0.75 w=0.36 l=0.15
X321 VDPWR a_14149_5650# a_13891_5650# VDPWR sky130_fd_pr__pfet_01v8_hvt ad=0.0567 pd=0.69 as=0.1092 ps=1.36 w=0.42 l=0.5
X322 a_9969_2956# digital_0.load_slew15.A digital_0._114_.RESET_B VDPWR sky130_fd_pr__pfet_01v8_hvt ad=0.135 pd=1.27 as=0.135 ps=1.27 w=1 l=0.15
X323 VGND digital_0.load_slew17.A digital_0._110_.RESET_B VGND sky130_fd_pr__nfet_01v8 ad=0.169 pd=1.82 as=0.08775 ps=0.92 w=0.65 l=0.15
X324 a_4939_2234# digital_0._105_.RESET_B VGND VGND sky130_fd_pr__nfet_01v8 ad=0.0441 pd=0.63 as=0.1346 ps=1.15 w=0.42 l=0.15
X325 a_10786_1298# digital_0.output12.A VGND VGND sky130_fd_pr__nfet_01v8 ad=0.1134 pd=1.38 as=0.1228 ps=1.065 w=0.42 l=0.15
X326 VGND a_8817_2386# digital_0._114_.Q VGND sky130_fd_pr__nfet_01v8 ad=0.2087 pd=2.02 as=0.08775 ps=0.92 w=0.65 l=0.15
X327 VDPWR digital_0._103_.D a_8852_5132# VDPWR sky130_fd_pr__pfet_01v8_hvt ad=0.1092 pd=1.36 as=0.0651 ps=0.73 w=0.42 l=0.15
X328 a_8685_2110# digital_0.clkload0.A VGND VGND sky130_fd_pr__nfet_01v8 ad=0.1092 pd=1.36 as=0.0567 ps=0.69 w=0.42 l=0.15
X329 VGND a_9421_2554# a_9382_2680# VGND sky130_fd_pr__nfet_01v8 ad=0.0567 pd=0.69 as=0.1092 ps=1.36 w=0.42 l=0.15
X330 VDPWR VGND VDPWR VDPWR sky130_fd_pr__pfet_01v8_hvt ad=0.2262 pd=2.26 as=0 ps=0 w=0.87 l=0.59
X331 VGND digital_0._057_.D a_8022_2412# VGND sky130_fd_pr__nfet_01v8 ad=0.17515 pd=1.265 as=0.0693 ps=0.75 w=0.42 l=0.15
X332 a_4632_1868# a_4545_2110# a_4228_2000# VDPWR sky130_fd_pr__pfet_01v8_hvt ad=0.12915 pd=1.185 as=0.0588 ps=0.7 w=0.42 l=0.15
X333 VGND a_13155_2412# a_13261_2412# VGND sky130_fd_pr__nfet_01v8 ad=0.097 pd=0.975 as=0.1092 ps=1.36 w=0.42 l=0.5
X334 digital_0._106_.RESET_B digital_0.load_slew17.X VDPWR VDPWR sky130_fd_pr__pfet_01v8_hvt ad=0.135 pd=1.27 as=0.26 ps=2.52 w=1 l=0.15
X335 VDPWR VGND VDPWR VDPWR sky130_fd_pr__pfet_01v8_hvt ad=0.2262 pd=2.26 as=0 ps=0 w=0.87 l=0.59
X336 LELO_GR01_0.x7.x25.D LELO_GR01_0.x8.PWRUP_N_1V8 LELO_GR01_0.x7.x30.N VDPWR sky130_fd_pr__pfet_01v8_lvt ad=0.3168 pd=1.62 as=0.5088 ps=2.98 w=0.96 l=0.94
X337 a_14149_5650# digital_0.output5.A VGND VGND sky130_fd_pr__nfet_01v8 ad=0.1092 pd=1.36 as=0.0567 ps=0.69 w=0.42 l=0.15
X338 VDPWR digital_0._115_.RESET_B a_10841_2386# VDPWR sky130_fd_pr__pfet_01v8_hvt ad=0.0819 pd=0.81 as=0.0567 ps=0.69 w=0.42 l=0.15
X339 digital_0.hold23.X a_3785_2412# VDPWR VDPWR sky130_fd_pr__pfet_01v8_hvt ad=0.26 pd=2.52 as=0.14075 ps=1.325 w=1 l=0.15
X340 digital_0.load_slew15.A a_9545_2956# VDPWR VDPWR sky130_fd_pr__pfet_01v8_hvt ad=0.495 pd=2.99 as=0.2726 ps=1.61 w=1 l=0.15
X341 VDPWR a_13132_4276# digital_0._069_.A VDPWR sky130_fd_pr__pfet_01v8_hvt ad=0.15075 pd=1.345 as=0.135 ps=1.27 w=1 l=0.15
X342 VGND a_6372_1298# uio_out<6> VGND sky130_fd_pr__nfet_01v8 ad=0.1856 pd=1.26 as=0.2079 ps=1.83 w=0.42 l=0.15
X343 digital_0.hold21.X a_8109_1324# VDPWR VDPWR sky130_fd_pr__pfet_01v8_hvt ad=0.26 pd=2.52 as=0.14075 ps=1.325 w=1 l=0.15
X344 a_14531_1476# a_14627_1298# VDPWR VDPWR sky130_fd_pr__pfet_01v8_hvt ad=0.1092 pd=1.36 as=0.14075 ps=1.325 w=0.42 l=0.5
X345 a_6477_4730# digital_0.input1.X VDPWR VDPWR sky130_fd_pr__pfet_01v8_hvt ad=0.1664 pd=1.8 as=0.0864 ps=0.91 w=0.64 l=0.15
X346 VGND a_10841_2386# digital_0._115_.Q VGND sky130_fd_pr__nfet_01v8 ad=0.2087 pd=2.02 as=0.08775 ps=0.92 w=0.65 l=0.15
X347 a_8739_4910# digital_0._111_.Q a_8655_4910# VDPWR sky130_fd_pr__pfet_01v8_hvt ad=0.0928 pd=0.93 as=0.0864 ps=0.91 w=0.64 l=0.15
X348 a_14490_5132# a_13969_5106# VDPWR VDPWR sky130_fd_pr__pfet_01v8_hvt ad=0.0567 pd=0.69 as=0.0819 ps=0.81 w=0.42 l=0.15
X349 VDPWR a_6280_5650# uio_out<3> VDPWR sky130_fd_pr__pfet_01v8_hvt ad=0.2726 pd=1.61 as=0.495 ps=2.99 w=1 l=0.15
X350 LELO_GR01_0.x8.IBP_BG LELO_GR01_0.x8.x5.CK VGND VGND sky130_fd_pr__nfet_01v8_lvt ad=0.3168 pd=1.62 as=0.5088 ps=2.98 w=0.96 l=0.94
X351 a_13132_4276# digital_0.output13.A VDPWR VDPWR sky130_fd_pr__pfet_01v8_hvt ad=0.1092 pd=1.36 as=0.0567 ps=0.69 w=0.42 l=0.15
X352 a_3910_2956# a_3389_2930# VDPWR VDPWR sky130_fd_pr__pfet_01v8_hvt ad=0.0567 pd=0.69 as=0.0819 ps=0.81 w=0.42 l=0.15
X353 VDPWR VGND VDPWR VDPWR sky130_fd_pr__pfet_01v8_hvt ad=0.2262 pd=2.26 as=0 ps=0 w=0.87 l=0.59
X354 a_12207_4410# digital_0._108_.RESET_B VGND VGND sky130_fd_pr__nfet_01v8 ad=0.0441 pd=0.63 as=0.1346 ps=1.15 w=0.42 l=0.15
X355 a_7529_5106# a_7816_5264# VDPWR VDPWR sky130_fd_pr__pfet_01v8_hvt ad=0.0567 pd=0.69 as=0.1134 ps=1.38 w=0.42 l=0.15
X356 a_8869_1651# digital_0._114_.Q a_8797_1651# VDPWR sky130_fd_pr__pfet_01v8_hvt ad=0.1932 pd=1.34 as=0.0441 ps=0.63 w=0.42 l=0.15
X357 a_11417_4825# a_11222_4856# a_11727_4588# VGND sky130_fd_pr__special_nfet_01v8 ad=0.0594 pd=0.69 as=0.1401 ps=1.1 w=0.36 l=0.15
X358 VGND digital_0._103_.RESET_B a_7851_5498# VGND sky130_fd_pr__nfet_01v8 ad=0.12495 pd=1.015 as=0.06405 ps=0.725 w=0.42 l=0.15
X359 VGND a_4701_1842# a_4632_1868# VGND sky130_fd_pr__nfet_01v8 ad=0.1346 pd=1.15 as=0.0999 ps=0.985 w=0.64 l=0.15
X360 VDPWR a_11813_4286# a_11774_4160# VDPWR sky130_fd_pr__pfet_01v8_hvt ad=0.0864 pd=0.91 as=0.1664 ps=1.8 w=0.64 l=0.15
X361 a_20372_11699# a_22292_11915# VGND sky130_fd_pr__res_high_po w=0.36 l=7.36
X362 VDPWR a_14275_1842# a_14165_1868# VDPWR sky130_fd_pr__pfet_01v8_hvt ad=0.07035 pd=0.755 as=0.1155 ps=0.97 w=0.42 l=0.15
X363 LELO_GR01_0.x8.IBP_BG VGND sky130_fd_pr__cap_mim_m3_1 l=5 w=5
X364 a_18600_18564# a_18816_16644# VGND sky130_fd_pr__res_high_po w=0.36 l=7.36
X365 a_8869_1324# a_8615_1651# VGND VGND sky130_fd_pr__nfet_01v8 ad=0.0693 pd=0.75 as=0.1449 ps=1.11 w=0.42 l=0.15
X366 VDPWR a_4701_1842# a_4632_1868# VDPWR sky130_fd_pr__pfet_01v8_hvt ad=0.2184 pd=2.2 as=0.12915 ps=1.185 w=0.84 l=0.15
X367 VDPWR digital_0.clkbuf_1_1__f_clk.A a_6343_2930# VDPWR sky130_fd_pr__pfet_01v8_hvt ad=0.14 pd=1.28 as=0.14 ps=1.28 w=1 l=0.15
X368 digital_0._115_.D a_11234_3276# VGND VGND sky130_fd_pr__nfet_01v8 ad=0.08775 pd=0.92 as=0.169 ps=1.82 w=0.65 l=0.15
X369 VGND VDPWR VGND VGND sky130_fd_pr__nfet_01v8 ad=0.143 pd=1.62 as=0 ps=0 w=0.55 l=0.59
X370 VDPWR digital_0._105_.D a_5264_1868# VDPWR sky130_fd_pr__pfet_01v8_hvt ad=0.1092 pd=1.36 as=0.0651 ps=0.73 w=0.42 l=0.15
X371 digital_0.hold28.X a_12709_2956# VDPWR VDPWR sky130_fd_pr__pfet_01v8_hvt ad=0.26 pd=2.52 as=0.14075 ps=1.325 w=1 l=0.15
X372 VDPWR VGND VDPWR VDPWR sky130_fd_pr__pfet_01v8_hvt ad=0.2262 pd=2.26 as=0 ps=0 w=0.87 l=0.59
X373 a_12392_1868# a_11315_1874# a_12230_2246# VDPWR sky130_fd_pr__pfet_01v8_hvt ad=0.0567 pd=0.69 as=0.0588 ps=0.7 w=0.42 l=0.15
X374 a_4637_5374# digital_0.clkload0.A VDPWR VDPWR sky130_fd_pr__pfet_01v8_hvt ad=0.1664 pd=1.8 as=0.0864 ps=0.91 w=0.64 l=0.15
X375 VDPWR LELO_GR01_0.x7.xd1<4>.A LELO_GR01_0.x7.x15.I2 VDPWR sky130_fd_pr__pfet_01v8_lvt ad=0.5088 pd=2.98 as=0.3168 ps=1.62 w=0.96 l=0.94
X376 VGND digital_0.output13.A a_12154_5452# VGND sky130_fd_pr__nfet_01v8 ad=0.08775 pd=0.92 as=0.08775 ps=0.92 w=0.65 l=0.15
X377 LELO_GR01_0.x8.x8.D LELO_GR01_0.x8.x8.D LELO_GR01_0.x8.x8.D LELO_GR01_0.x8.x8.D sky130_fd_pr__pfet_01v8 ad=0.468 pd=2.84 as=5.8896 ps=34.72 w=0.9 l=0.16
X378 a_13155_2412# a_12919_2412# VGND VGND sky130_fd_pr__nfet_01v8 ad=0.1092 pd=1.36 as=0.0567 ps=0.69 w=0.42 l=0.5
X379 a_6631_1842# digital_0._113_.Q VGND VGND sky130_fd_pr__nfet_01v8 ad=0.08775 pd=0.92 as=0.08775 ps=0.92 w=0.65 l=0.15
X380 VDPWR VGND VDPWR VDPWR sky130_fd_pr__pfet_01v8_hvt ad=0.2262 pd=2.26 as=0 ps=0 w=0.87 l=0.59
X381 VGND a_7745_2412# digital_0._060_.A_N VGND sky130_fd_pr__nfet_01v8 ad=0.195 pd=1.9 as=0.10725 ps=0.98 w=0.65 l=0.15
X382 a_13132_4276# digital_0.output13.A a_13452_4404# VGND sky130_fd_pr__nfet_01v8 ad=0.1092 pd=1.36 as=0.0441 ps=0.63 w=0.42 l=0.15
X383 a_23334_15064# a_23550_13144# VGND sky130_fd_pr__res_high_po w=0.36 l=7.36
X384 a_3702_4018# digital_0.output9.A VGND VGND sky130_fd_pr__nfet_01v8 ad=0.1134 pd=1.38 as=0.1228 ps=1.065 w=0.42 l=0.15
X385 VGND VDPWR VGND VGND sky130_fd_pr__nfet_01v8 ad=0.143 pd=1.62 as=0 ps=0 w=0.55 l=0.59
X386 VGND a_6343_2930# digital_0.clkload0.A VGND sky130_fd_pr__nfet_01v8 ad=0.0588 pd=0.7 as=0.0588 ps=0.7 w=0.42 l=0.15
X387 VDPWR a_8735_3474# digital_0.clkbuf_1_1__f_clk.A VDPWR sky130_fd_pr__pfet_01v8_hvt ad=0.14 pd=1.28 as=0.14 ps=1.28 w=1 l=0.15
X388 a_7253_2386# digital_0.clkload0.A VGND VGND sky130_fd_pr__nfet_01v8 ad=0.1113 pd=1.37 as=0.07035 ps=0.755 w=0.42 l=0.15
X389 VDPWR VGND VDPWR VDPWR sky130_fd_pr__pfet_01v8_hvt ad=0.2262 pd=2.26 as=0 ps=0 w=0.87 l=0.59
X390 digital_0._103_.D a_7949_6003# VGND VGND sky130_fd_pr__nfet_01v8 ad=0.169 pd=1.82 as=0.11285 ps=1.045 w=0.65 l=0.15
X391 LELO_GR01_0.x8.x5.XA6.A LELO_GR01_0.x8.x5.XA5.A LELO_GR01_0.x8.x8.D LELO_GR01_0.x8.x8.D sky130_fd_pr__pfet_01v8 ad=0.468 pd=2.84 as=0.468 ps=2.84 w=0.9 l=0.16
X392 digital_0.clkbuf_1_0__f_clk.X a_11416_3500# VDPWR VDPWR sky130_fd_pr__pfet_01v8_hvt ad=0.14 pd=1.28 as=0.14 ps=1.28 w=1 l=0.15
X393 a_12323_1476# a_12419_1298# VGND VGND sky130_fd_pr__nfet_01v8 ad=0.1092 pd=1.36 as=0.097 ps=0.975 w=0.42 l=0.5
X394 VDPWR VGND VDPWR VDPWR sky130_fd_pr__pfet_01v8_hvt ad=0.2262 pd=2.26 as=0 ps=0 w=0.87 l=0.59
X395 VGND digital_0.hold19.X a_15292_5132# VGND sky130_fd_pr__nfet_01v8 ad=0.2205 pd=1.89 as=0.066 ps=0.745 w=0.42 l=0.15
X396 a_14426_3500# digital_0._109_.Q a_14205_3827# VGND sky130_fd_pr__nfet_01v8 ad=0.0693 pd=0.75 as=0.09975 ps=0.895 w=0.42 l=0.15
X397 VGND a_11416_3500# digital_0.clkbuf_1_0__f_clk.X VGND sky130_fd_pr__nfet_01v8 ad=0.05775 pd=0.695 as=0.0588 ps=0.7 w=0.42 l=0.15
X398 LELO_GR01_0.x7.x11.N a_29150_13144# VGND sky130_fd_pr__res_high_po w=0.36 l=7.36
X399 VGND a_6075_1842# digital_0._057_.D VGND sky130_fd_pr__nfet_01v8 ad=0.1118 pd=1.04 as=0.12675 ps=1.04 w=0.65 l=0.15
X400 digital_0.clkload0.A a_6343_2930# VDPWR VDPWR sky130_fd_pr__pfet_01v8_hvt ad=0.14 pd=1.28 as=0.14 ps=1.28 w=1 l=0.15
X401 a_4554_5132# a_4033_5106# VDPWR VDPWR sky130_fd_pr__pfet_01v8_hvt ad=0.0567 pd=0.69 as=0.0819 ps=0.81 w=0.42 l=0.15
X402 a_6280_5650# a_6406_5834# VGND VGND sky130_fd_pr__nfet_01v8 ad=0.17225 pd=1.83 as=0.1856 ps=1.26 w=0.65 l=0.25
X403 a_13891_4588# a_13725_4588# VDPWR VDPWR sky130_fd_pr__pfet_01v8_hvt ad=0.1664 pd=1.8 as=0.0864 ps=0.91 w=0.64 l=0.15
X404 VDPWR digital_0._117_.RESET_B a_13969_5106# VDPWR sky130_fd_pr__pfet_01v8_hvt ad=0.0819 pd=0.81 as=0.0567 ps=0.69 w=0.42 l=0.15
X405 VGND digital_0._063_.A digital_0._112_.D VGND sky130_fd_pr__nfet_01v8 ad=0.182 pd=1.86 as=0.08775 ps=0.92 w=0.65 l=0.15
X406 a_6012_3866# a_5925_3642# a_5608_3752# VDPWR sky130_fd_pr__pfet_01v8_hvt ad=0.12915 pd=1.185 as=0.0588 ps=0.7 w=0.42 l=0.15
X407 VDPWR digital_0._104_.RESET_B a_3389_2930# VDPWR sky130_fd_pr__pfet_01v8_hvt ad=0.0819 pd=0.81 as=0.0567 ps=0.69 w=0.42 l=0.15
X408 VDPWR a_11883_1842# a_11773_1868# VDPWR sky130_fd_pr__pfet_01v8_hvt ad=0.07035 pd=0.755 as=0.1155 ps=0.97 w=0.42 l=0.15
X409 VDPWR a_10786_1298# a_10546_1482# VDPWR sky130_fd_pr__pfet_01v8_hvt ad=0.19265 pd=1.415 as=0.2173 ps=2.17 w=0.82 l=0.25
X410 LELO_GR01_0.x7.x7.G a_10730_11234# VGND sky130_fd_pr__res_high_po w=0.36 l=7.36
X411 a_14876_2626# a_14726_2778# VDPWR VDPWR sky130_fd_pr__pfet_01v8_hvt ad=0.2226 pd=2.21 as=0.12075 ps=1.165 w=0.84 l=0.15
X412 digital_0._113_.RESET_B digital_0.input3.X VGND VGND sky130_fd_pr__nfet_01v8 ad=0.08775 pd=0.92 as=0.169 ps=1.82 w=0.65 l=0.15
X413 digital_0._104_.D a_4637_3827# VDPWR VDPWR sky130_fd_pr__pfet_01v8_hvt ad=0.26 pd=2.52 as=0.15835 ps=1.395 w=1 l=0.15
X414 VGND digital_0.load_slew17.X digital_0._105_.RESET_B VGND sky130_fd_pr__nfet_01v8 ad=0.169 pd=1.82 as=0.08775 ps=0.92 w=0.65 l=0.15
X415 a_6738_1298# digital_0.output11.A VGND VGND sky130_fd_pr__nfet_01v8 ad=0.1134 pd=1.38 as=0.1228 ps=1.065 w=0.42 l=0.15
X416 VDPWR a_3993_3198# a_3954_3072# VDPWR sky130_fd_pr__pfet_01v8_hvt ad=0.0864 pd=0.91 as=0.1664 ps=1.8 w=0.64 l=0.15
X417 a_6081_2649# a_5886_2680# a_6391_2412# VGND sky130_fd_pr__special_nfet_01v8 ad=0.0594 pd=0.69 as=0.1401 ps=1.1 w=0.36 l=0.15
X418 VDPWR a_8739_4910# digital_0._111_.D VDPWR sky130_fd_pr__pfet_01v8_hvt ad=0.285 pd=2.57 as=0.135 ps=1.27 w=1 l=0.15
X419 VDPWR a_11416_3500# digital_0.clkbuf_1_0__f_clk.X VDPWR sky130_fd_pr__pfet_01v8_hvt ad=0.14 pd=1.28 as=0.14 ps=1.28 w=1 l=0.15
X420 LELO_GR01_0.x8.x1.x5.IBN LELO_GR01_0.x8.x1.x5.x9<2>.G VGND VGND sky130_fd_pr__nfet_01v8_lvt ad=0.3168 pd=1.62 as=0.5088 ps=2.98 w=0.96 l=0.94
X421 VDPWR a_6968_4276# digital_0._063_.A VDPWR sky130_fd_pr__pfet_01v8_hvt ad=0.15075 pd=1.345 as=0.135 ps=1.27 w=1 l=0.15
X422 VGND VGND LELO_GR01_0.x7.x15.I1 sky130_fd_pr__pnp_05v5_W3p40L3p40
**devattr s=462400,2720
X423 a_11257_5926# digital_0.load_slew15.A digital_0._109_.RESET_B VDPWR sky130_fd_pr__pfet_01v8_hvt ad=0.135 pd=1.27 as=0.135 ps=1.27 w=1 l=0.15
X424 a_4545_2110# digital_0.clkload0.A VGND VGND sky130_fd_pr__nfet_01v8 ad=0.1092 pd=1.36 as=0.0567 ps=0.69 w=0.42 l=0.15
X425 VGND VDPWR VGND VGND sky130_fd_pr__nfet_01v8 ad=0.143 pd=1.62 as=0 ps=0 w=0.55 l=0.59
X426 digital_0.clkbuf_1_0__f_clk.X a_11416_3500# VGND VGND sky130_fd_pr__nfet_01v8 ad=0.0588 pd=0.7 as=0.0588 ps=0.7 w=0.42 l=0.15
X427 a_23130_18564# a_23346_16644# VGND sky130_fd_pr__res_high_po w=0.36 l=7.36
X428 a_5608_2664# a_5925_2554# a_5883_2412# VGND sky130_fd_pr__special_nfet_01v8 ad=0.0711 pd=0.755 as=0.0669 ps=0.75 w=0.36 l=0.15
X429 VDPWR a_6343_2930# digital_0.clkload0.A VDPWR sky130_fd_pr__pfet_01v8_hvt ad=0.14 pd=1.28 as=0.14 ps=1.28 w=1 l=0.15
X430 VDPWR digital_0._063_.A a_5461_2956# VDPWR sky130_fd_pr__pfet_01v8_hvt ad=0.135 pd=1.27 as=0.135 ps=1.27 w=1 l=0.15
X431 VDPWR VGND VDPWR VDPWR sky130_fd_pr__pfet_01v8_hvt ad=0.2262 pd=2.26 as=0 ps=0 w=0.87 l=0.59
X432 VGND a_11417_4825# a_11348_4954# VGND sky130_fd_pr__nfet_01v8 ad=0.1346 pd=1.15 as=0.0999 ps=0.985 w=0.64 l=0.15
X433 a_11433_5132# digital_0.output13.A VDPWR VDPWR sky130_fd_pr__pfet_01v8_hvt ad=0.14 pd=1.28 as=0.135 ps=1.27 w=1 l=0.15
X434 a_14350_2386# a_14174_2412# a_14494_2412# VGND sky130_fd_pr__nfet_01v8 ad=0.1092 pd=1.36 as=0.0441 ps=0.63 w=0.42 l=0.15
X435 VGND a_4637_5374# a_4598_5248# VGND sky130_fd_pr__nfet_01v8 ad=0.0567 pd=0.69 as=0.1092 ps=1.36 w=0.42 l=0.15
X436 VDPWR VDPWR VDPWR VDPWR sky130_fd_pr__pfet_01v8 ad=0.468 pd=2.84 as=0 ps=0 w=0.9 l=0.16
X437 a_7745_2412# digital_0._065_.A2_N VDPWR VDPWR sky130_fd_pr__pfet_01v8_hvt ad=0.0588 pd=0.7 as=0.0777 ps=0.79 w=0.42 l=0.15
X438 a_11730_4044# a_11209_4018# VDPWR VDPWR sky130_fd_pr__pfet_01v8_hvt ad=0.0567 pd=0.69 as=0.0819 ps=0.81 w=0.42 l=0.15
X439 digital_0._109_.D digital_0._069_.B a_11793_5926# VDPWR sky130_fd_pr__pfet_01v8_hvt ad=0.135 pd=1.27 as=0.135 ps=1.27 w=1 l=0.15
X440 a_15506_2956# a_15289_2956# VDPWR VDPWR sky130_fd_pr__pfet_01v8_hvt ad=0.2173 pd=2.17 as=0.19265 ps=1.415 w=0.82 l=0.25
X441 LELO_GR01_0.x8.x5.XA3.MP1.S uo_out<0> LELO_GR01_0.x8.x8.D LELO_GR01_0.x8.x8.D sky130_fd_pr__pfet_01v8 ad=0.288 pd=1.54 as=0.468 ps=2.84 w=0.9 l=0.16
X442 digital_0._100_.RESET_B digital_0.load_slew15.X VGND VGND sky130_fd_pr__nfet_01v8 ad=0.08775 pd=0.92 as=0.169 ps=1.82 w=0.65 l=0.15
X443 a_10420_1842# a_10546_2106# VGND VGND sky130_fd_pr__nfet_01v8 ad=0.17225 pd=1.83 as=0.1856 ps=1.26 w=0.65 l=0.25
X444 digital_0._057_.D a_6075_1842# VGND VGND sky130_fd_pr__nfet_01v8 ad=0.12675 pd=1.04 as=0.247 ps=2.06 w=0.65 l=0.15
X445 VDPWR LELO_GR01_0.x7.xd1<4>.A LELO_GR01_0.x7.x15.I2 VDPWR sky130_fd_pr__pfet_01v8_lvt ad=0.5088 pd=2.98 as=0.3168 ps=1.62 w=0.96 l=0.94
X446 VGND a_3702_4018# a_3462_4282# VGND sky130_fd_pr__nfet_01v8 ad=0.1228 pd=1.065 as=0.17225 ps=1.83 w=0.65 l=0.25
X447 VDPWR digital_0._102_.RESET_B a_4033_5106# VDPWR sky130_fd_pr__pfet_01v8_hvt ad=0.0819 pd=0.81 as=0.0567 ps=0.69 w=0.42 l=0.15
X448 a_14275_1842# a_14057_2246# VGND VGND sky130_fd_pr__nfet_01v8 ad=0.0999 pd=0.985 as=0.1346 ps=1.15 w=0.64 l=0.15
X449 digital_0._110_.RESET_B digital_0.load_slew17.A a_5997_4044# VDPWR sky130_fd_pr__pfet_01v8_hvt ad=0.135 pd=1.27 as=0.135 ps=1.27 w=1 l=0.15
X450 VDPWR LELO_GR01_0.x7.x1.x7.D LELO_GR01_0.x7.x1.x7.D VDPWR sky130_fd_pr__pfet_01v8_lvt ad=0.5088 pd=2.98 as=0.3168 ps=1.62 w=0.96 l=0.94
X451 digital_0.load_slew15.X a_10861_3474# VDPWR VDPWR sky130_fd_pr__pfet_01v8_hvt ad=0.135 pd=1.27 as=0.26 ps=2.52 w=1 l=0.15
X452 VDPWR digital_0.input2.X digital_0._080_.A2 VDPWR sky130_fd_pr__pfet_01v8_hvt ad=0.26 pd=2.52 as=0.135 ps=1.27 w=1 l=0.15
X453 a_11163_2412# a_11128_2664# a_10841_2386# VGND sky130_fd_pr__nfet_01v8 ad=0.06405 pd=0.725 as=0.1092 ps=1.36 w=0.42 l=0.15
X454 digital_0.output10.A a_3941_1842# VGND VGND sky130_fd_pr__nfet_01v8 ad=0.08775 pd=0.92 as=0.169 ps=1.82 w=0.65 l=0.15
X455 a_11348_4954# a_11222_4856# a_10944_4840# VGND sky130_fd_pr__special_nfet_01v8 ad=0.0999 pd=0.985 as=0.0711 ps=0.755 w=0.36 l=0.15
X456 uo_out<0> LELO_GR01_0.x8.x5.XA7.CN LELO_GR01_0.x8.x5.XA7.MP1.S LELO_GR01_0.x8.x8.D sky130_fd_pr__pfet_01v8 ad=0.468 pd=2.84 as=0.288 ps=1.54 w=0.9 l=0.16
X457 digital_0.load_slew15.X a_10861_3474# VDPWR VDPWR sky130_fd_pr__pfet_01v8_hvt ad=0.135 pd=1.27 as=0.135 ps=1.27 w=1 l=0.15
X458 a_14205_3827# digital_0._109_.Q a_14133_3827# VDPWR sky130_fd_pr__pfet_01v8_hvt ad=0.1932 pd=1.34 as=0.0441 ps=0.63 w=0.42 l=0.15
X459 a_28102_18564# a_28318_16644# VGND sky130_fd_pr__res_high_po w=0.36 l=7.36
X460 a_5321_3474# a_5608_3752# VDPWR VDPWR sky130_fd_pr__pfet_01v8_hvt ad=0.0567 pd=0.69 as=0.1134 ps=1.38 w=0.42 l=0.15
X461 a_14995_3500# a_14759_3500# VGND VGND sky130_fd_pr__nfet_01v8 ad=0.1092 pd=1.36 as=0.0567 ps=0.69 w=0.42 l=0.5
X462 VGND digital_0._116_.Q digital_0._110_.RESET_B VGND sky130_fd_pr__nfet_01v8 ad=0.08775 pd=0.92 as=0.08775 ps=0.92 w=0.65 l=0.15
X463 VDPWR a_7529_5106# digital_0.output8.A VDPWR sky130_fd_pr__pfet_01v8_hvt ad=0.3012 pd=2.66 as=0.135 ps=1.27 w=1 l=0.15
X464 VGND digital_0._060_.A_N a_11234_3276# VGND sky130_fd_pr__nfet_01v8 ad=0.169 pd=1.82 as=0.08775 ps=0.92 w=0.65 l=0.15
X465 a_14349_4954# a_13725_4588# a_14241_4588# VDPWR sky130_fd_pr__pfet_01v8_hvt ad=0.1155 pd=0.97 as=0.07245 ps=0.765 w=0.42 l=0.15
X466 a_11771_4410# a_11209_4018# VGND VGND sky130_fd_pr__nfet_01v8 ad=0.0669 pd=0.75 as=0.12495 ps=1.015 w=0.42 l=0.15
X467 VGND a_7871_4616# digital_0._067_.A VGND sky130_fd_pr__nfet_01v8 ad=0.247 pd=2.06 as=0.12675 ps=1.04 w=0.65 l=0.15
X468 LELO_GR01_0.x7.x1.x5.IBN LELO_GR01_0.x7.x15.I2 LELO_GR01_0.x7.xd1<4>.A VGND sky130_fd_pr__nfet_01v8_lvt ad=0.5088 pd=2.98 as=0.3168 ps=1.62 w=0.96 l=0.94
X469 VGND a_8735_3474# digital_0.clkbuf_1_1__f_clk.A VGND sky130_fd_pr__nfet_01v8 ad=0.0588 pd=0.7 as=0.0588 ps=0.7 w=0.42 l=0.15
X470 a_13141_2930# a_13428_3088# VDPWR VDPWR sky130_fd_pr__pfet_01v8_hvt ad=0.0567 pd=0.69 as=0.1134 ps=1.38 w=0.42 l=0.15
X471 a_13832_2956# a_13706_3072# a_13428_3088# VGND sky130_fd_pr__special_nfet_01v8 ad=0.0999 pd=0.985 as=0.0711 ps=0.755 w=0.36 l=0.15
X472 VDPWR digital_0.output10.A a_3903_1324# VDPWR sky130_fd_pr__pfet_01v8_hvt ad=0.0567 pd=0.69 as=0.1092 ps=1.36 w=0.42 l=0.15
X473 a_3676_3088# a_3993_3198# a_3951_3322# VGND sky130_fd_pr__special_nfet_01v8 ad=0.0711 pd=0.755 as=0.0669 ps=0.75 w=0.36 l=0.15
X474 LELO_GR01_0.x7.xd1<4>.A LELO_GR01_0.x7.x18.D LELO_GR01_0.x7.x6<3>.G VGND sky130_fd_pr__nfet_01v8_lvt ad=0.3168 pd=1.62 as=0.5088 ps=2.98 w=0.96 l=0.94
X475 LELO_GR01_0.x7.x28.e a_17724_13144# VGND sky130_fd_pr__res_high_po w=0.36 l=7.36
X476 VDPWR a_7547_4018# digital_0._065_.A2_N VDPWR sky130_fd_pr__pfet_01v8_hvt ad=0.16655 pd=1.39 as=0.195 ps=1.39 w=1 l=0.15
X477 VDPWR a_8735_3474# digital_0.clkbuf_1_1__f_clk.A VDPWR sky130_fd_pr__pfet_01v8_hvt ad=0.14 pd=1.28 as=0.14 ps=1.28 w=1 l=0.15
X478 digital_0.output8.A a_7529_5106# VGND VGND sky130_fd_pr__nfet_01v8 ad=0.08775 pd=0.92 as=0.169 ps=1.82 w=0.65 l=0.15
X479 a_11592_2956# digital_0._115_.Q VDPWR VDPWR sky130_fd_pr__pfet_01v8_hvt ad=0.135 pd=1.27 as=0.135 ps=1.27 w=1 l=0.15
X480 digital_0.hold20.X a_7281_5676# VDPWR VDPWR sky130_fd_pr__pfet_01v8_hvt ad=0.26 pd=2.52 as=0.14075 ps=1.325 w=1 l=0.15
X481 VDPWR digital_0.output9.A a_3443_2412# VDPWR sky130_fd_pr__pfet_01v8_hvt ad=0.0567 pd=0.69 as=0.1092 ps=1.36 w=0.42 l=0.15
X482 digital_0.clkload0.A a_6343_2930# VDPWR VDPWR sky130_fd_pr__pfet_01v8_hvt ad=0.14 pd=1.28 as=0.1375 ps=1.275 w=1 l=0.15
X483 a_14770_5676# a_14553_5676# VDPWR VDPWR sky130_fd_pr__pfet_01v8_hvt ad=0.2173 pd=2.17 as=0.19265 ps=1.415 w=0.82 l=0.25
X484 a_10082_13154# a_9866_11234# VGND sky130_fd_pr__res_high_po w=0.36 l=7.36
X485 VDPWR VGND VDPWR VDPWR sky130_fd_pr__pfet_01v8_hvt ad=0.2262 pd=2.26 as=0 ps=0 w=0.87 l=0.59
X486 a_8368_4176# a_8685_4286# a_8643_4410# VGND sky130_fd_pr__special_nfet_01v8 ad=0.0711 pd=0.755 as=0.0669 ps=0.75 w=0.36 l=0.15
X487 LELO_GR01_0.x8.x5.XA1.MN1.S LELO_GR01_0.x8.x5.CK VGND VGND sky130_fd_pr__nfet_01v8 ad=0.288 pd=1.54 as=0.468 ps=2.84 w=0.9 l=0.16
X488 VDPWR VGND VDPWR VDPWR sky130_fd_pr__pfet_01v8_hvt ad=0.2262 pd=2.26 as=0 ps=0 w=0.87 l=0.59
X489 VDPWR digital_0.input3.X a_3513_3500# VDPWR sky130_fd_pr__pfet_01v8_hvt ad=0.19265 pd=1.415 as=0.27 ps=2.54 w=1 l=0.15
X490 a_8684_8824# a_8468_6904# VGND sky130_fd_pr__res_high_po w=0.36 l=7.36
X491 VDPWR LELO_GR01_0.x7.x1.x7.D LELO_GR01_0.x7.xd1<4>.A VDPWR sky130_fd_pr__pfet_01v8_lvt ad=0.5088 pd=2.98 as=0.3168 ps=1.62 w=0.96 l=0.94
X492 VDPWR a_11261_4730# a_11222_4856# VDPWR sky130_fd_pr__pfet_01v8_hvt ad=0.0864 pd=0.91 as=0.1664 ps=1.8 w=0.64 l=0.15
X493 VDPWR digital_0.output13.A a_12069_5132# VDPWR sky130_fd_pr__pfet_01v8_hvt ad=0.135 pd=1.27 as=0.275 ps=2.55 w=1 l=0.15
X494 a_5842_2778# a_5321_2386# VDPWR VDPWR sky130_fd_pr__pfet_01v8_hvt ad=0.0567 pd=0.69 as=0.0819 ps=0.81 w=0.42 l=0.15
X495 a_13420_1324# digital_0._116_.Q a_13042_1476# VGND sky130_fd_pr__nfet_01v8 ad=0.1235 pd=1.03 as=0.1625 ps=1.15 w=0.65 l=0.15
X496 LELO_GR01_0.x8.x8.D VDPWR LELO_GR01_0.x8.x5.XA7.C LELO_GR01_0.x8.x8.D sky130_fd_pr__pfet_01v8 ad=0.468 pd=2.84 as=0.288 ps=1.54 w=0.9 l=0.16
X497 VDPWR a_9862_1690# digital_0._114_.D VDPWR sky130_fd_pr__pfet_01v8_hvt ad=0.26 pd=2.52 as=0.135 ps=1.27 w=1 l=0.15
X498 VGND a_6081_2649# a_6012_2778# VGND sky130_fd_pr__nfet_01v8 ad=0.1346 pd=1.15 as=0.0999 ps=0.985 w=0.64 l=0.15
X499 VDPWR a_3941_1842# digital_0.output10.A VDPWR sky130_fd_pr__pfet_01v8_hvt ad=0.3012 pd=2.66 as=0.135 ps=1.27 w=1 l=0.15
X500 a_11234_3276# digital_0._060_.A_N a_11149_2956# VDPWR sky130_fd_pr__pfet_01v8_hvt ad=0.135 pd=1.27 as=0.135 ps=1.27 w=1 l=0.15
X501 a_6046_5364# digital_0._110_.Q a_6188_5498# VGND sky130_fd_pr__nfet_01v8 ad=0.09975 pd=0.895 as=0.0693 ps=0.75 w=0.42 l=0.15
X502 LELO_GR01_0.x7.x31.N a_6098_6904# VGND sky130_fd_pr__res_high_po w=0.36 l=7.36
X503 VGND a_13132_4276# digital_0._069_.A VGND sky130_fd_pr__nfet_01v8 ad=0.1304 pd=1.105 as=0.08775 ps=0.92 w=0.65 l=0.15
X504 a_8986_1868# a_8772_1868# VDPWR VDPWR sky130_fd_pr__pfet_01v8_hvt ad=0.1155 pd=0.97 as=0.07035 ps=0.755 w=0.42 l=0.15
X505 VDPWR digital_0._108_.RESET_B a_12114_4044# VDPWR sky130_fd_pr__pfet_01v8_hvt ad=0.07035 pd=0.755 as=0.1092 ps=1.36 w=0.42 l=0.15
X506 a_6631_1842# digital_0._063_.A VGND VGND sky130_fd_pr__nfet_01v8 ad=0.08775 pd=0.92 as=0.169 ps=1.82 w=0.65 l=0.15
X507 VDPWR VGND VDPWR VDPWR sky130_fd_pr__pfet_01v8_hvt ad=0.2262 pd=2.26 as=0 ps=0 w=0.87 l=0.59
X508 a_8403_4410# a_8368_4176# a_8081_4018# VGND sky130_fd_pr__nfet_01v8 ad=0.06405 pd=0.725 as=0.1092 ps=1.36 w=0.42 l=0.15
X509 a_7580_13154# a_7364_11234# VGND sky130_fd_pr__res_high_po w=0.36 l=7.36
X510 a_11592_3276# digital_0._060_.A_N digital_0._115_.D VGND sky130_fd_pr__nfet_01v8 ad=0.169 pd=1.82 as=0.10563 ps=0.975 w=0.65 l=0.15
X511 a_9079_4410# digital_0._111_.RESET_B VGND VGND sky130_fd_pr__nfet_01v8 ad=0.0441 pd=0.63 as=0.1346 ps=1.15 w=0.42 l=0.15
X512 VGND VGND LELO_GR01_0.x7.x15.I1 sky130_fd_pr__pnp_05v5_W3p40L3p40
**devattr s=462400,2720
X513 uo_out<0> LELO_GR01_0.x8.x5.XA7.C LELO_GR01_0.x8.x5.XA6.MP1.S LELO_GR01_0.x8.x8.D sky130_fd_pr__pfet_01v8 ad=0.468 pd=2.84 as=0.288 ps=1.54 w=0.9 l=0.16
X514 uo_out<1> a_14881_5676# VDPWR VDPWR sky130_fd_pr__pfet_01v8_hvt ad=0.495 pd=2.99 as=0.2726 ps=1.61 w=1 l=0.15
X515 a_8081_4018# a_8368_4176# VDPWR VDPWR sky130_fd_pr__pfet_01v8_hvt ad=0.0567 pd=0.69 as=0.1134 ps=1.38 w=0.42 l=0.15
X516 VGND a_12603_2956# a_12709_2956# VGND sky130_fd_pr__nfet_01v8 ad=0.097 pd=0.975 as=0.1092 ps=1.36 w=0.42 l=0.5
X517 VDPWR a_15507_3528# digital_0._118_.D VDPWR sky130_fd_pr__pfet_01v8_hvt ad=0.38 pd=2.76 as=0.195 ps=1.39 w=1 l=0.15
X518 VDPWR a_8685_4286# a_8646_4160# VDPWR sky130_fd_pr__pfet_01v8_hvt ad=0.0864 pd=0.91 as=0.1664 ps=1.8 w=0.64 l=0.15
X519 digital_0.clkbuf_1_1__f_clk.A a_8735_3474# VDPWR VDPWR sky130_fd_pr__pfet_01v8_hvt ad=0.14 pd=1.28 as=0.14 ps=1.28 w=1 l=0.15
X520 digital_0._067_.A a_7871_4616# VGND VGND sky130_fd_pr__nfet_01v8 ad=0.12675 pd=1.04 as=0.1118 ps=1.04 w=0.65 l=0.15
X521 a_6160_4840# a_6438_4856# a_6394_4954# VDPWR sky130_fd_pr__pfet_01v8_hvt ad=0.0588 pd=0.7 as=0.0567 ps=0.69 w=0.42 l=0.15
X522 a_6012_2778# a_5886_2680# a_5608_2664# VGND sky130_fd_pr__special_nfet_01v8 ad=0.0999 pd=0.985 as=0.0711 ps=0.755 w=0.36 l=0.15
X523 VGND a_4793_5106# a_4724_5132# VGND sky130_fd_pr__nfet_01v8 ad=0.1346 pd=1.15 as=0.0999 ps=0.985 w=0.64 l=0.15
X524 VGND a_13969_5106# digital_0.hold28.A VGND sky130_fd_pr__nfet_01v8 ad=0.2087 pd=2.02 as=0.08775 ps=0.92 w=0.65 l=0.15
X525 digital_0.clkbuf_1_0__f_clk.X a_11416_3500# VGND VGND sky130_fd_pr__nfet_01v8 ad=0.0588 pd=0.7 as=0.05775 ps=0.695 w=0.42 l=0.15
X526 a_9404_4044# a_8685_4286# a_8841_4018# VGND sky130_fd_pr__special_nfet_01v8 ad=0.066 pd=0.745 as=0.0594 ps=0.69 w=0.36 l=0.15
X527 a_6644_3866# a_5925_3642# a_6081_3737# VGND sky130_fd_pr__special_nfet_01v8 ad=0.066 pd=0.745 as=0.0594 ps=0.69 w=0.36 l=0.15
X528 LELO_GR01_0.x7.x6<3>.G LELO_GR01_0.x7.x18.D LELO_GR01_0.x7.xd1<4>.A VGND sky130_fd_pr__nfet_01v8_lvt ad=0.5088 pd=2.98 as=0.3168 ps=1.62 w=0.96 l=0.94
X529 LELO_GR01_0.x8.x5.XA6.MN1.S LELO_GR01_0.x8.x5.XA6.A VGND VGND sky130_fd_pr__nfet_01v8 ad=0.288 pd=1.54 as=0.468 ps=2.84 w=0.9 l=0.16
X530 VDPWR a_6646_5650# a_6406_5834# VDPWR sky130_fd_pr__pfet_01v8_hvt ad=0.19265 pd=1.415 as=0.2173 ps=2.17 w=0.82 l=0.25
X531 a_14573_5374# digital_0.clkbuf_1_0__f_clk.X VGND VGND sky130_fd_pr__nfet_01v8 ad=0.1092 pd=1.36 as=0.0567 ps=0.69 w=0.42 l=0.15
X532 VDPWR digital_0.hold28.A a_11467_1651# VDPWR sky130_fd_pr__pfet_01v8_hvt ad=0.0693 pd=0.75 as=0.1176 ps=1.4 w=0.42 l=0.15
X533 digital_0._065_.A2_N a_7547_4018# VDPWR VDPWR sky130_fd_pr__pfet_01v8_hvt ad=0.195 pd=1.39 as=0.38 ps=2.76 w=1 l=0.15
X534 VGND VDPWR VGND VGND sky130_fd_pr__nfet_01v8 ad=0.143 pd=1.62 as=0 ps=0 w=0.55 l=0.59
X535 LELO_GR01_0.x7.x11.P a_20754_16644# VGND sky130_fd_pr__res_high_po w=0.36 l=7.36
X536 VGND digital_0._063_.B digital_0._112_.D VGND sky130_fd_pr__nfet_01v8 ad=0.08775 pd=0.92 as=0.08775 ps=0.92 w=0.65 l=0.15
X537 VDPWR a_6343_2930# digital_0.clkload0.A VDPWR sky130_fd_pr__pfet_01v8_hvt ad=0.14 pd=1.28 as=0.14 ps=1.28 w=1 l=0.15
X538 VGND VDPWR VGND VGND sky130_fd_pr__nfet_01v8 ad=0.143 pd=1.62 as=0 ps=0 w=0.55 l=0.59
X539 VGND digital_0.hold28.A a_11467_1651# VGND sky130_fd_pr__nfet_01v8 ad=0.1449 pd=1.11 as=0.1092 ps=1.36 w=0.42 l=0.15
X540 a_8471_3276# digital_0._113_.Q a_8389_3276# VGND sky130_fd_pr__nfet_01v8 ad=0.08775 pd=0.92 as=0.169 ps=1.82 w=0.65 l=0.15
X541 VDPWR VGND VDPWR VDPWR sky130_fd_pr__pfet_01v8_hvt ad=0.2262 pd=2.26 as=0 ps=0 w=0.87 l=0.59
X542 VDPWR digital_0.load_slew15.X digital_0._100_.RESET_B VDPWR sky130_fd_pr__pfet_01v8_hvt ad=0.26 pd=2.52 as=0.135 ps=1.27 w=1 l=0.15
X543 digital_0._114_.Q a_8817_2386# VDPWR VDPWR sky130_fd_pr__pfet_01v8_hvt ad=0.135 pd=1.27 as=0.26 ps=2.52 w=1 l=0.15
X544 a_8368_2000# a_8646_1984# a_8602_1868# VDPWR sky130_fd_pr__pfet_01v8_hvt ad=0.0588 pd=0.7 as=0.0567 ps=0.69 w=0.42 l=0.15
X545 a_9887_2412# a_9508_2778# a_9815_2412# VGND sky130_fd_pr__nfet_01v8 ad=0.1401 pd=1.1 as=0.0441 ps=0.63 w=0.42 l=0.15
X546 digital_0._063_.A a_6968_4276# VDPWR VDPWR sky130_fd_pr__pfet_01v8_hvt ad=0.135 pd=1.27 as=0.26 ps=2.52 w=1 l=0.15
X547 a_9379_2412# a_8817_2386# VGND VGND sky130_fd_pr__nfet_01v8 ad=0.0669 pd=0.75 as=0.12495 ps=1.015 w=0.42 l=0.15
X548 VDPWR digital_0._112_.RESET_B a_5321_2386# VDPWR sky130_fd_pr__pfet_01v8_hvt ad=0.0819 pd=0.81 as=0.0567 ps=0.69 w=0.42 l=0.15
X549 VDPWR a_11445_2554# a_11406_2680# VDPWR sky130_fd_pr__pfet_01v8_hvt ad=0.0864 pd=0.91 as=0.1664 ps=1.8 w=0.64 l=0.15
X550 VDPWR digital_0.hold28.A a_8163_6003# VDPWR sky130_fd_pr__pfet_01v8_hvt ad=0.15835 pd=1.395 as=0.07665 ps=0.785 w=0.42 l=0.15
X551 a_9980_8824# a_10196_6904# VGND sky130_fd_pr__res_high_po w=0.36 l=7.36
X552 LELO_GR01_0.x7.x29.N a_22254_13144# VGND sky130_fd_pr__res_high_po w=0.36 l=7.36
X553 VGND VDPWR VGND VGND sky130_fd_pr__nfet_01v8 ad=0.143 pd=1.62 as=0 ps=0 w=0.55 l=0.59
X554 VDPWR digital_0._110_.Q a_6457_4044# VDPWR sky130_fd_pr__pfet_01v8_hvt ad=0.135 pd=1.27 as=0.28 ps=2.56 w=1 l=0.15
X555 VGND LELO_GR01_0.x8.x1.x5.x9<2>.G LELO_GR01_0.x8.x1.x5.IBN VGND sky130_fd_pr__nfet_01v8_lvt ad=0.5088 pd=2.98 as=0.3168 ps=1.62 w=0.96 l=0.94
X556 a_6575_1868# digital_0._113_.Q VDPWR VDPWR sky130_fd_pr__pfet_01v8_hvt ad=0.26 pd=2.52 as=0.135 ps=1.27 w=1 l=0.15
X557 digital_0._113_.Q a_5321_3474# VDPWR VDPWR sky130_fd_pr__pfet_01v8_hvt ad=0.135 pd=1.27 as=0.26 ps=2.52 w=1 l=0.15
X558 VDPWR digital_0.output7.A a_5169_5676# VDPWR sky130_fd_pr__pfet_01v8_hvt ad=0.19265 pd=1.415 as=0.27 ps=2.54 w=1 l=0.15
X559 VDPWR uo_out<0> a_13725_1324# VDPWR sky130_fd_pr__pfet_01v8_hvt ad=0.19265 pd=1.415 as=0.27 ps=2.54 w=1 l=0.15
X560 a_13463_3322# a_13428_3088# a_13141_2930# VGND sky130_fd_pr__nfet_01v8 ad=0.06405 pd=0.725 as=0.1092 ps=1.36 w=0.42 l=0.15
X561 a_14139_3322# digital_0._118_.RESET_B VGND VGND sky130_fd_pr__nfet_01v8 ad=0.0441 pd=0.63 as=0.1346 ps=1.15 w=0.42 l=0.15
X562 a_6391_3500# a_6012_3866# a_6319_3500# VGND sky130_fd_pr__nfet_01v8 ad=0.1401 pd=1.1 as=0.0441 ps=0.63 w=0.42 l=0.15
X563 VDPWR digital_0._112_.RESET_B a_6226_2778# VDPWR sky130_fd_pr__pfet_01v8_hvt ad=0.07035 pd=0.755 as=0.1092 ps=1.36 w=0.42 l=0.15
X564 digital_0._080_.A2 digital_0.input2.X VGND VGND sky130_fd_pr__nfet_01v8 ad=0.08775 pd=0.92 as=0.169 ps=1.82 w=0.65 l=0.15
X565 VDPWR VGND VDPWR VDPWR sky130_fd_pr__pfet_01v8_hvt ad=0.2262 pd=2.26 as=0 ps=0 w=0.87 l=0.59
X566 VGND a_6633_4825# a_6564_4954# VGND sky130_fd_pr__nfet_01v8 ad=0.1346 pd=1.15 as=0.0999 ps=0.985 w=0.64 l=0.15
X567 digital_0.clkbuf_1_0__f_clk.X a_11416_3500# VDPWR VDPWR sky130_fd_pr__pfet_01v8_hvt ad=0.14 pd=1.28 as=0.14 ps=1.28 w=1 l=0.15
X568 digital_0._112_.Q a_5321_2386# VGND VGND sky130_fd_pr__nfet_01v8 ad=0.08775 pd=0.92 as=0.169 ps=1.82 w=0.65 l=0.15
X569 a_14885_1298# digital_0.output4.A VGND VGND sky130_fd_pr__nfet_01v8 ad=0.1092 pd=1.36 as=0.0567 ps=0.69 w=0.42 l=0.15
X570 a_8434_5132# a_8220_5132# VDPWR VDPWR sky130_fd_pr__pfet_01v8_hvt ad=0.1155 pd=0.97 as=0.07035 ps=0.755 w=0.42 l=0.15
X571 VDPWR a_13795_5828# digital_0.hold25.X VDPWR sky130_fd_pr__pfet_01v8_hvt ad=0.14075 pd=1.325 as=0.26 ps=2.52 w=1 l=0.15
X572 a_25510_18564# a_25726_16644# VGND sky130_fd_pr__res_high_po w=0.36 l=7.36
X573 VGND digital_0.load_slew15.A digital_0._108_.RESET_B VGND sky130_fd_pr__nfet_01v8 ad=0.169 pd=1.82 as=0.08775 ps=0.92 w=0.65 l=0.15
X574 VDPWR digital_0.output11.A a_7767_1324# VDPWR sky130_fd_pr__pfet_01v8_hvt ad=0.0567 pd=0.69 as=0.1092 ps=1.36 w=0.42 l=0.15
X575 a_8163_6003# digital_0.hold20.X a_7949_6003# VDPWR sky130_fd_pr__pfet_01v8_hvt ad=0.07665 pd=0.785 as=0.1932 ps=1.34 w=0.42 l=0.15
X576 VDPWR digital_0._057_.D a_7745_2412# VDPWR sky130_fd_pr__pfet_01v8_hvt ad=0.27995 pd=1.615 as=0.0588 ps=0.7 w=0.42 l=0.15
X577 digital_0._118_.D a_15507_3528# VDPWR VDPWR sky130_fd_pr__pfet_01v8_hvt ad=0.195 pd=1.39 as=0.16655 ps=1.39 w=1 l=0.15
X578 VDPWR a_13155_2412# a_13261_2412# VDPWR sky130_fd_pr__pfet_01v8_hvt ad=0.14075 pd=1.325 as=0.1092 ps=1.36 w=0.42 l=0.5
X579 VDPWR digital_0.input2.X a_15507_3528# VDPWR sky130_fd_pr__pfet_01v8_hvt ad=0.16655 pd=1.39 as=0.0567 ps=0.69 w=0.42 l=0.15
X580 VGND a_11416_3500# digital_0.clkbuf_1_0__f_clk.X VGND sky130_fd_pr__nfet_01v8 ad=0.0588 pd=0.7 as=0.0588 ps=0.7 w=0.42 l=0.15
X581 VDPWR digital_0._069_.A a_7871_4616# VDPWR sky130_fd_pr__pfet_01v8_hvt ad=0.16655 pd=1.39 as=0.0567 ps=0.69 w=0.42 l=0.15
X582 LELO_GR01_0.x8.x5.XA4.MP1.S LELO_GR01_0.x8.x5.XA6.A LELO_GR01_0.x8.x8.D LELO_GR01_0.x8.x8.D sky130_fd_pr__pfet_01v8 ad=0.288 pd=1.54 as=0.468 ps=2.84 w=0.9 l=0.16
X583 digital_0.clkload0.A a_6343_2930# VDPWR VDPWR sky130_fd_pr__pfet_01v8_hvt ad=0.14 pd=1.28 as=0.14 ps=1.28 w=1 l=0.15
X584 a_11433_5132# digital_0._109_.Q digital_0._069_.B VDPWR sky130_fd_pr__pfet_01v8_hvt ad=0.135 pd=1.27 as=0.135 ps=1.27 w=1 l=0.15
X585 VDPWR VGND VDPWR VDPWR sky130_fd_pr__pfet_01v8_hvt ad=0.2262 pd=2.26 as=0 ps=0 w=0.87 l=0.59
X586 a_14464_2956# a_13745_3198# a_13901_2930# VGND sky130_fd_pr__special_nfet_01v8 ad=0.066 pd=0.745 as=0.0594 ps=0.69 w=0.36 l=0.15
X587 a_13707_1874# a_13541_1874# VGND VGND sky130_fd_pr__nfet_01v8 ad=0.1092 pd=1.36 as=0.0567 ps=0.69 w=0.42 l=0.15
X588 VGND LELO_GR01_0.x8.x1.x5.x9<2>.G LELO_GR01_0.x8.x1.x5.x9<2>.G VGND sky130_fd_pr__nfet_01v8_lvt ad=0.5088 pd=2.98 as=0.3168 ps=1.62 w=0.96 l=0.94
X589 VGND digital_0._105_.RESET_B a_4263_2234# VGND sky130_fd_pr__nfet_01v8 ad=0.12495 pd=1.015 as=0.06405 ps=0.725 w=0.42 l=0.15
X590 digital_0.clkload0.X a_7253_2386# VDPWR VDPWR sky130_fd_pr__pfet_01v8_hvt ad=0.14 pd=1.28 as=0.14 ps=1.28 w=1 l=0.15
X591 VGND digital_0.hold28.A a_13322_4588# VGND sky130_fd_pr__nfet_01v8 ad=0.11285 pd=1.045 as=0.0693 ps=0.75 w=0.42 l=0.15
X592 VDPWR digital_0.output13.A a_11433_5132# VDPWR sky130_fd_pr__pfet_01v8_hvt ad=0.14 pd=1.28 as=0.14 ps=1.28 w=1 l=0.15
X593 VGND a_4033_5106# digital_0.output7.A VGND sky130_fd_pr__nfet_01v8 ad=0.2087 pd=2.02 as=0.08775 ps=0.92 w=0.65 l=0.15
X594 a_14146_4588# digital_0._100_.D VGND VGND sky130_fd_pr__nfet_01v8 ad=0.066 pd=0.745 as=0.2205 ps=1.89 w=0.42 l=0.15
X595 a_26134_15064# a_26350_13144# VGND sky130_fd_pr__res_high_po w=0.36 l=7.36
X596 a_8022_2412# digital_0._065_.A2_N a_7916_2412# VGND sky130_fd_pr__nfet_01v8 ad=0.0693 pd=0.75 as=0.0798 ps=0.8 w=0.42 l=0.15
X597 VGND digital_0._104_.D a_4712_2956# VGND sky130_fd_pr__nfet_01v8 ad=0.2205 pd=1.89 as=0.066 ps=0.745 w=0.42 l=0.15
X598 digital_0._115_.RESET_B digital_0.load_slew17.X VGND VGND sky130_fd_pr__nfet_01v8 ad=0.08775 pd=0.92 as=0.169 ps=1.82 w=0.65 l=0.15
X599 a_7825_3500# digital_0._069_.A digital_0._063_.B VGND sky130_fd_pr__nfet_01v8 ad=0.08937 pd=0.925 as=0.091 ps=0.93 w=0.65 l=0.15
X600 VDPWR digital_0._116_.Q a_5997_4044# VDPWR sky130_fd_pr__pfet_01v8_hvt ad=0.135 pd=1.27 as=0.28 ps=2.56 w=1 l=0.15
X601 a_9862_1690# a_9677_1690# VDPWR VDPWR sky130_fd_pr__pfet_01v8_hvt ad=0.0609 pd=0.71 as=0.07665 ps=0.785 w=0.42 l=0.15
X602 VGND a_11813_4286# a_11774_4160# VGND sky130_fd_pr__nfet_01v8 ad=0.0567 pd=0.69 as=0.1092 ps=1.36 w=0.42 l=0.15
X603 LELO_GR01_0.x7.x1.x5.x6.N LELO_GR01_0.x7.x1.x5.x8.G LELO_GR01_0.x7.x1.x5.x9<2>.G LELO_GR01_0.x7.x1.x5.x6.N sky130_fd_pr__pfet_01v8_lvt ad=0.5088 pd=2.98 as=0.3168 ps=1.62 w=0.96 l=0.94
X604 VDPWR VGND VDPWR VDPWR sky130_fd_pr__pfet_01v8_hvt ad=0.2262 pd=2.26 as=0 ps=0 w=0.87 l=0.59
X605 VGND digital_0._108_.D a_12532_4044# VGND sky130_fd_pr__nfet_01v8 ad=0.2205 pd=1.89 as=0.066 ps=0.745 w=0.42 l=0.15
X606 VGND digital_0._112_.Q digital_0._063_.B VGND sky130_fd_pr__nfet_01v8 ad=0.10725 pd=0.98 as=0.08775 ps=0.92 w=0.65 l=0.15
X607 VGND VDPWR VGND VGND sky130_fd_pr__nfet_01v8 ad=0.143 pd=1.62 as=0 ps=0 w=0.55 l=0.59
X608 a_13348_1574# digital_0.hold18.X a_13042_1476# VDPWR sky130_fd_pr__pfet_01v8_hvt ad=0.14 pd=1.28 as=0.265 ps=2.53 w=1 l=0.15
X609 VDPWR a_8389_3276# digital_0._060_.B VDPWR sky130_fd_pr__pfet_01v8_hvt ad=0.26 pd=2.52 as=0.135 ps=1.27 w=1 l=0.15
X610 a_8252_8824# a_8468_6904# VGND sky130_fd_pr__res_high_po w=0.36 l=7.36
X611 VDPWR a_14797_2172# digital_0.output4.A VDPWR sky130_fd_pr__pfet_01v8_hvt ad=0.26 pd=2.52 as=0.135 ps=1.27 w=1 l=0.15
X612 digital_0._069_.B digital_0._109_.Q VGND VGND sky130_fd_pr__nfet_01v8 ad=0.08775 pd=0.92 as=0.26 ps=2.1 w=0.65 l=0.15
X613 VGND digital_0._115_.Q a_11234_3276# VGND sky130_fd_pr__nfet_01v8 ad=0.08775 pd=0.92 as=0.08775 ps=0.92 w=0.65 l=0.15
X614 a_14726_2778# a_13725_2412# a_14654_2778# VDPWR sky130_fd_pr__pfet_01v8_hvt ad=0.0819 pd=0.81 as=0.0441 ps=0.63 w=0.42 l=0.15
X615 a_12279_4410# a_11900_4044# a_12207_4410# VGND sky130_fd_pr__nfet_01v8 ad=0.1401 pd=1.1 as=0.0441 ps=0.63 w=0.42 l=0.15
X616 LELO_GR01_0.x8.x5.Q uo_out<0> VGND VGND sky130_fd_pr__nfet_01v8 ad=0.468 pd=2.84 as=0.468 ps=2.84 w=0.9 l=0.16
X617 a_14205_3827# digital_0.hold22.X a_14205_3500# VGND sky130_fd_pr__nfet_01v8 ad=0.09975 pd=0.895 as=0.0693 ps=0.75 w=0.42 l=0.15
X618 a_11655_4588# digital_0._109_.RESET_B VGND VGND sky130_fd_pr__nfet_01v8 ad=0.0441 pd=0.63 as=0.1346 ps=1.15 w=0.42 l=0.15
X619 a_13155_2412# a_12919_2412# VDPWR VDPWR sky130_fd_pr__pfet_01v8_hvt ad=0.1092 pd=1.36 as=0.0567 ps=0.69 w=0.42 l=0.5
X620 VGND a_4691_5676# a_4797_5676# VGND sky130_fd_pr__nfet_01v8 ad=0.097 pd=0.975 as=0.1092 ps=1.36 w=0.42 l=0.5
X621 a_3730_3500# a_3513_3500# VDPWR VDPWR sky130_fd_pr__pfet_01v8_hvt ad=0.2173 pd=2.17 as=0.19265 ps=1.415 w=0.82 l=0.25
X622 LELO_GR01_0.x7.x6<3>.G LELO_GR01_0.x7.x18.D LELO_GR01_0.x7.xd1<4>.A VGND sky130_fd_pr__nfet_01v8_lvt ad=0.5088 pd=2.98 as=0.3168 ps=1.62 w=0.96 l=0.94
X623 VGND a_10786_1298# a_10546_1482# VGND sky130_fd_pr__nfet_01v8 ad=0.1228 pd=1.065 as=0.17225 ps=1.83 w=0.65 l=0.25
X624 VGND a_6631_1842# digital_0._113_.D VGND sky130_fd_pr__nfet_01v8 ad=0.169 pd=1.82 as=0.08775 ps=0.92 w=0.65 l=0.15
X625 VDPWR VGND VDPWR VDPWR sky130_fd_pr__pfet_01v8_hvt ad=0.2262 pd=2.26 as=0 ps=0 w=0.87 l=0.59
X626 a_14349_4954# digital_0._100_.RESET_B VDPWR VDPWR sky130_fd_pr__pfet_01v8_hvt ad=0.1092 pd=1.36 as=0.07035 ps=0.755 w=0.42 l=0.15
X627 VGND a_3389_2930# digital_0.output9.A VGND sky130_fd_pr__nfet_01v8 ad=0.2087 pd=2.02 as=0.08775 ps=0.92 w=0.65 l=0.15
X628 a_13980_4176# a_14258_4160# a_14214_4044# VDPWR sky130_fd_pr__pfet_01v8_hvt ad=0.0588 pd=0.7 as=0.0567 ps=0.69 w=0.42 l=0.15
X629 VGND a_15506_2956# a_15617_2956# VGND sky130_fd_pr__nfet_01v8 ad=0.1856 pd=1.26 as=0.17225 ps=1.83 w=0.65 l=0.25
X630 LELO_GR01_0.x7.x3.P a_9434_11234# VGND sky130_fd_pr__res_high_po w=0.36 l=7.36
X631 VDPWR digital_0.clkbuf_1_1__f_clk.A a_6343_2930# VDPWR sky130_fd_pr__pfet_01v8_hvt ad=0.265 pd=2.53 as=0.14 ps=1.28 w=1 l=0.15
X632 uio_out<2> a_5497_5676# VDPWR VDPWR sky130_fd_pr__pfet_01v8_hvt ad=0.495 pd=2.99 as=0.2726 ps=1.61 w=1 l=0.15
X633 a_8643_4410# a_8081_4018# VGND VGND sky130_fd_pr__nfet_01v8 ad=0.0669 pd=0.75 as=0.12495 ps=1.015 w=0.42 l=0.15
X634 VGND VDPWR VGND VGND sky130_fd_pr__nfet_01v8 ad=0.143 pd=1.62 as=0 ps=0 w=0.55 l=0.59
X635 VGND VGND LELO_GR01_0.x7.x15.I1 sky130_fd_pr__pnp_05v5_W3p40L3p40
**devattr s=462400,2720
X636 a_3437_1574# digital_0._116_.Q VDPWR VDPWR sky130_fd_pr__pfet_01v8_hvt ad=0.28 pd=2.56 as=0.135 ps=1.27 w=1 l=0.15
X637 a_5189_1651# digital_0.hold27.X a_5189_1324# VGND sky130_fd_pr__nfet_01v8 ad=0.09975 pd=0.895 as=0.0693 ps=0.75 w=0.42 l=0.15
X638 a_17736_18564# a_17952_16644# VGND sky130_fd_pr__res_high_po w=0.36 l=7.36
X639 digital_0._117_.RESET_B digital_0.load_slew15.X VGND VGND sky130_fd_pr__nfet_01v8 ad=0.08775 pd=0.92 as=0.169 ps=1.82 w=0.65 l=0.15
X640 VDPWR a_7175_5676# a_7281_5676# VDPWR sky130_fd_pr__pfet_01v8_hvt ad=0.14075 pd=1.325 as=0.1092 ps=1.36 w=0.42 l=0.5
X641 VDPWR a_14729_5106# a_14660_5132# VDPWR sky130_fd_pr__pfet_01v8_hvt ad=0.2184 pd=2.2 as=0.12915 ps=1.185 w=0.84 l=0.15
X642 a_9969_2956# digital_0._116_.Q VDPWR VDPWR sky130_fd_pr__pfet_01v8_hvt ad=0.28 pd=2.56 as=0.135 ps=1.27 w=1 l=0.15
X643 VGND digital_0._101_.D a_15016_4044# VGND sky130_fd_pr__nfet_01v8 ad=0.2205 pd=1.89 as=0.066 ps=0.745 w=0.42 l=0.15
X644 VDPWR a_5321_2386# digital_0._112_.Q VDPWR sky130_fd_pr__pfet_01v8_hvt ad=0.3012 pd=2.66 as=0.135 ps=1.27 w=1 l=0.15
X645 digital_0._111_.Q a_8081_4018# VGND VGND sky130_fd_pr__nfet_01v8 ad=0.08775 pd=0.92 as=0.169 ps=1.82 w=0.65 l=0.15
X646 a_14981_4562# digital_0._100_.RESET_B VDPWR VDPWR sky130_fd_pr__pfet_01v8_hvt ad=0.0567 pd=0.69 as=0.0819 ps=0.81 w=0.42 l=0.15
R1 uio_oe<4> JNWTR_TIEH_CV_0.Y sky130_fd_pr__res_generic_m4 w=0.3 l=0.3
X647 digital_0.load_slew17.X a_4341_4052# VDPWR VDPWR sky130_fd_pr__pfet_01v8_hvt ad=0.135 pd=1.27 as=0.149 ps=1.325 w=1 l=0.15
X648 digital_0._119_.RESET_B digital_0.load_slew15.X VDPWR VDPWR sky130_fd_pr__pfet_01v8_hvt ad=0.135 pd=1.27 as=0.26 ps=2.52 w=1 l=0.15
X649 a_21402_18564# a_21186_16644# VGND sky130_fd_pr__res_high_po w=0.36 l=7.36
X650 digital_0._113_.D a_6631_1842# a_6575_1868# VDPWR sky130_fd_pr__pfet_01v8_hvt ad=0.135 pd=1.27 as=0.28 ps=2.56 w=1 l=0.15
X651 digital_0.hold28.A a_13969_5106# VGND VGND sky130_fd_pr__nfet_01v8 ad=0.08775 pd=0.92 as=0.169 ps=1.82 w=0.65 l=0.15
X652 VDPWR a_12405_2172# digital_0.output12.A VDPWR sky130_fd_pr__pfet_01v8_hvt ad=0.26 pd=2.52 as=0.135 ps=1.27 w=1 l=0.15
X653 a_14153_2246# a_13707_1874# a_14057_2246# VGND sky130_fd_pr__special_nfet_01v8 ad=0.1401 pd=1.1 as=0.0594 ps=0.69 w=0.36 l=0.15
X654 VDPWR LELO_GR01_0.x7.xd1<4>.A sky130_fd_pr__cap_mim_m3_1 l=5 w=5
X655 a_11883_1842# a_11665_2246# VGND VGND sky130_fd_pr__nfet_01v8 ad=0.0999 pd=0.985 as=0.1346 ps=1.15 w=0.64 l=0.15
X656 VDPWR VGND VDPWR VDPWR sky130_fd_pr__pfet_01v8_hvt ad=0.2262 pd=2.26 as=0 ps=0 w=0.87 l=0.59
X657 JNWTR_TIEH_CV_0.Y JNWTR_TIEH_CV_0.MP0.G VDPWR VDPWR sky130_fd_pr__pfet_01v8 ad=0.468 pd=2.84 as=0.468 ps=2.84 w=0.9 l=0.16
X658 VGND a_10420_1842# digital_0.input2.X VGND sky130_fd_pr__nfet_01v8 ad=0.1856 pd=1.26 as=0.2079 ps=1.83 w=0.42 l=0.15
X659 VGND digital_0._069_.B digital_0._109_.D VGND sky130_fd_pr__nfet_01v8 ad=0.169 pd=1.82 as=0.08775 ps=0.92 w=0.65 l=0.15
X660 LELO_GR01_0.x7.x15.I2 LELO_GR01_0.x7.xd1<4>.A VDPWR VDPWR sky130_fd_pr__pfet_01v8_lvt ad=0.3168 pd=1.62 as=0.5088 ps=2.98 w=0.96 l=0.94
X661 VDPWR digital_0._116_.Q a_9417_4838# VDPWR sky130_fd_pr__pfet_01v8_hvt ad=0.135 pd=1.27 as=0.135 ps=1.27 w=1 l=0.15
X662 a_13189_3750# digital_0.load_slew17.X digital_0._115_.RESET_B VDPWR sky130_fd_pr__pfet_01v8_hvt ad=0.135 pd=1.27 as=0.135 ps=1.27 w=1 l=0.15
X663 VGND VDPWR VGND VGND sky130_fd_pr__nfet_01v8 ad=0.143 pd=1.62 as=0 ps=0 w=0.55 l=0.59
X664 a_4586_8824# a_4370_6904# VGND sky130_fd_pr__res_high_po w=0.36 l=7.36
X665 digital_0.hold24.X a_4797_5676# VGND VGND sky130_fd_pr__nfet_01v8 ad=0.169 pd=1.82 as=0.097 ps=0.975 w=0.65 l=0.15
X666 VDPWR digital_0.output5.A a_15289_5676# VDPWR sky130_fd_pr__pfet_01v8_hvt ad=0.19265 pd=1.415 as=0.27 ps=2.54 w=1 l=0.15
X667 a_6564_4954# a_6477_4730# a_6160_4840# VDPWR sky130_fd_pr__pfet_01v8_hvt ad=0.12915 pd=1.185 as=0.0588 ps=0.7 w=0.42 l=0.15
X668 a_14015_4410# a_13980_4176# a_13693_4018# VGND sky130_fd_pr__nfet_01v8 ad=0.06405 pd=0.725 as=0.1092 ps=1.36 w=0.42 l=0.15
X669 LELO_GR01_0.x7.x15.I2 LELO_GR01_0.x7.xd1<4>.A VDPWR VDPWR sky130_fd_pr__pfet_01v8_lvt ad=0.3168 pd=1.62 as=0.5088 ps=2.98 w=0.96 l=0.94
X670 a_9722_2778# a_9508_2778# VDPWR VDPWR sky130_fd_pr__pfet_01v8_hvt ad=0.1155 pd=0.97 as=0.07035 ps=0.755 w=0.42 l=0.15
X671 VDPWR digital_0._111_.RESET_B a_8986_4044# VDPWR sky130_fd_pr__pfet_01v8_hvt ad=0.07035 pd=0.755 as=0.1092 ps=1.36 w=0.42 l=0.15
X672 a_5643_2412# a_5608_2664# a_5321_2386# VGND sky130_fd_pr__nfet_01v8 ad=0.06405 pd=0.725 as=0.1092 ps=1.36 w=0.42 l=0.15
X673 VGND a_11416_3500# digital_0.clkbuf_1_0__f_clk.X VGND sky130_fd_pr__nfet_01v8 ad=0.0588 pd=0.7 as=0.0588 ps=0.7 w=0.42 l=0.15
X674 VDPWR a_11416_3500# digital_0.clkbuf_1_0__f_clk.X VDPWR sky130_fd_pr__pfet_01v8_hvt ad=0.265 pd=2.53 as=0.14 ps=1.28 w=1 l=0.15
X675 a_13693_4018# a_13980_4176# VDPWR VDPWR sky130_fd_pr__pfet_01v8_hvt ad=0.0567 pd=0.69 as=0.1134 ps=1.38 w=0.42 l=0.15
X676 LELO_GR01_0.x8.x5.XA5.A LELO_GR01_0.x8.x5.XA7.CN LELO_GR01_0.x8.x5.XA4.MN1.S VGND sky130_fd_pr__nfet_01v8 ad=0.468 pd=2.84 as=0.288 ps=1.54 w=0.9 l=0.16
X677 VDPWR digital_0._065_.A2_N a_7385_3750# VDPWR sky130_fd_pr__pfet_01v8_hvt ad=0.135 pd=1.27 as=0.135 ps=1.27 w=1 l=0.15
X678 VDPWR a_6046_5364# digital_0._102_.D VDPWR sky130_fd_pr__pfet_01v8_hvt ad=0.15835 pd=1.395 as=0.26 ps=2.52 w=1 l=0.15
X679 VDPWR LELO_GR01_0.x8.PWRUP_N_1V8 LELO_GR01_0.x8.x8.D VDPWR sky130_fd_pr__pfet_01v8_lvt ad=0.5088 pd=2.98 as=0.3168 ps=1.62 w=0.96 l=0.94
X680 a_7175_5676# a_6939_5676# VDPWR VDPWR sky130_fd_pr__pfet_01v8_hvt ad=0.1092 pd=1.36 as=0.0567 ps=0.69 w=0.42 l=0.5
X681 a_11178_4954# a_10657_4562# VDPWR VDPWR sky130_fd_pr__pfet_01v8_hvt ad=0.0567 pd=0.69 as=0.0819 ps=0.81 w=0.42 l=0.15
X682 a_25702_15064# a_25918_13144# VGND sky130_fd_pr__res_high_po w=0.36 l=7.36
X683 VDPWR a_11416_3500# digital_0.clkbuf_1_0__f_clk.X VDPWR sky130_fd_pr__pfet_01v8_hvt ad=0.14 pd=1.28 as=0.14 ps=1.28 w=1 l=0.15
X684 a_5925_3642# digital_0.input1.X VDPWR VDPWR sky130_fd_pr__pfet_01v8_hvt ad=0.1664 pd=1.8 as=0.0864 ps=0.91 w=0.64 l=0.15
X685 VDPWR digital_0._114_.Q a_6075_1842# VDPWR sky130_fd_pr__pfet_01v8_hvt ad=0.1176 pd=1.4 as=0.0567 ps=0.69 w=0.42 l=0.15
X686 a_11746_2778# a_11532_2778# VDPWR VDPWR sky130_fd_pr__pfet_01v8_hvt ad=0.1155 pd=0.97 as=0.07035 ps=0.755 w=0.42 l=0.15
X687 VGND digital_0._108_.Q a_12154_5452# VGND sky130_fd_pr__nfet_01v8 ad=0.169 pd=1.82 as=0.08775 ps=0.92 w=0.65 l=0.15
X688 a_15016_4044# a_14297_4286# a_14453_4018# VGND sky130_fd_pr__special_nfet_01v8 ad=0.066 pd=0.745 as=0.0594 ps=0.69 w=0.36 l=0.15
X689 a_8772_1868# a_8685_2110# a_8368_2000# VDPWR sky130_fd_pr__pfet_01v8_hvt ad=0.12915 pd=1.185 as=0.0588 ps=0.7 w=0.42 l=0.15
X690 VDPWR VGND VDPWR VDPWR sky130_fd_pr__pfet_01v8_hvt ad=0.2262 pd=2.26 as=0 ps=0 w=0.87 l=0.59
X691 VGND digital_0.hold28.A a_13951_3827# VGND sky130_fd_pr__nfet_01v8 ad=0.1449 pd=1.11 as=0.1092 ps=1.36 w=0.42 l=0.15
X692 digital_0._104_.RESET_B digital_0.load_slew17.A VDPWR VDPWR sky130_fd_pr__pfet_01v8_hvt ad=0.135 pd=1.27 as=0.26 ps=2.52 w=1 l=0.15
X693 VDPWR a_6343_2930# digital_0.clkload0.A VDPWR sky130_fd_pr__pfet_01v8_hvt ad=0.14 pd=1.28 as=0.14 ps=1.28 w=1 l=0.15
X694 VDPWR digital_0.hold28.A a_12847_4915# VDPWR sky130_fd_pr__pfet_01v8_hvt ad=0.0693 pd=0.75 as=0.1176 ps=1.4 w=0.42 l=0.15
X695 a_7877_6003# a_7695_6003# VDPWR VDPWR sky130_fd_pr__pfet_01v8_hvt ad=0.0441 pd=0.63 as=0.0693 ps=0.75 w=0.42 l=0.15
X696 digital_0.output13.A a_13141_2930# VGND VGND sky130_fd_pr__nfet_01v8 ad=0.08775 pd=0.92 as=0.169 ps=1.82 w=0.65 l=0.15
X697 a_14770_5676# a_14553_5676# VGND VGND sky130_fd_pr__nfet_01v8 ad=0.17225 pd=1.83 as=0.1228 ps=1.065 w=0.65 l=0.25
X698 LELO_GR01_0.x7.x6<3>.G LELO_GR01_0.x7.x18.D LELO_GR01_0.x7.xd1<4>.A VGND sky130_fd_pr__nfet_01v8_lvt ad=0.5088 pd=2.98 as=0.3168 ps=1.62 w=0.96 l=0.94
X699 VDPWR digital_0._110_.D a_7196_4954# VDPWR sky130_fd_pr__pfet_01v8_hvt ad=0.1092 pd=1.36 as=0.0651 ps=0.73 w=0.42 l=0.15
X700 a_14241_4588# a_13725_4588# a_14146_4588# VGND sky130_fd_pr__special_nfet_01v8 ad=0.0594 pd=0.69 as=0.066 ps=0.745 w=0.36 l=0.15
X701 a_7871_4616# digital_0._110_.Q VDPWR VDPWR sky130_fd_pr__pfet_01v8_hvt ad=0.0567 pd=0.69 as=0.1176 ps=1.4 w=0.42 l=0.15
X702 VGND a_14797_2172# a_14731_2246# VGND sky130_fd_pr__nfet_01v8 ad=0.12495 pd=1.015 as=0.0669 ps=0.75 w=0.42 l=0.15
X703 VDPWR digital_0._114_.D a_10140_2778# VDPWR sky130_fd_pr__pfet_01v8_hvt ad=0.1092 pd=1.36 as=0.0651 ps=0.73 w=0.42 l=0.15
X704 VDPWR a_14981_4562# a_14968_4954# VDPWR sky130_fd_pr__pfet_01v8_hvt ad=0.0819 pd=0.81 as=0.0567 ps=0.69 w=0.42 l=0.15
X705 a_14995_3500# a_14759_3500# VDPWR VDPWR sky130_fd_pr__pfet_01v8_hvt ad=0.1092 pd=1.36 as=0.0567 ps=0.69 w=0.42 l=0.5
X706 VDPWR VGND VDPWR VDPWR sky130_fd_pr__pfet_01v8_hvt ad=0.2262 pd=2.26 as=0 ps=0 w=0.87 l=0.59
X707 a_14079_2412# digital_0._116_.D VGND VGND sky130_fd_pr__nfet_01v8 ad=0.0935 pd=0.965 as=0.1664 ps=1.8 w=0.64 l=0.15
X708 a_14319_2234# a_14275_1842# a_14153_2246# VGND sky130_fd_pr__nfet_01v8 ad=0.0441 pd=0.63 as=0.1401 ps=1.1 w=0.42 l=0.15
X709 digital_0.output7.A a_4033_5106# VDPWR VDPWR sky130_fd_pr__pfet_01v8_hvt ad=0.135 pd=1.27 as=0.26 ps=2.52 w=1 l=0.15
X710 a_11761_2246# a_11315_1874# a_11665_2246# VGND sky130_fd_pr__special_nfet_01v8 ad=0.1401 pd=1.1 as=0.0594 ps=0.69 w=0.36 l=0.15
X711 a_11261_4730# digital_0.input1.X VGND VGND sky130_fd_pr__nfet_01v8 ad=0.1092 pd=1.36 as=0.0567 ps=0.69 w=0.42 l=0.15
X712 VGND digital_0._116_.Q digital_0._108_.RESET_B VGND sky130_fd_pr__nfet_01v8 ad=0.08775 pd=0.92 as=0.08775 ps=0.92 w=0.65 l=0.15
X713 a_19032_18564# a_19248_16644# VGND sky130_fd_pr__res_high_po w=0.36 l=7.36
X714 LELO_GR01_0.x8.x5.XA7.CN LELO_GR01_0.x8.x5.XA7.C VGND VGND sky130_fd_pr__nfet_01v8 ad=0.468 pd=2.84 as=0.468 ps=2.84 w=0.9 l=0.16
X715 a_7851_5498# a_7816_5264# a_7529_5106# VGND sky130_fd_pr__nfet_01v8 ad=0.06405 pd=0.725 as=0.1092 ps=1.36 w=0.42 l=0.15
X716 digital_0._116_.Q a_15300_2412# VGND VGND sky130_fd_pr__nfet_01v8 ad=0.08775 pd=0.92 as=0.08775 ps=0.92 w=0.65 l=0.15
X717 VDPWR a_8841_1842# a_8772_1868# VDPWR sky130_fd_pr__pfet_01v8_hvt ad=0.2184 pd=2.2 as=0.12915 ps=1.185 w=0.84 l=0.15
X718 digital_0._109_.RESET_B digital_0.load_slew15.A a_11257_5926# VDPWR sky130_fd_pr__pfet_01v8_hvt ad=0.135 pd=1.27 as=0.26 ps=2.52 w=1 l=0.15
X719 a_22266_18564# a_22482_16644# VGND sky130_fd_pr__res_high_po w=0.36 l=7.36
X720 VGND digital_0.clkbuf_1_0__f_clk.X a_13725_2412# VGND sky130_fd_pr__nfet_01v8 ad=0.0567 pd=0.69 as=0.1092 ps=1.36 w=0.42 l=0.15
X721 VDPWR digital_0._069_.A a_6968_4276# VDPWR sky130_fd_pr__pfet_01v8_hvt ad=0.0567 pd=0.69 as=0.07438 ps=0.815 w=0.42 l=0.15
X722 digital_0._063_.A a_6968_4276# VGND VGND sky130_fd_pr__nfet_01v8 ad=0.08775 pd=0.92 as=0.17875 ps=1.85 w=0.65 l=0.15
X723 digital_0._060_.A_N a_7745_2412# VDPWR VDPWR sky130_fd_pr__pfet_01v8_hvt ad=0.165 pd=1.33 as=0.27995 ps=1.615 w=1 l=0.15
X724 digital_0.clkbuf_1_1__f_clk.A a_8735_3474# VDPWR VDPWR sky130_fd_pr__pfet_01v8_hvt ad=0.14 pd=1.28 as=0.14 ps=1.28 w=1 l=0.15
X725 a_15506_1324# a_15289_1324# VDPWR VDPWR sky130_fd_pr__pfet_01v8_hvt ad=0.2173 pd=2.17 as=0.19265 ps=1.415 w=0.82 l=0.25
X726 VDPWR digital_0._106_.D a_9404_1868# VDPWR sky130_fd_pr__pfet_01v8_hvt ad=0.1092 pd=1.36 as=0.0651 ps=0.73 w=0.42 l=0.15
X727 VDPWR LELO_GR01_0.x7.xd1<4>.A LELO_GR01_0.x7.x15.I2 VDPWR sky130_fd_pr__pfet_01v8_lvt ad=0.5088 pd=2.98 as=0.3168 ps=1.62 w=0.96 l=0.94
X728 LELO_GR01_0.x8.PWRUP_N_1V8 LELO_GR01_0.PWRUP_1V8 VDPWR VDPWR sky130_fd_pr__pfet_01v8 ad=0.468 pd=2.84 as=0.468 ps=2.84 w=0.9 l=0.16
X729 VDPWR a_6343_2930# digital_0.clkload0.A VDPWR sky130_fd_pr__pfet_01v8_hvt ad=0.14 pd=1.28 as=0.14 ps=1.28 w=1 l=0.15
X730 a_11416_3500# digital_0.clkbuf_1_1__f_clk.A VDPWR VDPWR sky130_fd_pr__pfet_01v8_hvt ad=0.14 pd=1.28 as=0.14 ps=1.28 w=1 l=0.15
X731 VGND a_10420_1298# uio_out<7> VGND sky130_fd_pr__nfet_01v8 ad=0.1856 pd=1.26 as=0.2079 ps=1.83 w=0.42 l=0.15
X732 digital_0._106_.D a_8869_1651# VDPWR VDPWR sky130_fd_pr__pfet_01v8_hvt ad=0.26 pd=2.52 as=0.15835 ps=1.395 w=1 l=0.15
X733 VDPWR a_7253_2386# digital_0.clkload0.X VDPWR sky130_fd_pr__pfet_01v8_hvt ad=0.165 pd=1.33 as=0.14 ps=1.28 w=1 l=0.15
X734 VGND a_8735_3474# digital_0.clkbuf_1_1__f_clk.A VGND sky130_fd_pr__nfet_01v8 ad=0.05775 pd=0.695 as=0.0588 ps=0.7 w=0.42 l=0.15
X735 VGND a_4149_2930# a_4080_2956# VGND sky130_fd_pr__nfet_01v8 ad=0.1346 pd=1.15 as=0.0999 ps=0.985 w=0.64 l=0.15
X736 digital_0._060_.B a_8389_3276# VDPWR VDPWR sky130_fd_pr__pfet_01v8_hvt ad=0.135 pd=1.27 as=0.26 ps=2.52 w=1 l=0.15
X737 VDPWR a_5873_4562# digital_0._110_.Q VDPWR sky130_fd_pr__pfet_01v8_hvt ad=0.3012 pd=2.66 as=0.135 ps=1.27 w=1 l=0.15
X738 a_12512_5452# digital_0._108_.Q digital_0._108_.D VGND sky130_fd_pr__nfet_01v8 ad=0.169 pd=1.82 as=0.10563 ps=0.975 w=0.65 l=0.15
X739 LELO_GR01_0.x8.x5.XA7.MP1.S LELO_GR01_0.x8.x5.Q LELO_GR01_0.x8.x8.D LELO_GR01_0.x8.x8.D sky130_fd_pr__pfet_01v8 ad=0.288 pd=1.54 as=0.288 ps=1.54 w=0.9 l=0.16
X740 digital_0._101_.RESET_B digital_0.load_slew15.X VDPWR VDPWR sky130_fd_pr__pfet_01v8_hvt ad=0.135 pd=1.27 as=0.26 ps=2.52 w=1 l=0.15
X741 LELO_GR01_0.x7.x21.D LELO_GR01_0.x8.PWRUP_N_1V8 LELO_GR01_0.x7.x20.D VDPWR sky130_fd_pr__pfet_01v8_lvt ad=0.5088 pd=2.98 as=0.3168 ps=1.62 w=0.96 l=0.94
X742 VDPWR digital_0.load_slew15.X digital_0._116_.SET_B VDPWR sky130_fd_pr__pfet_01v8_hvt ad=0.26 pd=2.52 as=0.135 ps=1.27 w=1 l=0.15
X743 a_15593_3528# digital_0._116_.Q a_15507_3528# VGND sky130_fd_pr__nfet_01v8 ad=0.0567 pd=0.69 as=0.1176 ps=1.4 w=0.42 l=0.15
X744 LELO_GR01_0.x7.x18.D LELO_GR01_0.x8.PWRUP_N_1V8 LELO_GR01_0.x7.x19.D VDPWR sky130_fd_pr__pfet_01v8_lvt ad=0.3168 pd=1.62 as=0.5088 ps=2.98 w=0.96 l=0.94
X745 VGND a_8841_4018# a_8772_4044# VGND sky130_fd_pr__nfet_01v8 ad=0.1346 pd=1.15 as=0.0999 ps=0.985 w=0.64 l=0.15
X746 a_11935_1651# digital_0.hold26.X a_11721_1651# VDPWR sky130_fd_pr__pfet_01v8_hvt ad=0.07665 pd=0.785 as=0.1932 ps=1.34 w=0.42 l=0.15
X747 uio_out<0> a_15617_5676# VDPWR VDPWR sky130_fd_pr__pfet_01v8_hvt ad=0.495 pd=2.99 as=0.2726 ps=1.61 w=1 l=0.15
X748 VGND a_6646_5650# a_6406_5834# VGND sky130_fd_pr__nfet_01v8 ad=0.1228 pd=1.065 as=0.17225 ps=1.83 w=0.65 l=0.25
X749 VGND a_3993_3198# a_3954_3072# VGND sky130_fd_pr__nfet_01v8 ad=0.0567 pd=0.69 as=0.1092 ps=1.36 w=0.42 l=0.15
X750 VDPWR digital_0._116_.Q a_13348_1574# VDPWR sky130_fd_pr__pfet_01v8_hvt ad=0.1575 pd=1.315 as=0.14 ps=1.28 w=1 l=0.15
X751 a_4320_5264# a_4637_5374# a_4595_5498# VGND sky130_fd_pr__special_nfet_01v8 ad=0.0711 pd=0.755 as=0.0669 ps=0.75 w=0.36 l=0.15
X752 VGND VGND LELO_GR01_0.x7.x15.I1 sky130_fd_pr__pnp_05v5_W3p40L3p40
**devattr s=462400,2720
X753 a_27238_18564# a_27454_16644# VGND sky130_fd_pr__res_high_po w=0.36 l=7.36
X754 digital_0._114_.RESET_B digital_0._116_.Q VGND VGND sky130_fd_pr__nfet_01v8 ad=0.08775 pd=0.92 as=0.08775 ps=0.92 w=0.65 l=0.15
X755 VGND VDPWR VGND VGND sky130_fd_pr__nfet_01v8 ad=0.143 pd=1.62 as=0 ps=0 w=0.55 l=0.59
X756 a_5386_5676# a_5169_5676# VDPWR VDPWR sky130_fd_pr__pfet_01v8_hvt ad=0.2173 pd=2.17 as=0.19265 ps=1.415 w=0.82 l=0.25
X757 VGND digital_0._069_.A digital_0._067_.B VGND sky130_fd_pr__nfet_01v8 ad=0.169 pd=1.82 as=0.08775 ps=0.92 w=0.65 l=0.15
X758 VGND VDPWR VGND VGND sky130_fd_pr__nfet_01v8 ad=0.143 pd=1.62 as=0 ps=0 w=0.55 l=0.59
X759 LELO_GR01_0.x8.x5.XA7.MN0.S VDPWR VGND VGND sky130_fd_pr__nfet_01v8 ad=0.288 pd=1.54 as=0.468 ps=2.84 w=0.9 l=0.16
X760 a_13042_1476# digital_0.hold18.X VGND VGND sky130_fd_pr__nfet_01v8 ad=0.1625 pd=1.15 as=0.1105 ps=0.99 w=0.65 l=0.15
X761 LELO_GR01_0.x7.x1.x5.IBN LELO_GR01_0.x7.x1.x5.x9<2>.G VGND VGND sky130_fd_pr__nfet_01v8_lvt ad=0.3168 pd=1.62 as=0.5088 ps=2.98 w=0.96 l=0.94
X762 a_18600_18564# a_18384_16644# VGND sky130_fd_pr__res_high_po w=0.36 l=7.36
X763 a_8772_1868# a_8646_1984# a_8368_2000# VGND sky130_fd_pr__special_nfet_01v8 ad=0.0999 pd=0.985 as=0.0711 ps=0.755 w=0.36 l=0.15
X764 VGND a_8685_4286# a_8646_4160# VGND sky130_fd_pr__nfet_01v8 ad=0.0567 pd=0.69 as=0.1092 ps=1.36 w=0.42 l=0.15
X765 a_11927_2234# a_11883_1842# a_11761_2246# VGND sky130_fd_pr__nfet_01v8 ad=0.0441 pd=0.63 as=0.1401 ps=1.1 w=0.42 l=0.15
X766 VDPWR a_14885_1298# a_14627_1298# VDPWR sky130_fd_pr__pfet_01v8_hvt ad=0.0567 pd=0.69 as=0.1092 ps=1.36 w=0.42 l=0.5
X767 digital_0._110_.D digital_0._067_.A VGND VGND sky130_fd_pr__nfet_01v8 ad=0.08775 pd=0.92 as=0.08775 ps=0.92 w=0.65 l=0.15
X768 digital_0.clkload0.X a_7253_2386# VDPWR VDPWR sky130_fd_pr__pfet_01v8_hvt ad=0.14 pd=1.28 as=0.3 ps=2.6 w=1 l=0.15
X769 digital_0.clkbuf_1_1__f_clk.A a_8735_3474# VGND VGND sky130_fd_pr__nfet_01v8 ad=0.0588 pd=0.7 as=0.0588 ps=0.7 w=0.42 l=0.15
X770 LELO_GR01_0.x7.x29.P a_25054_13144# VGND sky130_fd_pr__res_high_po w=0.36 l=7.36
X771 a_3290_8824# a_3074_6904# VGND sky130_fd_pr__res_high_po w=0.36 l=7.36
X772 digital_0._107_.RESET_B digital_0.load_slew15.X VDPWR VDPWR sky130_fd_pr__pfet_01v8_hvt ad=0.135 pd=1.27 as=0.26 ps=2.52 w=1 l=0.15
X773 VDPWR a_5925_2554# a_5886_2680# VDPWR sky130_fd_pr__pfet_01v8_hvt ad=0.0864 pd=0.91 as=0.1664 ps=1.8 w=0.64 l=0.15
X774 VGND a_11416_3500# digital_0.clkbuf_1_0__f_clk.X VGND sky130_fd_pr__nfet_01v8 ad=0.0588 pd=0.7 as=0.0588 ps=0.7 w=0.42 l=0.15
X775 a_14384_4044# a_14297_4286# a_13980_4176# VDPWR sky130_fd_pr__pfet_01v8_hvt ad=0.12915 pd=1.185 as=0.0588 ps=0.7 w=0.42 l=0.15
X776 a_7816_5264# a_8094_5248# a_8050_5132# VDPWR sky130_fd_pr__pfet_01v8_hvt ad=0.0588 pd=0.7 as=0.0567 ps=0.69 w=0.42 l=0.15
X777 VDPWR LELO_GR01_0.x7.xd1<4>.A LELO_GR01_0.x8.VREF_BG VDPWR sky130_fd_pr__pfet_01v8_lvt ad=0.5088 pd=2.98 as=0.3168 ps=1.62 w=0.96 l=0.94
X778 VGND digital_0.load_slew17.X digital_0._106_.RESET_B VGND sky130_fd_pr__nfet_01v8 ad=0.169 pd=1.82 as=0.08775 ps=0.92 w=0.65 l=0.15
X779 a_5117_1651# a_4935_1651# VDPWR VDPWR sky130_fd_pr__pfet_01v8_hvt ad=0.0441 pd=0.63 as=0.0693 ps=0.75 w=0.42 l=0.15
X780 digital_0.hold27.X a_4245_1324# VGND VGND sky130_fd_pr__nfet_01v8 ad=0.169 pd=1.82 as=0.097 ps=0.975 w=0.65 l=0.15
X781 a_14149_5650# digital_0.output5.A VDPWR VDPWR sky130_fd_pr__pfet_01v8_hvt ad=0.1092 pd=1.36 as=0.0567 ps=0.69 w=0.42 l=0.15
X782 LELO_GR01_0.x8.x3.A LELO_GR01_0.x8.x7.D VGND VGND sky130_fd_pr__nfet_01v8 ad=0.468 pd=2.84 as=0.468 ps=2.84 w=0.9 l=0.16
X783 VDPWR VGND VDPWR VDPWR sky130_fd_pr__pfet_01v8_hvt ad=0.2262 pd=2.26 as=0 ps=0 w=0.87 l=0.59
X784 LELO_GR01_0.x7.x25.D LELO_GR01_0.x8.PWRUP_N_1V8 LELO_GR01_0.x7.x24.D VDPWR sky130_fd_pr__pfet_01v8_lvt ad=0.5088 pd=2.98 as=0.3168 ps=1.62 w=0.96 l=0.94
X785 a_5925_2554# digital_0.input1.X VGND VGND sky130_fd_pr__nfet_01v8 ad=0.1092 pd=1.36 as=0.0567 ps=0.69 w=0.42 l=0.15
X786 a_6081_3737# a_5925_3642# a_6226_3866# VDPWR sky130_fd_pr__pfet_01v8_hvt ad=0.07245 pd=0.765 as=0.1155 ps=0.97 w=0.42 l=0.15
X787 a_3437_1574# digital_0.load_slew17.X digital_0._112_.RESET_B VDPWR sky130_fd_pr__pfet_01v8_hvt ad=0.135 pd=1.27 as=0.135 ps=1.27 w=1 l=0.15
X788 VDPWR VGND VDPWR VDPWR sky130_fd_pr__pfet_01v8_hvt ad=0.2262 pd=2.26 as=0 ps=0 w=0.87 l=0.59
X789 a_10861_3474# digital_0.load_slew15.A VDPWR VDPWR sky130_fd_pr__pfet_01v8_hvt ad=0.26 pd=2.52 as=0.135 ps=1.27 w=1 l=0.15
X790 VDPWR VGND VDPWR VDPWR sky130_fd_pr__pfet_01v8_hvt ad=0.2262 pd=2.26 as=0 ps=0 w=0.87 l=0.59
X791 LELO_GR01_0.x7.x22.D LELO_GR01_0.x8.PWRUP_N_1V8 LELO_GR01_0.x7.x23.D VDPWR sky130_fd_pr__pfet_01v8_lvt ad=0.3168 pd=1.62 as=0.5088 ps=2.98 w=0.96 l=0.94
X792 LELO_GR01_0.x7.x29.N a_19234_13144# VGND sky130_fd_pr__res_high_po w=0.36 l=7.36
X793 a_13942_1324# a_13725_1324# VDPWR VDPWR sky130_fd_pr__pfet_01v8_hvt ad=0.2173 pd=2.17 as=0.19265 ps=1.415 w=0.82 l=0.25
X794 a_11570_2234# digital_0._107_.D VGND VGND sky130_fd_pr__nfet_01v8 ad=0.066 pd=0.745 as=0.2205 ps=1.89 w=0.42 l=0.15
X795 a_13901_2930# a_13745_3198# a_14046_2956# VDPWR sky130_fd_pr__pfet_01v8_hvt ad=0.07245 pd=0.765 as=0.1155 ps=0.97 w=0.42 l=0.15
X796 VGND digital_0.output4.A a_14553_5676# VGND sky130_fd_pr__nfet_01v8 ad=0.1228 pd=1.065 as=0.1134 ps=1.38 w=0.42 l=0.15
X797 LELO_GR01_0.x7.x1.x5.x8.G LELO_GR01_0.x7.x1.x5.x8.G LELO_GR01_0.x7.x1.x5.x9<2>.G VGND sky130_fd_pr__nfet_01v8_lvt ad=0.3168 pd=1.62 as=0.5088 ps=2.98 w=0.96 l=0.94
X798 digital_0.output5.A a_14981_4562# VGND VGND sky130_fd_pr__nfet_01v8 ad=0.08775 pd=0.92 as=0.2087 ps=2.02 w=0.65 l=0.15
X799 digital_0._105_.D a_5189_1651# VDPWR VDPWR sky130_fd_pr__pfet_01v8_hvt ad=0.26 pd=2.52 as=0.15835 ps=1.395 w=1 l=0.15
X800 a_10140_2778# a_9421_2554# a_9577_2649# VGND sky130_fd_pr__special_nfet_01v8 ad=0.066 pd=0.745 as=0.0594 ps=0.69 w=0.36 l=0.15
X801 a_12512_5132# digital_0.output13.A VDPWR VDPWR sky130_fd_pr__pfet_01v8_hvt ad=0.135 pd=1.27 as=0.135 ps=1.27 w=1 l=0.15
X802 a_28934_15064# a_29150_13144# VGND sky130_fd_pr__res_high_po w=0.36 l=7.36
X803 VGND a_12323_1476# digital_0.hold26.X VGND sky130_fd_pr__nfet_01v8 ad=0.097 pd=0.975 as=0.169 ps=1.82 w=0.65 l=0.15
X804 VDPWR a_14453_4018# a_14384_4044# VDPWR sky130_fd_pr__pfet_01v8_hvt ad=0.2184 pd=2.2 as=0.12915 ps=1.185 w=0.84 l=0.15
X805 VGND VDPWR VGND VGND sky130_fd_pr__nfet_01v8 ad=0.143 pd=1.62 as=0 ps=0 w=0.55 l=0.59
X806 VGND a_10786_1842# a_10546_2106# VGND sky130_fd_pr__nfet_01v8 ad=0.1228 pd=1.065 as=0.17225 ps=1.83 w=0.65 l=0.25
X807 VDPWR digital_0._101_.D a_15016_4044# VDPWR sky130_fd_pr__pfet_01v8_hvt ad=0.1092 pd=1.36 as=0.0651 ps=0.73 w=0.42 l=0.15
X808 a_9421_2554# digital_0.input1.X VDPWR VDPWR sky130_fd_pr__pfet_01v8_hvt ad=0.1664 pd=1.8 as=0.0864 ps=0.91 w=0.64 l=0.15
X809 a_6644_3866# a_5886_3768# a_6081_3737# VDPWR sky130_fd_pr__pfet_01v8_hvt ad=0.0651 pd=0.73 as=0.07245 ps=0.765 w=0.42 l=0.15
X810 digital_0._111_.RESET_B digital_0.load_slew17.A a_9417_4838# VDPWR sky130_fd_pr__pfet_01v8_hvt ad=0.135 pd=1.27 as=0.26 ps=2.52 w=1 l=0.15
X811 a_7226_1324# a_7009_1324# VDPWR VDPWR sky130_fd_pr__pfet_01v8_hvt ad=0.2173 pd=2.17 as=0.19265 ps=1.415 w=0.82 l=0.25
X812 digital_0.clkbuf_1_0__f_clk.X a_11416_3500# VGND VGND sky130_fd_pr__nfet_01v8 ad=0.0588 pd=0.7 as=0.0588 ps=0.7 w=0.42 l=0.15
X813 VGND a_12677_1298# a_12419_1298# VGND sky130_fd_pr__nfet_01v8 ad=0.0567 pd=0.69 as=0.1092 ps=1.36 w=0.42 l=0.5
X814 VGND digital_0._114_.D a_10140_2778# VGND sky130_fd_pr__nfet_01v8 ad=0.2205 pd=1.89 as=0.066 ps=0.745 w=0.42 l=0.15
X815 digital_0.output6.A a_13693_4018# VGND VGND sky130_fd_pr__nfet_01v8 ad=0.08775 pd=0.92 as=0.169 ps=1.82 w=0.65 l=0.15
X816 a_10514_13154# a_10730_11234# VGND sky130_fd_pr__res_high_po w=0.36 l=7.36
X817 digital_0.clkbuf_1_1__f_clk.A a_8735_3474# VDPWR VDPWR sky130_fd_pr__pfet_01v8_hvt ad=0.14 pd=1.28 as=0.1375 ps=1.275 w=1 l=0.15
X818 a_14464_2956# a_13706_3072# a_13901_2930# VDPWR sky130_fd_pr__pfet_01v8_hvt ad=0.0651 pd=0.73 as=0.07245 ps=0.765 w=0.42 l=0.15
X819 VGND a_3679_2412# a_3785_2412# VGND sky130_fd_pr__nfet_01v8 ad=0.097 pd=0.975 as=0.1092 ps=1.36 w=0.42 l=0.5
X820 a_14419_3827# digital_0.hold22.X a_14205_3827# VDPWR sky130_fd_pr__pfet_01v8_hvt ad=0.07665 pd=0.785 as=0.1932 ps=1.34 w=0.42 l=0.15
X821 a_12154_5452# digital_0._108_.Q a_12069_5132# VDPWR sky130_fd_pr__pfet_01v8_hvt ad=0.135 pd=1.27 as=0.135 ps=1.27 w=1 l=0.15
X822 VDPWR a_14876_2626# a_14834_2778# VDPWR sky130_fd_pr__pfet_01v8_hvt ad=0.1092 pd=1.36 as=0.0441 ps=0.63 w=0.42 l=0.15
X823 a_8133_5374# digital_0.clkload0.A VGND VGND sky130_fd_pr__nfet_01v8 ad=0.1092 pd=1.36 as=0.0567 ps=0.69 w=0.42 l=0.15
X824 digital_0._063_.B digital_0._112_.Q a_7385_3750# VDPWR sky130_fd_pr__pfet_01v8_hvt ad=0.135 pd=1.27 as=0.36 ps=2.72 w=1 l=0.15
X825 a_3336_4018# a_3462_4282# VDPWR VDPWR sky130_fd_pr__pfet_01v8_hvt ad=0.2173 pd=2.17 as=0.2726 ps=1.61 w=0.82 l=0.25
X826 a_16440_18564# a_16656_16644# VGND sky130_fd_pr__res_high_po w=0.36 l=7.36
X827 digital_0._108_.RESET_B digital_0.load_slew15.A a_10137_4838# VDPWR sky130_fd_pr__pfet_01v8_hvt ad=0.135 pd=1.27 as=0.135 ps=1.27 w=1 l=0.15
X828 LELO_GR01_0.x7.x19.D LELO_GR01_0.x8.PWRUP_N_1V8 LELO_GR01_0.x7.x18.D VDPWR sky130_fd_pr__pfet_01v8_lvt ad=0.5088 pd=2.98 as=0.3168 ps=1.62 w=0.96 l=0.94
X829 a_14174_2412# a_13725_2412# a_14079_2412# VGND sky130_fd_pr__special_nfet_01v8 ad=0.072 pd=0.76 as=0.0935 ps=0.965 w=0.36 l=0.15
X830 a_9090_1324# digital_0._114_.Q a_8869_1651# VGND sky130_fd_pr__nfet_01v8 ad=0.0693 pd=0.75 as=0.09975 ps=0.895 w=0.42 l=0.15
X831 digital_0._107_.D a_11721_1651# VGND VGND sky130_fd_pr__nfet_01v8 ad=0.169 pd=1.82 as=0.11285 ps=1.045 w=0.65 l=0.15
X832 VGND digital_0._113_.RESET_B a_5643_3500# VGND sky130_fd_pr__nfet_01v8 ad=0.12495 pd=1.015 as=0.06405 ps=0.725 w=0.42 l=0.15
X833 a_8841_4018# a_8685_4286# a_8986_4044# VDPWR sky130_fd_pr__pfet_01v8_hvt ad=0.07245 pd=0.765 as=0.1155 ps=0.97 w=0.42 l=0.15
X834 digital_0.clkbuf_1_0__f_clk.X a_11416_3500# VDPWR VDPWR sky130_fd_pr__pfet_01v8_hvt ad=0.14 pd=1.28 as=0.14 ps=1.28 w=1 l=0.15
X835 a_14968_4954# a_13891_4588# a_14806_4588# VDPWR sky130_fd_pr__pfet_01v8_hvt ad=0.0567 pd=0.69 as=0.0588 ps=0.7 w=0.42 l=0.15
X836 a_23130_18564# a_22914_16644# VGND sky130_fd_pr__res_high_po w=0.36 l=7.36
X837 digital_0._101_.D a_14205_3827# VGND VGND sky130_fd_pr__nfet_01v8 ad=0.169 pd=1.82 as=0.11285 ps=1.045 w=0.65 l=0.15
X838 VDPWR a_14770_5676# a_14881_5676# VDPWR sky130_fd_pr__pfet_01v8_hvt ad=0.2726 pd=1.61 as=0.2173 ps=2.17 w=0.82 l=0.25
X839 a_8852_5132# a_8133_5374# a_8289_5106# VGND sky130_fd_pr__special_nfet_01v8 ad=0.066 pd=0.745 as=0.0594 ps=0.69 w=0.36 l=0.15
X840 VDPWR VGND VDPWR VDPWR sky130_fd_pr__pfet_01v8_hvt ad=0.2262 pd=2.26 as=0 ps=0 w=0.87 l=0.59
X841 digital_0.clkload0.A a_6343_2930# VDPWR VDPWR sky130_fd_pr__pfet_01v8_hvt ad=0.14 pd=1.28 as=0.14 ps=1.28 w=1 l=0.15
X842 LELO_GR01_0.x7.x7.G LELO_GR01_0.x7.xd1<4>.A VDPWR VDPWR sky130_fd_pr__pfet_01v8_lvt ad=0.3168 pd=1.62 as=0.5088 ps=2.98 w=0.96 l=0.94
X843 LELO_GR01_0.x8.x5.XA5.A LELO_GR01_0.x8.x5.XA7.C LELO_GR01_0.x8.x5.XA3.MN1.S VGND sky130_fd_pr__nfet_01v8 ad=0.468 pd=2.84 as=0.288 ps=1.54 w=0.9 l=0.16
X844 VGND digital_0.hold28.A a_4858_3500# VGND sky130_fd_pr__nfet_01v8 ad=0.11285 pd=1.045 as=0.0693 ps=0.75 w=0.42 l=0.15
X845 VGND digital_0.hold28.A a_12367_2956# VGND sky130_fd_pr__nfet_01v8 ad=0.0567 pd=0.69 as=0.1092 ps=1.36 w=0.42 l=0.15
X846 a_4374_2412# a_4157_2412# VDPWR VDPWR sky130_fd_pr__pfet_01v8_hvt ad=0.2173 pd=2.17 as=0.19265 ps=1.415 w=0.82 l=0.25
X847 a_6477_4730# digital_0.input1.X VGND VGND sky130_fd_pr__nfet_01v8 ad=0.1092 pd=1.36 as=0.0567 ps=0.69 w=0.42 l=0.15
X848 VGND digital_0.output8.A a_6939_5676# VGND sky130_fd_pr__nfet_01v8 ad=0.0567 pd=0.69 as=0.1092 ps=1.36 w=0.42 l=0.15
X849 digital_0._116_.SET_B digital_0.load_slew15.X VGND VGND sky130_fd_pr__nfet_01v8 ad=0.08775 pd=0.92 as=0.169 ps=1.82 w=0.65 l=0.15
X850 a_3679_2412# a_3443_2412# VGND VGND sky130_fd_pr__nfet_01v8 ad=0.1092 pd=1.36 as=0.0567 ps=0.69 w=0.42 l=0.5
X851 digital_0._108_.D a_12154_5452# a_12512_5132# VDPWR sky130_fd_pr__pfet_01v8_hvt ad=0.135 pd=1.27 as=0.26 ps=2.52 w=1 l=0.15
X852 a_11721_1651# digital_0._115_.Q a_11649_1651# VDPWR sky130_fd_pr__pfet_01v8_hvt ad=0.1932 pd=1.34 as=0.0441 ps=0.63 w=0.42 l=0.15
X853 a_9404_4044# a_8646_4160# a_8841_4018# VDPWR sky130_fd_pr__pfet_01v8_hvt ad=0.0651 pd=0.73 as=0.07245 ps=0.765 w=0.42 l=0.15
X854 VDPWR digital_0._105_.RESET_B a_4846_1868# VDPWR sky130_fd_pr__pfet_01v8_hvt ad=0.07035 pd=0.755 as=0.1092 ps=1.36 w=0.42 l=0.15
X855 a_3722_8824# a_3938_6904# VGND sky130_fd_pr__res_high_po w=0.36 l=7.36
X856 LELO_GR01_0.x8.x1.x5.x8.G LELO_GR01_0.x8.x1.x5.x8.G LELO_GR01_0.x8.x1.x5.x8.S LELO_GR01_0.x8.x1.x5.x8.S sky130_fd_pr__pfet_01v8_lvt ad=0.3168 pd=1.62 as=0.5088 ps=2.98 w=0.96 l=0.94
X857 a_4632_1868# a_4506_1984# a_4228_2000# VGND sky130_fd_pr__special_nfet_01v8 ad=0.0999 pd=0.985 as=0.0711 ps=0.755 w=0.36 l=0.15
X858 a_3941_1842# a_4228_2000# VDPWR VDPWR sky130_fd_pr__pfet_01v8_hvt ad=0.0567 pd=0.69 as=0.1134 ps=1.38 w=0.42 l=0.15
X859 a_11721_1324# a_11467_1651# VGND VGND sky130_fd_pr__nfet_01v8 ad=0.0693 pd=0.75 as=0.1449 ps=1.11 w=0.42 l=0.15
X860 VDPWR a_8081_1842# digital_0.output11.A VDPWR sky130_fd_pr__pfet_01v8_hvt ad=0.3012 pd=2.66 as=0.135 ps=1.27 w=1 l=0.15
X861 VGND VDPWR VGND VGND sky130_fd_pr__nfet_01v8 ad=0.143 pd=1.62 as=0 ps=0 w=0.55 l=0.59
X862 a_15506_5676# a_15289_5676# VDPWR VDPWR sky130_fd_pr__pfet_01v8_hvt ad=0.2173 pd=2.17 as=0.19265 ps=1.415 w=0.82 l=0.25
X863 VGND digital_0._109_.RESET_B a_10979_4588# VGND sky130_fd_pr__nfet_01v8 ad=0.12495 pd=1.015 as=0.06405 ps=0.725 w=0.42 l=0.15
X864 a_28102_18564# a_27886_16644# VGND sky130_fd_pr__res_high_po w=0.36 l=7.36
X865 a_9980_8824# a_9764_6904# VGND sky130_fd_pr__res_high_po w=0.36 l=7.36
X866 VDPWR a_8003_1324# a_8109_1324# VDPWR sky130_fd_pr__pfet_01v8_hvt ad=0.14075 pd=1.325 as=0.1092 ps=1.36 w=0.42 l=0.5
X867 digital_0.hold23.X a_3785_2412# VGND VGND sky130_fd_pr__nfet_01v8 ad=0.169 pd=1.82 as=0.097 ps=0.975 w=0.65 l=0.15
X868 a_8389_3276# digital_0._114_.Q VGND VGND sky130_fd_pr__nfet_01v8 ad=0.169 pd=1.82 as=0.08775 ps=0.92 w=0.65 l=0.15
X869 a_8003_1324# a_7767_1324# VGND VGND sky130_fd_pr__nfet_01v8 ad=0.1092 pd=1.36 as=0.0567 ps=0.69 w=0.42 l=0.5
X870 VDPWR digital_0.clkbuf_1_1__f_clk.A a_11416_3500# VDPWR sky130_fd_pr__pfet_01v8_hvt ad=0.14 pd=1.28 as=0.14 ps=1.28 w=1 l=0.15
X871 digital_0.hold21.X a_8109_1324# VGND VGND sky130_fd_pr__nfet_01v8 ad=0.169 pd=1.82 as=0.097 ps=0.975 w=0.65 l=0.15
X872 digital_0._067_.B digital_0._069_.A a_6457_4044# VDPWR sky130_fd_pr__pfet_01v8_hvt ad=0.135 pd=1.27 as=0.135 ps=1.27 w=1 l=0.15
X873 a_22902_15064# a_22686_13144# VGND sky130_fd_pr__res_high_po w=0.36 l=7.36
X874 LELO_GR01_0.x7.x30.N a_3074_6904# VGND sky130_fd_pr__res_high_po w=0.36 l=7.36
X875 a_9434_2956# a_9217_2956# VGND VGND sky130_fd_pr__nfet_01v8 ad=0.17225 pd=1.83 as=0.1228 ps=1.065 w=0.65 l=0.25
X876 VDPWR VGND VDPWR VDPWR sky130_fd_pr__pfet_01v8_hvt ad=0.2262 pd=2.26 as=0 ps=0 w=0.87 l=0.59
X877 a_11128_2664# a_11406_2680# a_11362_2778# VDPWR sky130_fd_pr__pfet_01v8_hvt ad=0.0588 pd=0.7 as=0.0567 ps=0.69 w=0.42 l=0.15
X878 VGND digital_0._116_.Q digital_0._111_.RESET_B VGND sky130_fd_pr__nfet_01v8 ad=0.182 pd=1.86 as=0.08775 ps=0.92 w=0.65 l=0.15
X879 digital_0._109_.Q a_10657_4562# VDPWR VDPWR sky130_fd_pr__pfet_01v8_hvt ad=0.135 pd=1.27 as=0.26 ps=2.52 w=1 l=0.15
X880 a_7025_5132# digital_0._067_.B digital_0._110_.D VDPWR sky130_fd_pr__pfet_01v8_hvt ad=0.135 pd=1.27 as=0.135 ps=1.27 w=1 l=0.15
X881 VGND digital_0._110_.Q digital_0._067_.B VGND sky130_fd_pr__nfet_01v8 ad=0.08775 pd=0.92 as=0.08775 ps=0.92 w=0.65 l=0.15
X882 a_14967_5498# digital_0._117_.RESET_B VGND VGND sky130_fd_pr__nfet_01v8 ad=0.0441 pd=0.63 as=0.1346 ps=1.15 w=0.42 l=0.15
X883 a_5410_1324# digital_0._113_.Q a_5189_1651# VGND sky130_fd_pr__nfet_01v8 ad=0.0693 pd=0.75 as=0.09975 ps=0.895 w=0.42 l=0.15
X884 a_28502_15064# a_28718_13144# VGND sky130_fd_pr__res_high_po w=0.36 l=7.36
X885 LELO_GR01_0.x8.x1.x5.x8.G LELO_GR01_0.x8.x1.x5.x8.G LELO_GR01_0.x8.x1.x5.x9<2>.G VGND sky130_fd_pr__nfet_01v8_lvt ad=0.3168 pd=1.62 as=0.5088 ps=2.98 w=0.96 l=0.94
X886 a_20970_18564# a_21186_16644# VGND sky130_fd_pr__res_high_po w=0.36 l=7.36
X887 VDPWR LELO_GR01_0.x8.x1.x7.D LELO_GR01_0.x8.x1.x7.D VDPWR sky130_fd_pr__pfet_01v8_lvt ad=0.5088 pd=2.98 as=0.3168 ps=1.62 w=0.96 l=0.94
X888 a_8389_2956# digital_0._065_.A2_N VDPWR VDPWR sky130_fd_pr__pfet_01v8_hvt ad=0.135 pd=1.27 as=0.135 ps=1.27 w=1 l=0.15
X889 a_13891_4588# a_13725_4588# VGND VGND sky130_fd_pr__nfet_01v8 ad=0.1092 pd=1.36 as=0.0567 ps=0.69 w=0.42 l=0.15
X890 VGND LELO_GR01_0.x8.x1.x5.x9<2>.G LELO_GR01_0.x8.x1.x5.x8.G VGND sky130_fd_pr__nfet_01v8_lvt ad=0.5088 pd=2.98 as=0.3168 ps=1.62 w=0.96 l=0.94
X891 digital_0.clkbuf_1_1__f_clk.A a_8735_3474# VDPWR VDPWR sky130_fd_pr__pfet_01v8_hvt ad=0.14 pd=1.28 as=0.14 ps=1.28 w=1 l=0.15
X892 VGND VDPWR VGND VGND sky130_fd_pr__nfet_01v8 ad=0.143 pd=1.62 as=0 ps=0 w=0.55 l=0.59
X893 digital_0._110_.D digital_0._067_.B VGND VGND sky130_fd_pr__nfet_01v8 ad=0.08775 pd=0.92 as=0.169 ps=1.82 w=0.65 l=0.15
X894 VDPWR a_14981_4562# digital_0.output5.A VDPWR sky130_fd_pr__pfet_01v8_hvt ad=0.26 pd=2.52 as=0.135 ps=1.27 w=1 l=0.15
X895 a_6188_5498# digital_0.hold28.A VGND VGND sky130_fd_pr__nfet_01v8 ad=0.0693 pd=0.75 as=0.11285 ps=1.045 w=0.42 l=0.15
X896 LELO_GR01_0.x8.x7.D LELO_GR01_0.x8.x1.x7.D VDPWR VDPWR sky130_fd_pr__pfet_01v8_lvt ad=0.3168 pd=1.62 as=0.5088 ps=2.98 w=0.96 l=0.94
X897 VGND digital_0._080_.A2 a_13420_1324# VGND sky130_fd_pr__nfet_01v8 ad=0.17225 pd=1.83 as=0.1235 ps=1.03 w=0.65 l=0.15
X898 VGND VDPWR VGND VGND sky130_fd_pr__nfet_01v8 ad=0.143 pd=1.62 as=0 ps=0 w=0.55 l=0.59
X899 digital_0._114_.RESET_B digital_0.load_slew15.A VGND VGND sky130_fd_pr__nfet_01v8 ad=0.08775 pd=0.92 as=0.169 ps=1.82 w=0.65 l=0.15
X900 a_11416_3500# digital_0.clkbuf_1_1__f_clk.A VDPWR VDPWR sky130_fd_pr__pfet_01v8_hvt ad=0.14 pd=1.28 as=0.265 ps=2.53 w=1 l=0.15
X901 VGND digital_0.hold28.A a_8170_5676# VGND sky130_fd_pr__nfet_01v8 ad=0.11285 pd=1.045 as=0.0693 ps=0.75 w=0.42 l=0.15
X902 a_14874_5132# a_14660_5132# VDPWR VDPWR sky130_fd_pr__pfet_01v8_hvt ad=0.1155 pd=0.97 as=0.07035 ps=0.755 w=0.42 l=0.15
X903 VDPWR a_7253_2386# digital_0.clkload0.X VDPWR sky130_fd_pr__pfet_01v8_hvt ad=0.14 pd=1.28 as=0.14 ps=1.28 w=1 l=0.15
X904 VGND a_8735_3474# digital_0.clkbuf_1_1__f_clk.A VGND sky130_fd_pr__nfet_01v8 ad=0.0588 pd=0.7 as=0.0588 ps=0.7 w=0.42 l=0.15
X905 VDPWR digital_0._116_.Q a_3437_1868# VDPWR sky130_fd_pr__pfet_01v8_hvt ad=0.135 pd=1.27 as=0.135 ps=1.27 w=1 l=0.15
X906 a_4294_2956# a_4080_2956# VDPWR VDPWR sky130_fd_pr__pfet_01v8_hvt ad=0.1155 pd=0.97 as=0.07035 ps=0.755 w=0.42 l=0.15
X907 a_7207_4404# digital_0._065_.A2_N VGND VGND sky130_fd_pr__nfet_01v8 ad=0.05355 pd=0.675 as=0.1304 ps=1.105 w=0.42 l=0.15
X908 a_6646_5650# digital_0.output8.A VGND VGND sky130_fd_pr__nfet_01v8 ad=0.1134 pd=1.38 as=0.1228 ps=1.065 w=0.42 l=0.15
X909 VGND a_12405_2172# a_12339_2246# VGND sky130_fd_pr__nfet_01v8 ad=0.12495 pd=1.015 as=0.0669 ps=0.75 w=0.42 l=0.15
X910 a_12405_2172# digital_0._107_.RESET_B VDPWR VDPWR sky130_fd_pr__pfet_01v8_hvt ad=0.0567 pd=0.69 as=0.0819 ps=0.81 w=0.42 l=0.15
X911 digital_0.clkbuf_1_0__f_clk.X a_11416_3500# VGND VGND sky130_fd_pr__nfet_01v8 ad=0.0588 pd=0.7 as=0.0588 ps=0.7 w=0.42 l=0.15
X912 VGND digital_0._102_.D a_5356_5132# VGND sky130_fd_pr__nfet_01v8 ad=0.2205 pd=1.89 as=0.066 ps=0.745 w=0.42 l=0.15
X913 a_4139_1324# a_3903_1324# VGND VGND sky130_fd_pr__nfet_01v8 ad=0.1092 pd=1.36 as=0.0567 ps=0.69 w=0.42 l=0.5
X914 a_14241_4588# a_13891_4588# a_14146_4588# VDPWR sky130_fd_pr__pfet_01v8_hvt ad=0.07245 pd=0.765 as=0.0651 ps=0.73 w=0.42 l=0.15
X915 digital_0._100_.D a_13101_4915# VDPWR VDPWR sky130_fd_pr__pfet_01v8_hvt ad=0.26 pd=2.52 as=0.15835 ps=1.395 w=1 l=0.15
X916 a_11315_1874# a_11149_1874# VDPWR VDPWR sky130_fd_pr__pfet_01v8_hvt ad=0.1664 pd=1.8 as=0.0864 ps=0.91 w=0.64 l=0.15
X917 digital_0._115_.D digital_0._060_.A_N a_11592_3276# VGND sky130_fd_pr__nfet_01v8 ad=0.10563 pd=0.975 as=0.08775 ps=0.92 w=0.65 l=0.15
X918 VDPWR a_8289_5106# a_8220_5132# VDPWR sky130_fd_pr__pfet_01v8_hvt ad=0.2184 pd=2.2 as=0.12915 ps=1.185 w=0.84 l=0.15
X919 VGND digital_0._101_.RESET_B a_14015_4410# VGND sky130_fd_pr__nfet_01v8 ad=0.12495 pd=1.015 as=0.06405 ps=0.725 w=0.42 l=0.15
X920 a_25942_18564# a_26158_16644# VGND sky130_fd_pr__res_high_po w=0.36 l=7.36
X921 a_3730_3500# a_3513_3500# VGND VGND sky130_fd_pr__nfet_01v8 ad=0.17225 pd=1.83 as=0.1228 ps=1.065 w=0.65 l=0.25
X922 a_5103_5498# a_4724_5132# a_5031_5498# VGND sky130_fd_pr__nfet_01v8 ad=0.1401 pd=1.1 as=0.0441 ps=0.63 w=0.42 l=0.15
X923 a_15506_1324# a_15289_1324# VGND VGND sky130_fd_pr__nfet_01v8 ad=0.17225 pd=1.83 as=0.1228 ps=1.065 w=0.65 l=0.25
X924 VGND LELO_GR01_0.x7.x1.x5.x9<2>.G LELO_GR01_0.x7.x1.x5.x8.G VGND sky130_fd_pr__nfet_01v8_lvt ad=0.5088 pd=2.98 as=0.3168 ps=1.62 w=0.96 l=0.94
X925 VDPWR a_13745_3198# a_13706_3072# VDPWR sky130_fd_pr__pfet_01v8_hvt ad=0.0864 pd=0.91 as=0.1664 ps=1.8 w=0.64 l=0.15
X926 a_8841_4018# a_8646_4160# a_9151_4410# VGND sky130_fd_pr__special_nfet_01v8 ad=0.0594 pd=0.69 as=0.1401 ps=1.1 w=0.36 l=0.15
X927 digital_0._109_.D digital_0._069_.A VGND VGND sky130_fd_pr__nfet_01v8 ad=0.08775 pd=0.92 as=0.182 ps=1.86 w=0.65 l=0.15
X928 digital_0.clkload0.A a_6343_2930# VDPWR VDPWR sky130_fd_pr__pfet_01v8_hvt ad=0.14 pd=1.28 as=0.14 ps=1.28 w=1 l=0.15
X929 a_6081_3737# a_5886_3768# a_6391_3500# VGND sky130_fd_pr__special_nfet_01v8 ad=0.0594 pd=0.69 as=0.1401 ps=1.1 w=0.36 l=0.15
X930 LELO_GR01_0.x7.x29.N a_16214_13144# VGND sky130_fd_pr__res_high_po w=0.36 l=7.36
X931 a_17304_18564# a_17088_16644# VGND sky130_fd_pr__res_high_po w=0.36 l=7.36
X932 LELO_GR01_0.x8.IBP_BG VGND sky130_fd_pr__cap_mim_m3_1 l=5 w=5
X933 LELO_GR01_0.x7.x6<3>.G LELO_GR01_0.x7.x6<3>.G LELO_GR01_0.x7.x7.S VGND sky130_fd_pr__nfet_01v8_lvt ad=0.3168 pd=1.62 as=0.5088 ps=2.98 w=0.96 l=0.94
X934 digital_0._104_.D a_4637_3827# VGND VGND sky130_fd_pr__nfet_01v8 ad=0.169 pd=1.82 as=0.11285 ps=1.045 w=0.65 l=0.15
X935 VGND digital_0._106_.RESET_B a_8403_2234# VGND sky130_fd_pr__nfet_01v8 ad=0.12495 pd=1.015 as=0.06405 ps=0.725 w=0.42 l=0.15
X936 VDPWR a_13042_1476# digital_0._116_.D VDPWR sky130_fd_pr__pfet_01v8_hvt ad=0.265 pd=2.53 as=0.14 ps=1.28 w=1 l=0.15
X937 a_4263_2234# a_4228_2000# a_3941_1842# VGND sky130_fd_pr__nfet_01v8 ad=0.06405 pd=0.725 as=0.1092 ps=1.36 w=0.42 l=0.15
X938 LELO_GR01_0.x8.IBP_BG LELO_GR01_0.x7.xd1<4>.A VDPWR VDPWR sky130_fd_pr__pfet_01v8_lvt ad=0.3168 pd=1.62 as=0.5088 ps=2.98 w=0.96 l=0.94
X939 VGND VDPWR VGND VGND sky130_fd_pr__nfet_01v8 ad=0.143 pd=1.62 as=0 ps=0 w=0.55 l=0.59
X940 digital_0._118_.RESET_B digital_0.load_slew15.X VDPWR VDPWR sky130_fd_pr__pfet_01v8_hvt ad=0.135 pd=1.27 as=0.26 ps=2.52 w=1 l=0.15
X941 a_6188_5171# digital_0.hold28.A VDPWR VDPWR sky130_fd_pr__pfet_01v8_hvt ad=0.07665 pd=0.785 as=0.15835 ps=1.395 w=0.42 l=0.15
X942 a_14256_5264# a_14534_5248# a_14490_5132# VDPWR sky130_fd_pr__pfet_01v8_hvt ad=0.0588 pd=0.7 as=0.0567 ps=0.69 w=0.42 l=0.15
X943 VGND LELO_GR01_0.x7.x7.G LELO_GR01_0.x7.x7.S VDPWR sky130_fd_pr__pfet_01v8_lvt ad=0.3168 pd=1.62 as=0.5088 ps=2.98 w=0.96 l=0.94
X944 VGND VDPWR VGND VGND sky130_fd_pr__nfet_01v8 ad=0.143 pd=1.62 as=0 ps=0 w=0.55 l=0.59
X945 a_5608_3752# a_5925_3642# a_5883_3500# VGND sky130_fd_pr__special_nfet_01v8 ad=0.0711 pd=0.755 as=0.0669 ps=0.75 w=0.36 l=0.15
X946 VGND VDPWR VGND VGND sky130_fd_pr__nfet_01v8 ad=0.143 pd=1.62 as=0 ps=0 w=0.55 l=0.59
X947 a_3676_3088# a_3954_3072# a_3910_2956# VDPWR sky130_fd_pr__pfet_01v8_hvt ad=0.0588 pd=0.7 as=0.0567 ps=0.69 w=0.42 l=0.15
X948 VDPWR VGND VDPWR VDPWR sky130_fd_pr__pfet_01v8_hvt ad=0.2262 pd=2.26 as=0 ps=0 w=0.87 l=0.59
X949 VGND a_11416_3500# digital_0.clkbuf_1_0__f_clk.X VGND sky130_fd_pr__nfet_01v8 ad=0.0588 pd=0.7 as=0.0588 ps=0.7 w=0.42 l=0.15
X950 LELO_GR01_0.x7.x1.x5.IBN LELO_GR01_0.x7.x1.x5.x9<2>.G VGND VGND sky130_fd_pr__nfet_01v8_lvt ad=0.3168 pd=1.62 as=0.5088 ps=2.98 w=0.96 l=0.94
X951 VDPWR digital_0._108_.RESET_B a_11209_4018# VDPWR sky130_fd_pr__pfet_01v8_hvt ad=0.0819 pd=0.81 as=0.0567 ps=0.69 w=0.42 l=0.15
X952 a_7949_6003# digital_0._111_.Q a_7877_6003# VDPWR sky130_fd_pr__pfet_01v8_hvt ad=0.1932 pd=1.34 as=0.0441 ps=0.63 w=0.42 l=0.15
X953 a_11813_4286# digital_0.input1.X VDPWR VDPWR sky130_fd_pr__pfet_01v8_hvt ad=0.1664 pd=1.8 as=0.0864 ps=0.91 w=0.64 l=0.15
X954 a_6343_2930# digital_0.clkbuf_1_1__f_clk.A VDPWR VDPWR sky130_fd_pr__pfet_01v8_hvt ad=0.14 pd=1.28 as=0.14 ps=1.28 w=1 l=0.15
X955 a_5386_5676# a_5169_5676# VGND VGND sky130_fd_pr__nfet_01v8 ad=0.17225 pd=1.83 as=0.1228 ps=1.065 w=0.65 l=0.25
X956 VDPWR digital_0.hold28.A a_8615_1651# VDPWR sky130_fd_pr__pfet_01v8_hvt ad=0.0693 pd=0.75 as=0.1176 ps=1.4 w=0.42 l=0.15
X957 VDPWR a_11416_3500# digital_0.clkbuf_1_0__f_clk.X VDPWR sky130_fd_pr__pfet_01v8_hvt ad=0.14 pd=1.28 as=0.14 ps=1.28 w=1 l=0.15
X958 a_5264_1868# a_4545_2110# a_4701_1842# VGND sky130_fd_pr__special_nfet_01v8 ad=0.066 pd=0.745 as=0.0594 ps=0.69 w=0.36 l=0.15
X959 VDPWR a_3730_3500# a_3841_3500# VDPWR sky130_fd_pr__pfet_01v8_hvt ad=0.2726 pd=1.61 as=0.2173 ps=2.17 w=0.82 l=0.25
X960 VDPWR digital_0._116_.Q a_10137_4838# VDPWR sky130_fd_pr__pfet_01v8_hvt ad=0.135 pd=1.27 as=0.28 ps=2.56 w=1 l=0.15
X961 VGND a_11234_3276# digital_0._115_.D VGND sky130_fd_pr__nfet_01v8 ad=0.169 pd=1.82 as=0.08775 ps=0.92 w=0.65 l=0.15
X962 a_7827_2412# digital_0._112_.Q a_7745_2412# VGND sky130_fd_pr__nfet_01v8 ad=0.06195 pd=0.715 as=0.1092 ps=1.36 w=0.42 l=0.15
X963 VDPWR digital_0.output13.A a_15289_1324# VDPWR sky130_fd_pr__pfet_01v8_hvt ad=0.19265 pd=1.415 as=0.27 ps=2.54 w=1 l=0.15
X964 VGND digital_0.hold28.A a_8615_1651# VGND sky130_fd_pr__nfet_01v8 ad=0.1449 pd=1.11 as=0.1092 ps=1.36 w=0.42 l=0.15
X965 VDPWR a_12405_2172# a_12392_1868# VDPWR sky130_fd_pr__pfet_01v8_hvt ad=0.0819 pd=0.81 as=0.0567 ps=0.69 w=0.42 l=0.15
X966 VGND digital_0.output6.A a_12919_2412# VGND sky130_fd_pr__nfet_01v8 ad=0.0567 pd=0.69 as=0.1092 ps=1.36 w=0.42 l=0.15
X967 VDPWR VGND VDPWR VDPWR sky130_fd_pr__pfet_01v8_hvt ad=0.2262 pd=2.26 as=0 ps=0 w=0.87 l=0.59
X968 a_25510_18564# a_25294_16644# VGND sky130_fd_pr__res_high_po w=0.36 l=7.36
X969 VGND LELO_GR01_0.x8.PWRUP_N_1V8 LELO_GR01_0.x7.x1.x5.x9<2>.G VGND sky130_fd_pr__nfet_01v8_lvt ad=0.5088 pd=2.98 as=0.3168 ps=1.62 w=0.96 l=0.94
X970 VDPWR VGND VDPWR VDPWR sky130_fd_pr__pfet_01v8_hvt ad=0.2262 pd=2.26 as=0 ps=0 w=0.87 l=0.59
X971 a_9548_8824# a_9764_6904# VGND sky130_fd_pr__res_high_po w=0.36 l=7.36
X972 VGND digital_0._113_.Q a_6631_1842# VGND sky130_fd_pr__nfet_01v8 ad=0.17875 pd=1.85 as=0.08775 ps=0.92 w=0.65 l=0.15
X973 a_12603_2956# a_12367_2956# VDPWR VDPWR sky130_fd_pr__pfet_01v8_hvt ad=0.1092 pd=1.36 as=0.0567 ps=0.69 w=0.42 l=0.5
X974 VDPWR LELO_GR01_0.PWRUP_1V8 LELO_GR01_0.x8.x1.x7.D VDPWR sky130_fd_pr__pfet_01v8_lvt ad=0.5088 pd=2.98 as=0.3168 ps=1.62 w=0.96 l=0.94
X975 VGND VDPWR VGND VGND sky130_fd_pr__nfet_01v8 ad=0.143 pd=1.62 as=0 ps=0 w=0.55 l=0.59
X976 a_13901_2930# a_13706_3072# a_14211_3322# VGND sky130_fd_pr__special_nfet_01v8 ad=0.0594 pd=0.69 as=0.1401 ps=1.1 w=0.36 l=0.15
X977 a_10944_4840# a_11261_4730# a_11219_4588# VGND sky130_fd_pr__special_nfet_01v8 ad=0.0711 pd=0.755 as=0.0669 ps=0.75 w=0.36 l=0.15
X978 a_7793_4382# digital_0._110_.Q VGND VGND sky130_fd_pr__nfet_01v8 ad=0.0567 pd=0.69 as=0.1118 ps=1.04 w=0.42 l=0.15
X979 JNWTR_ORX1_CV_0.XA1.MP1.S JNWTR_ORX1_CV_0.A VDPWR VDPWR sky130_fd_pr__pfet_01v8 ad=0.288 pd=1.54 as=0.468 ps=2.84 w=0.9 l=0.16
X980 VDPWR a_6343_2930# digital_0.clkload0.A VDPWR sky130_fd_pr__pfet_01v8_hvt ad=0.14 pd=1.28 as=0.14 ps=1.28 w=1 l=0.15
X981 digital_0.load_slew15.X a_10861_3474# VGND VGND sky130_fd_pr__nfet_01v8 ad=0.08775 pd=0.92 as=0.169 ps=1.82 w=0.65 l=0.15
X982 a_13189_3750# digital_0._116_.Q VDPWR VDPWR sky130_fd_pr__pfet_01v8_hvt ad=0.28 pd=2.56 as=0.135 ps=1.27 w=1 l=0.15
X983 JNWTR_IVX1_CV_0.Y rst_n VGND VGND sky130_fd_pr__nfet_01v8 ad=0.468 pd=2.84 as=0.468 ps=2.84 w=0.9 l=0.16
X984 a_14453_4018# a_14297_4286# a_14598_4044# VDPWR sky130_fd_pr__pfet_01v8_hvt ad=0.07245 pd=0.765 as=0.1155 ps=0.97 w=0.42 l=0.15
X985 VGND VDPWR VGND VGND sky130_fd_pr__nfet_01v8 ad=0.143 pd=1.62 as=0 ps=0 w=0.55 l=0.59
X986 digital_0.load_slew15.X a_10861_3474# VGND VGND sky130_fd_pr__nfet_01v8 ad=0.08775 pd=0.92 as=0.08775 ps=0.92 w=0.65 l=0.15
X987 a_23562_18564# a_23778_16644# VGND sky130_fd_pr__res_high_po w=0.36 l=7.36
X988 a_13428_3088# a_13745_3198# a_13703_3322# VGND sky130_fd_pr__special_nfet_01v8 ad=0.0711 pd=0.755 as=0.0669 ps=0.75 w=0.36 l=0.15
X989 a_18168_18564# a_18384_16644# VGND sky130_fd_pr__res_high_po w=0.36 l=7.36
X990 a_13942_1324# a_13725_1324# VGND VGND sky130_fd_pr__nfet_01v8 ad=0.17225 pd=1.83 as=0.1228 ps=1.065 w=0.65 l=0.25
X991 digital_0._115_.D a_11234_3276# a_11592_2956# VDPWR sky130_fd_pr__pfet_01v8_hvt ad=0.135 pd=1.27 as=0.26 ps=2.52 w=1 l=0.15
X992 VGND VDPWR VGND VGND sky130_fd_pr__nfet_01v8 ad=0.143 pd=1.62 as=0 ps=0 w=0.55 l=0.59
X993 VGND a_4341_4052# digital_0.load_slew17.X VGND sky130_fd_pr__nfet_01v8 ad=0.17225 pd=1.83 as=0.08775 ps=0.92 w=0.65 l=0.15
X994 VGND a_11261_4730# a_11222_4856# VGND sky130_fd_pr__nfet_01v8 ad=0.0567 pd=0.69 as=0.1092 ps=1.36 w=0.42 l=0.15
X995 a_4320_5264# a_4598_5248# a_4554_5132# VDPWR sky130_fd_pr__pfet_01v8_hvt ad=0.0588 pd=0.7 as=0.0567 ps=0.69 w=0.42 l=0.15
X996 a_9508_2778# a_9421_2554# a_9104_2664# VDPWR sky130_fd_pr__pfet_01v8_hvt ad=0.12915 pd=1.185 as=0.0588 ps=0.7 w=0.42 l=0.15
X997 a_14622_2246# a_13707_1874# a_14275_1842# VGND sky130_fd_pr__special_nfet_01v8 ad=0.0711 pd=0.755 as=0.0999 ps=0.985 w=0.36 l=0.15
X998 VDPWR digital_0.output6.A a_15289_2956# VDPWR sky130_fd_pr__pfet_01v8_hvt ad=0.19265 pd=1.415 as=0.27 ps=2.54 w=1 l=0.15
X999 VGND a_8735_3474# digital_0.clkbuf_1_1__f_clk.A VGND sky130_fd_pr__nfet_01v8 ad=0.0588 pd=0.7 as=0.0588 ps=0.7 w=0.42 l=0.15
X1000 VDPWR digital_0._113_.Q a_7302_1868# VDPWR sky130_fd_pr__pfet_01v8_hvt ad=0.135 pd=1.27 as=0.135 ps=1.27 w=1 l=0.15
X1001 a_14205_3500# a_13951_3827# VGND VGND sky130_fd_pr__nfet_01v8 ad=0.0693 pd=0.75 as=0.1449 ps=1.11 w=0.42 l=0.15
X1002 a_15016_4044# a_14258_4160# a_14453_4018# VDPWR sky130_fd_pr__pfet_01v8_hvt ad=0.0651 pd=0.73 as=0.07245 ps=0.765 w=0.42 l=0.15
X1003 digital_0.clkbuf_1_0__f_clk.X a_11416_3500# VDPWR VDPWR sky130_fd_pr__pfet_01v8_hvt ad=0.14 pd=1.28 as=0.14 ps=1.28 w=1 l=0.15
X1004 a_5842_3866# a_5321_3474# VDPWR VDPWR sky130_fd_pr__pfet_01v8_hvt ad=0.0567 pd=0.69 as=0.0819 ps=0.81 w=0.42 l=0.15
X1005 LELO_GR01_0.x7.x7.S LELO_GR01_0.x7.x6<3>.G LELO_GR01_0.x7.x6<3>.G VGND sky130_fd_pr__nfet_01v8_lvt ad=0.5088 pd=2.98 as=0.3168 ps=1.62 w=0.96 l=0.94
X1006 VGND VDPWR VGND VGND sky130_fd_pr__nfet_01v8 ad=0.143 pd=1.62 as=0 ps=0 w=0.55 l=0.59
X1007 a_7226_1324# a_7009_1324# VGND VGND sky130_fd_pr__nfet_01v8 ad=0.17225 pd=1.83 as=0.1228 ps=1.065 w=0.65 l=0.25
X1008 VGND VDPWR VGND VGND sky130_fd_pr__nfet_01v8 ad=0.143 pd=1.62 as=0 ps=0 w=0.55 l=0.59
X1009 VGND a_6081_3737# a_6012_3866# VGND sky130_fd_pr__nfet_01v8 ad=0.1346 pd=1.15 as=0.0999 ps=0.985 w=0.64 l=0.15
X1010 VGND digital_0._107_.RESET_B a_11927_2234# VGND sky130_fd_pr__nfet_01v8 ad=0.1346 pd=1.15 as=0.0441 ps=0.63 w=0.42 l=0.15
X1011 a_3993_3198# digital_0.clkload0.A VDPWR VDPWR sky130_fd_pr__pfet_01v8_hvt ad=0.1664 pd=1.8 as=0.0864 ps=0.91 w=0.64 l=0.15
X1012 VGND digital_0.input3.X a_3513_3500# VGND sky130_fd_pr__nfet_01v8 ad=0.1228 pd=1.065 as=0.1134 ps=1.38 w=0.42 l=0.15
X1013 digital_0.clkload0.A a_6343_2930# VDPWR VDPWR sky130_fd_pr__pfet_01v8_hvt ad=0.14 pd=1.28 as=0.265 ps=2.53 w=1 l=0.15
X1014 a_13662_2956# a_13141_2930# VDPWR VDPWR sky130_fd_pr__pfet_01v8_hvt ad=0.0567 pd=0.69 as=0.0819 ps=0.81 w=0.42 l=0.15
X1015 VGND a_14981_4562# a_14915_4588# VGND sky130_fd_pr__nfet_01v8 ad=0.12495 pd=1.015 as=0.0669 ps=0.75 w=0.42 l=0.15
X1016 VDPWR VGND VDPWR VDPWR sky130_fd_pr__pfet_01v8_hvt ad=0.2262 pd=2.26 as=0 ps=0 w=0.87 l=0.59
X1017 VGND digital_0.load_slew17.A digital_0._111_.RESET_B VGND sky130_fd_pr__nfet_01v8 ad=0.08775 pd=0.92 as=0.08775 ps=0.92 w=0.65 l=0.15
X1018 LELO_GR01_0.x7.x15.I2 LELO_GR01_0.x7.xd1<4>.A VDPWR VDPWR sky130_fd_pr__pfet_01v8_lvt ad=0.3168 pd=1.62 as=0.5088 ps=2.98 w=0.96 l=0.94
X1019 a_14503_4588# a_14459_4830# a_14337_4588# VGND sky130_fd_pr__nfet_01v8 ad=0.0441 pd=0.63 as=0.1401 ps=1.1 w=0.42 l=0.15
X1020 VDPWR digital_0.hold28.A a_4935_1651# VDPWR sky130_fd_pr__pfet_01v8_hvt ad=0.0693 pd=0.75 as=0.1176 ps=1.4 w=0.42 l=0.15
X1021 VGND a_9862_1690# digital_0._114_.D VGND sky130_fd_pr__nfet_01v8 ad=0.1755 pd=1.84 as=0.08775 ps=0.92 w=0.65 l=0.15
X1022 a_14754_2412# a_14174_2412# VGND VGND sky130_fd_pr__nfet_01v8 ad=0.0441 pd=0.63 as=0.1092 ps=1.36 w=0.42 l=0.15
X1023 digital_0._115_.Q a_10841_2386# VDPWR VDPWR sky130_fd_pr__pfet_01v8_hvt ad=0.135 pd=1.27 as=0.26 ps=2.52 w=1 l=0.15
X1024 a_11532_2778# a_11445_2554# a_11128_2664# VDPWR sky130_fd_pr__pfet_01v8_hvt ad=0.12915 pd=1.185 as=0.0588 ps=0.7 w=0.42 l=0.15
X1025 VDPWR a_6075_1842# digital_0._057_.D VDPWR sky130_fd_pr__pfet_01v8_hvt ad=0.16655 pd=1.39 as=0.195 ps=1.39 w=1 l=0.15
X1026 VDPWR digital_0._116_.Q a_11257_5926# VDPWR sky130_fd_pr__pfet_01v8_hvt ad=0.135 pd=1.27 as=0.135 ps=1.27 w=1 l=0.15
X1027 a_5189_1651# digital_0._113_.Q a_5117_1651# VDPWR sky130_fd_pr__pfet_01v8_hvt ad=0.1932 pd=1.34 as=0.0441 ps=0.63 w=0.42 l=0.15
X1028 a_26374_18564# a_26590_16644# VGND sky130_fd_pr__res_high_po w=0.36 l=7.36
X1029 VGND digital_0.hold28.A a_4935_1651# VGND sky130_fd_pr__nfet_01v8 ad=0.1449 pd=1.11 as=0.1092 ps=1.36 w=0.42 l=0.15
X1030 a_11911_2412# a_11532_2778# a_11839_2412# VGND sky130_fd_pr__nfet_01v8 ad=0.1401 pd=1.1 as=0.0441 ps=0.63 w=0.42 l=0.15
X1031 digital_0._102_.RESET_B digital_0.load_slew17.A VDPWR VDPWR sky130_fd_pr__pfet_01v8_hvt ad=0.135 pd=1.27 as=0.26 ps=2.52 w=1 l=0.15
X1032 a_6372_1298# a_6498_1482# VDPWR VDPWR sky130_fd_pr__pfet_01v8_hvt ad=0.2173 pd=2.17 as=0.2726 ps=1.61 w=0.82 l=0.25
X1033 digital_0._103_.RESET_B digital_0.load_slew17.A VGND VGND sky130_fd_pr__nfet_01v8 ad=0.08775 pd=0.92 as=0.169 ps=1.82 w=0.65 l=0.15
X1034 a_5461_2956# digital_0._063_.A VDPWR VDPWR sky130_fd_pr__pfet_01v8_hvt ad=0.28 pd=2.56 as=0.135 ps=1.27 w=1 l=0.15
X1035 a_5882_8824# a_5666_6904# VGND sky130_fd_pr__res_high_po w=0.36 l=7.36
X1036 a_11403_2412# a_10841_2386# VGND VGND sky130_fd_pr__nfet_01v8 ad=0.0669 pd=0.75 as=0.12495 ps=1.015 w=0.42 l=0.15
X1037 a_5189_1324# a_4935_1651# VGND VGND sky130_fd_pr__nfet_01v8 ad=0.0693 pd=0.75 as=0.1449 ps=1.11 w=0.42 l=0.15
X1038 JNWTR_ORX1_CV_0.A a_15617_1324# VDPWR VDPWR sky130_fd_pr__pfet_01v8_hvt ad=0.495 pd=2.99 as=0.2726 ps=1.61 w=1 l=0.15
X1039 VGND digital_0.load_slew17.A digital_0._104_.RESET_B VGND sky130_fd_pr__nfet_01v8 ad=0.169 pd=1.82 as=0.08775 ps=0.92 w=0.65 l=0.15
X1040 VGND ui_in<1> JNWTR_ORX1_CV_0.XA2.A VGND sky130_fd_pr__nfet_01v8 ad=0.468 pd=2.84 as=0.288 ps=1.54 w=0.9 l=0.16
X1041 VDPWR VGND VDPWR VDPWR sky130_fd_pr__pfet_01v8_hvt ad=0.2262 pd=2.26 as=0 ps=0 w=0.87 l=0.59
X1042 a_11793_5926# digital_0._069_.A VDPWR VDPWR sky130_fd_pr__pfet_01v8_hvt ad=0.135 pd=1.27 as=0.135 ps=1.27 w=1 l=0.15
X1043 a_4637_5374# digital_0.clkload0.A VGND VGND sky130_fd_pr__nfet_01v8 ad=0.1092 pd=1.36 as=0.0567 ps=0.69 w=0.42 l=0.15
X1044 a_6012_3866# a_5886_3768# a_5608_3752# VGND sky130_fd_pr__special_nfet_01v8 ad=0.0999 pd=0.985 as=0.0711 ps=0.755 w=0.36 l=0.15
X1045 VGND a_14770_5676# a_14881_5676# VGND sky130_fd_pr__nfet_01v8 ad=0.1856 pd=1.26 as=0.17225 ps=1.83 w=0.65 l=0.25
X1046 VGND a_15507_3528# digital_0._118_.D VGND sky130_fd_pr__nfet_01v8 ad=0.247 pd=2.06 as=0.12675 ps=1.04 w=0.65 l=0.15
X1047 VGND a_14995_3500# a_15101_3500# VGND sky130_fd_pr__nfet_01v8 ad=0.097 pd=0.975 as=0.1092 ps=1.36 w=0.42 l=0.5
X1048 VDPWR a_8735_3474# digital_0.clkbuf_1_1__f_clk.A VDPWR sky130_fd_pr__pfet_01v8_hvt ad=0.14 pd=1.28 as=0.14 ps=1.28 w=1 l=0.15
X1049 digital_0._113_.RESET_B digital_0.input3.X a_3437_1868# VDPWR sky130_fd_pr__pfet_01v8_hvt ad=0.135 pd=1.27 as=0.26 ps=2.52 w=1 l=0.15
X1050 VDPWR a_4691_5676# a_4797_5676# VDPWR sky130_fd_pr__pfet_01v8_hvt ad=0.14075 pd=1.325 as=0.1092 ps=1.36 w=0.42 l=0.5
X1051 digital_0.hold22.X a_13261_2412# VDPWR VDPWR sky130_fd_pr__pfet_01v8_hvt ad=0.26 pd=2.52 as=0.14075 ps=1.325 w=1 l=0.15
X1052 VDPWR digital_0.clkbuf_1_1__f_clk.A a_11416_3500# VDPWR sky130_fd_pr__pfet_01v8_hvt ad=0.14 pd=1.28 as=0.14 ps=1.28 w=1 l=0.15
X1053 VDPWR digital_0.output10.A a_7009_1324# VDPWR sky130_fd_pr__pfet_01v8_hvt ad=0.19265 pd=1.415 as=0.27 ps=2.54 w=1 l=0.15
X1054 VDPWR a_3679_2412# a_3785_2412# VDPWR sky130_fd_pr__pfet_01v8_hvt ad=0.14075 pd=1.325 as=0.1092 ps=1.36 w=0.42 l=0.5
X1055 a_4565_3827# a_4383_3827# VDPWR VDPWR sky130_fd_pr__pfet_01v8_hvt ad=0.0441 pd=0.63 as=0.0693 ps=0.75 w=0.42 l=0.15
X1056 digital_0.clkbuf_1_1__f_clk.A a_8735_3474# VGND VGND sky130_fd_pr__nfet_01v8 ad=0.0588 pd=0.7 as=0.0588 ps=0.7 w=0.42 l=0.15
X1057 a_5997_4044# digital_0.load_slew17.A digital_0._110_.RESET_B VDPWR sky130_fd_pr__pfet_01v8_hvt ad=0.26 pd=2.52 as=0.135 ps=1.27 w=1 l=0.15
X1058 a_14057_2246# a_13541_1874# a_13962_2234# VGND sky130_fd_pr__special_nfet_01v8 ad=0.0594 pd=0.69 as=0.066 ps=0.745 w=0.36 l=0.15
X1059 VGND digital_0._115_.Q a_11592_3276# VGND sky130_fd_pr__nfet_01v8 ad=0.08775 pd=0.92 as=0.169 ps=1.82 w=0.65 l=0.15
X1060 LELO_GR01_0.x8.x1.x5.x8.S LELO_GR01_0.x8.PWRUP_N_1V8 VDPWR VDPWR sky130_fd_pr__pfet_01v8_lvt ad=0.3168 pd=1.62 as=0.5088 ps=2.98 w=0.96 l=0.94
X1061 VDPWR digital_0._115_.D a_12164_2778# VDPWR sky130_fd_pr__pfet_01v8_hvt ad=0.1092 pd=1.36 as=0.0651 ps=0.73 w=0.42 l=0.15
X1062 VDPWR a_10861_3474# digital_0.load_slew15.X VDPWR sky130_fd_pr__pfet_01v8_hvt ad=0.135 pd=1.27 as=0.135 ps=1.27 w=1 l=0.15
X1063 a_8602_4044# a_8081_4018# VDPWR VDPWR sky130_fd_pr__pfet_01v8_hvt ad=0.0567 pd=0.69 as=0.0819 ps=0.81 w=0.42 l=0.15
X1064 a_6564_4954# a_6438_4856# a_6160_4840# VGND sky130_fd_pr__special_nfet_01v8 ad=0.0999 pd=0.985 as=0.0711 ps=0.755 w=0.36 l=0.15
X1065 a_14660_5132# a_14534_5248# a_14256_5264# VGND sky130_fd_pr__special_nfet_01v8 ad=0.0999 pd=0.985 as=0.0711 ps=0.755 w=0.36 l=0.15
X1066 LELO_GR01_0.x8.x1.x5.x6.N LELO_GR01_0.x8.x1.x5.x8.G LELO_GR01_0.x8.x1.x5.x9<2>.G LELO_GR01_0.x8.x1.x5.x6.N sky130_fd_pr__pfet_01v8_lvt ad=0.5088 pd=2.98 as=0.3168 ps=1.62 w=0.96 l=0.94
X1067 a_8817_2386# a_9104_2664# VDPWR VDPWR sky130_fd_pr__pfet_01v8_hvt ad=0.0567 pd=0.69 as=0.1134 ps=1.38 w=0.42 l=0.15
X1068 VDPWR digital_0._113_.RESET_B a_5321_3474# VDPWR sky130_fd_pr__pfet_01v8_hvt ad=0.0819 pd=0.81 as=0.0567 ps=0.69 w=0.42 l=0.15
X1069 a_15506_5676# a_15289_5676# VGND VGND sky130_fd_pr__nfet_01v8 ad=0.17225 pd=1.83 as=0.1228 ps=1.065 w=0.65 l=0.25
X1070 a_5882_8824# a_6098_6904# VGND sky130_fd_pr__res_high_po w=0.36 l=7.36
X1071 digital_0._114_.Q a_8817_2386# VGND VGND sky130_fd_pr__nfet_01v8 ad=0.08775 pd=0.92 as=0.169 ps=1.82 w=0.65 l=0.15
X1072 VDPWR a_14573_5374# a_14534_5248# VDPWR sky130_fd_pr__pfet_01v8_hvt ad=0.0864 pd=0.91 as=0.1664 ps=1.8 w=0.64 l=0.15
X1073 VGND VDPWR VGND VGND sky130_fd_pr__nfet_01v8 ad=0.143 pd=1.62 as=0 ps=0 w=0.55 l=0.59
X1074 LELO_GR01_0.x7.x18.D LELO_GR01_0.x7.xd1<4>.A VGND VGND sky130_fd_pr__nfet_01v8_lvt ad=0.3168 pd=1.62 as=0.5088 ps=2.98 w=0.96 l=0.94
X1075 VDPWR a_6343_2930# digital_0.clkload0.A VDPWR sky130_fd_pr__pfet_01v8_hvt ad=0.1375 pd=1.275 as=0.14 ps=1.28 w=1 l=0.15
X1076 VDPWR digital_0._118_.RESET_B a_13141_2930# VDPWR sky130_fd_pr__pfet_01v8_hvt ad=0.0819 pd=0.81 as=0.0567 ps=0.69 w=0.42 l=0.15
X1077 VDPWR digital_0._113_.RESET_B a_6226_3866# VDPWR sky130_fd_pr__pfet_01v8_hvt ad=0.07035 pd=0.755 as=0.1092 ps=1.36 w=0.42 l=0.15
X1078 VGND digital_0.load_slew15.X digital_0._101_.RESET_B VGND sky130_fd_pr__nfet_01v8 ad=0.169 pd=1.82 as=0.08775 ps=0.92 w=0.65 l=0.15
X1079 uio_out<1> a_15617_2956# VDPWR VDPWR sky130_fd_pr__pfet_01v8_hvt ad=0.495 pd=2.99 as=0.2726 ps=1.61 w=1 l=0.15
X1080 VGND LELO_GR01_0.x8.PWRUP_N_1V8 LELO_GR01_0.x8.IBP_BG VGND sky130_fd_pr__nfet_01v8_lvt ad=0.5088 pd=2.98 as=0.3168 ps=1.62 w=0.96 l=0.94
X1081 digital_0.clkbuf_1_1__f_clk.A a_8735_3474# VDPWR VDPWR sky130_fd_pr__pfet_01v8_hvt ad=0.14 pd=1.28 as=0.14 ps=1.28 w=1 l=0.15
X1082 VDPWR digital_0.load_slew17.A a_4341_4052# VDPWR sky130_fd_pr__pfet_01v8_hvt ad=0.149 pd=1.325 as=0.1664 ps=1.8 w=0.64 l=0.15
X1083 a_25702_15064# a_25486_13144# VGND sky130_fd_pr__res_high_po w=0.36 l=7.36
X1084 digital_0._113_.Q a_5321_3474# VGND VGND sky130_fd_pr__nfet_01v8 ad=0.08775 pd=0.92 as=0.169 ps=1.82 w=0.65 l=0.15
X1085 a_9548_8824# a_9332_6904# VGND sky130_fd_pr__res_high_po w=0.36 l=7.36
X1086 digital_0._057_.D a_6075_1842# VDPWR VDPWR sky130_fd_pr__pfet_01v8_hvt ad=0.195 pd=1.39 as=0.38 ps=2.76 w=1 l=0.15
X1087 a_10420_1842# a_10546_2106# VDPWR VDPWR sky130_fd_pr__pfet_01v8_hvt ad=0.2173 pd=2.17 as=0.2726 ps=1.61 w=0.82 l=0.25
X1088 VGND a_11209_4018# digital_0._108_.Q VGND sky130_fd_pr__nfet_01v8 ad=0.2087 pd=2.02 as=0.08775 ps=0.92 w=0.65 l=0.15
X1089 VGND VDPWR VGND VGND sky130_fd_pr__nfet_01v8 ad=0.143 pd=1.62 as=0 ps=0 w=0.55 l=0.59
X1090 VDPWR LELO_GR01_0.x7.xd1<4>.A sky130_fd_pr__cap_mim_m3_1 l=5 w=5
X1091 VGND uo_out<0> a_13725_1324# VGND sky130_fd_pr__nfet_01v8 ad=0.1228 pd=1.065 as=0.1134 ps=1.38 w=0.42 l=0.15
X1092 a_3679_2412# a_3443_2412# VDPWR VDPWR sky130_fd_pr__pfet_01v8_hvt ad=0.1092 pd=1.36 as=0.0567 ps=0.69 w=0.42 l=0.5
X1093 VDPWR digital_0._118_.RESET_B a_14046_2956# VDPWR sky130_fd_pr__pfet_01v8_hvt ad=0.07035 pd=0.755 as=0.1092 ps=1.36 w=0.42 l=0.15
X1094 VDPWR LELO_GR01_0.x7.xd1<4>.A sky130_fd_pr__cap_mim_m3_1 l=5 w=5
X1095 a_14453_4018# a_14258_4160# a_14763_4410# VGND sky130_fd_pr__special_nfet_01v8 ad=0.0594 pd=0.69 as=0.1401 ps=1.1 w=0.36 l=0.15
X1096 VGND digital_0.load_slew15.X digital_0._119_.RESET_B VGND sky130_fd_pr__nfet_01v8 ad=0.169 pd=1.82 as=0.08775 ps=0.92 w=0.65 l=0.15
X1097 digital_0._110_.Q a_5873_4562# VGND VGND sky130_fd_pr__nfet_01v8 ad=0.08775 pd=0.92 as=0.169 ps=1.82 w=0.65 l=0.15
X1098 a_14660_5132# a_14573_5374# a_14256_5264# VDPWR sky130_fd_pr__pfet_01v8_hvt ad=0.12915 pd=1.185 as=0.0588 ps=0.7 w=0.42 l=0.15
X1099 a_7288_4404# digital_0._069_.A a_7207_4404# VGND sky130_fd_pr__nfet_01v8 ad=0.0441 pd=0.63 as=0.05355 ps=0.675 w=0.42 l=0.15
X1100 VGND digital_0._116_.SET_B a_14998_2412# VGND sky130_fd_pr__nfet_01v8 ad=0.1137 pd=1.01 as=0.0441 ps=0.63 w=0.42 l=0.15
X1101 digital_0.clkbuf_1_0__f_clk.X a_11416_3500# VGND VGND sky130_fd_pr__nfet_01v8 ad=0.0588 pd=0.7 as=0.0588 ps=0.7 w=0.42 l=0.15
X1102 VGND a_6343_2930# digital_0.clkload0.A VGND sky130_fd_pr__nfet_01v8 ad=0.0588 pd=0.7 as=0.0588 ps=0.7 w=0.42 l=0.15
X1103 digital_0.output10.A a_3941_1842# VDPWR VDPWR sky130_fd_pr__pfet_01v8_hvt ad=0.135 pd=1.27 as=0.26 ps=2.52 w=1 l=0.15
X1104 VDPWR VGND VDPWR VDPWR sky130_fd_pr__pfet_01v8_hvt ad=0.2262 pd=2.26 as=0 ps=0 w=0.87 l=0.59
X1105 a_12069_5132# digital_0.output13.A VDPWR VDPWR sky130_fd_pr__pfet_01v8_hvt ad=0.135 pd=1.27 as=0.135 ps=1.27 w=1 l=0.15
X1106 a_11562_4954# a_11348_4954# VDPWR VDPWR sky130_fd_pr__pfet_01v8_hvt ad=0.1155 pd=0.97 as=0.07035 ps=0.755 w=0.42 l=0.15
X1107 digital_0._118_.D a_15507_3528# VGND VGND sky130_fd_pr__nfet_01v8 ad=0.12675 pd=1.04 as=0.1118 ps=1.04 w=0.65 l=0.15
X1108 digital_0._105_.RESET_B digital_0.load_slew17.X VDPWR VDPWR sky130_fd_pr__pfet_01v8_hvt ad=0.135 pd=1.27 as=0.26 ps=2.52 w=1 l=0.15
X1109 VDPWR digital_0._109_.Q a_13132_4276# VDPWR sky130_fd_pr__pfet_01v8_hvt ad=0.0567 pd=0.69 as=0.07438 ps=0.815 w=0.42 l=0.15
X1110 VGND LELO_GR01_0.x8.PWRUP_N_1V8 LELO_GR01_0.x8.x1.x5.x9<2>.G VGND sky130_fd_pr__nfet_01v8_lvt ad=0.5088 pd=2.98 as=0.3168 ps=1.62 w=0.96 l=0.94
X1111 LELO_GR01_0.x7.xd1<4>.A LELO_GR01_0.PWRUP_1V8 VDPWR VDPWR sky130_fd_pr__pfet_01v8_lvt ad=0.3168 pd=1.62 as=0.5088 ps=2.98 w=0.96 l=0.94
X1112 a_11149_2956# digital_0._060_.A_N a_11234_3276# VDPWR sky130_fd_pr__pfet_01v8_hvt ad=0.26 pd=2.52 as=0.135 ps=1.27 w=1 l=0.15
X1113 VDPWR a_14174_2412# a_14350_2386# VDPWR sky130_fd_pr__pfet_01v8_hvt ad=0.0567 pd=0.69 as=0.0567 ps=0.69 w=0.42 l=0.15
X1114 VGND a_10657_4562# digital_0._109_.Q VGND sky130_fd_pr__nfet_01v8 ad=0.2087 pd=2.02 as=0.08775 ps=0.92 w=0.65 l=0.15
X1115 a_11665_2246# a_11149_1874# a_11570_2234# VGND sky130_fd_pr__special_nfet_01v8 ad=0.0594 pd=0.69 as=0.066 ps=0.745 w=0.36 l=0.15
X1116 LELO_GR01_0.PWRUP_1V8 JNWTR_ORX1_CV_0.XA2.A VDPWR VDPWR sky130_fd_pr__pfet_01v8 ad=0.468 pd=2.84 as=0.468 ps=2.84 w=0.9 l=0.16
X1117 a_19032_18564# a_18816_16644# VGND sky130_fd_pr__res_high_po w=0.36 l=7.36
X1118 VDPWR a_10628_6904# VGND sky130_fd_pr__res_high_po w=0.36 l=7.36
X1119 digital_0.clkload0.A a_6343_2930# VDPWR VDPWR sky130_fd_pr__pfet_01v8_hvt ad=0.14 pd=1.28 as=0.14 ps=1.28 w=1 l=0.15
X1120 VGND digital_0._063_.A a_6631_1842# VGND sky130_fd_pr__nfet_01v8 ad=0.08775 pd=0.92 as=0.08775 ps=0.92 w=0.65 l=0.15
X1121 a_22470_15064# a_22686_13144# VGND sky130_fd_pr__res_high_po w=0.36 l=7.36
X1122 VGND VDPWR VGND VGND sky130_fd_pr__nfet_01v8 ad=0.143 pd=1.62 as=0 ps=0 w=0.55 l=0.59
X1123 VDPWR digital_0._111_.RESET_B a_8081_4018# VDPWR sky130_fd_pr__pfet_01v8_hvt ad=0.0819 pd=0.81 as=0.0567 ps=0.69 w=0.42 l=0.15
X1124 VDPWR digital_0.hold19.X a_15292_5132# VDPWR sky130_fd_pr__pfet_01v8_hvt ad=0.1092 pd=1.36 as=0.0651 ps=0.73 w=0.42 l=0.15
X1125 a_8685_4286# digital_0.input1.X VDPWR VDPWR sky130_fd_pr__pfet_01v8_hvt ad=0.1664 pd=1.8 as=0.0864 ps=0.91 w=0.64 l=0.15
X1126 a_4691_5676# a_4455_5676# VGND VGND sky130_fd_pr__nfet_01v8 ad=0.1092 pd=1.36 as=0.0567 ps=0.69 w=0.42 l=0.5
X1127 VDPWR digital_0._104_.D a_4712_2956# VDPWR sky130_fd_pr__pfet_01v8_hvt ad=0.1092 pd=1.36 as=0.0651 ps=0.73 w=0.42 l=0.15
X1128 uio_out<5> a_7337_1324# VDPWR VDPWR sky130_fd_pr__pfet_01v8_hvt ad=0.495 pd=2.99 as=0.2726 ps=1.61 w=1 l=0.15
R2 uio_oe<3> JNWTR_TIEH_CV_0.Y sky130_fd_pr__res_generic_m4 w=0.3 l=0.3
X1129 a_14057_2246# a_13707_1874# a_13962_2234# VDPWR sky130_fd_pr__pfet_01v8_hvt ad=0.07245 pd=0.765 as=0.0651 ps=0.73 w=0.42 l=0.15
X1130 a_6319_2412# digital_0._112_.RESET_B VGND VGND sky130_fd_pr__nfet_01v8 ad=0.0441 pd=0.63 as=0.1346 ps=1.15 w=0.42 l=0.15
X1131 a_8289_5106# a_8133_5374# a_8434_5132# VDPWR sky130_fd_pr__pfet_01v8_hvt ad=0.07245 pd=0.765 as=0.1155 ps=0.97 w=0.42 l=0.15
X1132 VGND digital_0._113_.Q a_6851_2188# VGND sky130_fd_pr__nfet_01v8 ad=0.08775 pd=0.92 as=0.08775 ps=0.92 w=0.65 l=0.15
X1133 VDPWR a_6081_2649# a_6012_2778# VDPWR sky130_fd_pr__pfet_01v8_hvt ad=0.2184 pd=2.2 as=0.12915 ps=1.185 w=0.84 l=0.15
X1134 VDPWR a_8735_3474# digital_0.clkbuf_1_1__f_clk.A VDPWR sky130_fd_pr__pfet_01v8_hvt ad=0.14 pd=1.28 as=0.14 ps=1.28 w=1 l=0.15
X1135 a_13703_3322# a_13141_2930# VGND VGND sky130_fd_pr__nfet_01v8 ad=0.0669 pd=0.75 as=0.12495 ps=1.015 w=0.42 l=0.15
X1136 VGND digital_0.hold28.A a_12847_4915# VGND sky130_fd_pr__nfet_01v8 ad=0.1449 pd=1.11 as=0.1092 ps=1.36 w=0.42 l=0.15
X1137 digital_0._108_.D digital_0._108_.Q a_12512_5452# VGND sky130_fd_pr__nfet_01v8 ad=0.10563 pd=0.975 as=0.08775 ps=0.92 w=0.65 l=0.15
X1138 VDPWR digital_0.clkbuf_1_0__f_clk.X a_13725_4588# VDPWR sky130_fd_pr__pfet_01v8_hvt ad=0.0864 pd=0.91 as=0.1664 ps=1.8 w=0.64 l=0.15
X1139 a_13969_5106# a_14256_5264# VDPWR VDPWR sky130_fd_pr__pfet_01v8_hvt ad=0.0567 pd=0.69 as=0.1134 ps=1.38 w=0.42 l=0.15
X1140 VGND digital_0._117_.RESET_B a_14291_5498# VGND sky130_fd_pr__nfet_01v8 ad=0.12495 pd=1.015 as=0.06405 ps=0.725 w=0.42 l=0.15
X1141 VDPWR VGND VDPWR VDPWR sky130_fd_pr__pfet_01v8_hvt ad=0.2262 pd=2.26 as=0 ps=0 w=0.87 l=0.59
X1142 a_3389_2930# a_3676_3088# VDPWR VDPWR sky130_fd_pr__pfet_01v8_hvt ad=0.0567 pd=0.69 as=0.1134 ps=1.38 w=0.42 l=0.15
X1143 a_14691_4410# digital_0._101_.RESET_B VGND VGND sky130_fd_pr__nfet_01v8 ad=0.0441 pd=0.63 as=0.1346 ps=1.15 w=0.42 l=0.15
X1144 a_10786_1842# ui_in<0> VDPWR VDPWR sky130_fd_pr__pfet_01v8_hvt ad=0.27 pd=2.54 as=0.19265 ps=1.415 w=1 l=0.15
X1145 a_8555_3276# digital_0._112_.Q a_8471_3276# VGND sky130_fd_pr__nfet_01v8 ad=0.13975 pd=1.08 as=0.08775 ps=0.92 w=0.65 l=0.15
X1146 VDPWR digital_0.load_slew17.A digital_0._103_.RESET_B VDPWR sky130_fd_pr__pfet_01v8_hvt ad=0.26 pd=2.52 as=0.135 ps=1.27 w=1 l=0.15
X1147 a_5450_8824# a_5666_6904# VGND sky130_fd_pr__res_high_po w=0.36 l=7.36
X1148 a_8552_20000# a_10472_19784# VGND sky130_fd_pr__res_high_po w=0.36 l=7.36
X1149 a_6631_1842# digital_0._063_.A a_7302_1868# VDPWR sky130_fd_pr__pfet_01v8_hvt ad=0.135 pd=1.27 as=0.26 ps=2.52 w=1 l=0.15
X1150 a_11592_2956# digital_0._060_.A_N VDPWR VDPWR sky130_fd_pr__pfet_01v8_hvt ad=0.26 pd=2.52 as=0.1625 ps=1.325 w=1 l=0.15
X1151 VGND VDPWR VGND VGND sky130_fd_pr__nfet_01v8 ad=0.143 pd=1.62 as=0 ps=0 w=0.55 l=0.59
X1152 a_6343_2930# digital_0.clkbuf_1_1__f_clk.A VGND VGND sky130_fd_pr__nfet_01v8 ad=0.0588 pd=0.7 as=0.0588 ps=0.7 w=0.42 l=0.15
X1153 a_14165_1868# a_13541_1874# a_14057_2246# VDPWR sky130_fd_pr__pfet_01v8_hvt ad=0.1155 pd=0.97 as=0.07245 ps=0.765 w=0.42 l=0.15
X1154 a_7196_4954# a_6477_4730# a_6633_4825# VGND sky130_fd_pr__special_nfet_01v8 ad=0.066 pd=0.745 as=0.0594 ps=0.69 w=0.36 l=0.15
X1155 VDPWR digital_0._117_.RESET_B a_14874_5132# VDPWR sky130_fd_pr__pfet_01v8_hvt ad=0.07035 pd=0.755 as=0.1092 ps=1.36 w=0.42 l=0.15
X1156 VGND VGND LELO_GR01_0.x7.x15.I2 sky130_fd_pr__pnp_05v5_W3p40L3p40
**devattr s=462400,2720
X1157 a_14806_4588# a_13725_4588# a_14459_4830# VDPWR sky130_fd_pr__pfet_01v8_hvt ad=0.0588 pd=0.7 as=0.12915 ps=1.185 w=0.42 l=0.15
X1158 a_8852_5132# a_8094_5248# a_8289_5106# VDPWR sky130_fd_pr__pfet_01v8_hvt ad=0.0651 pd=0.73 as=0.07245 ps=0.765 w=0.42 l=0.15
X1159 a_11445_2554# digital_0.input1.X VDPWR VDPWR sky130_fd_pr__pfet_01v8_hvt ad=0.1664 pd=1.8 as=0.0864 ps=0.91 w=0.64 l=0.15
X1160 a_4374_2412# a_4157_2412# VGND VGND sky130_fd_pr__nfet_01v8 ad=0.17225 pd=1.83 as=0.1228 ps=1.065 w=0.65 l=0.25
X1161 a_14260_2778# a_13725_2412# a_14174_2412# VDPWR sky130_fd_pr__pfet_01v8_hvt ad=0.0945 pd=0.87 as=0.0567 ps=0.69 w=0.42 l=0.15
X1162 LELO_GR01_0.x7.x1.x5.x8.G LELO_GR01_0.x7.x1.x5.x8.G LELO_GR01_0.x7.x1.x5.x8.S LELO_GR01_0.x7.x1.x5.x8.S sky130_fd_pr__pfet_01v8_lvt ad=0.3168 pd=1.62 as=0.5088 ps=2.98 w=0.96 l=0.94
X1163 VGND ui_in<1> sky130_fd_pr__diode_pw2nd_05v5 perim=1.8e+06 area=2.025e+11
X1164 VGND a_11445_2554# a_11406_2680# VGND sky130_fd_pr__nfet_01v8 ad=0.0567 pd=0.69 as=0.1092 ps=1.36 w=0.42 l=0.15
X1165 LELO_GR01_0.x8.x7.D LELO_GR01_0.x8.PWRUP_N_1V8 VGND VGND sky130_fd_pr__nfet_01v8_lvt ad=0.3168 pd=1.62 as=0.5088 ps=2.98 w=0.96 l=0.94
X1166 VDPWR a_5321_3474# digital_0._113_.Q VDPWR sky130_fd_pr__pfet_01v8_hvt ad=0.3012 pd=2.66 as=0.135 ps=1.27 w=1 l=0.15
X1167 digital_0.clkbuf_1_1__f_clk.A a_8735_3474# VDPWR VDPWR sky130_fd_pr__pfet_01v8_hvt ad=0.14 pd=1.28 as=0.14 ps=1.28 w=1 l=0.15
X1168 digital_0._111_.D a_8739_4910# VDPWR VDPWR sky130_fd_pr__pfet_01v8_hvt ad=0.135 pd=1.27 as=0.154 ps=1.335 w=1 l=0.15
X1169 VGND digital_0._115_.D a_12164_2778# VGND sky130_fd_pr__nfet_01v8 ad=0.2205 pd=1.89 as=0.066 ps=0.745 w=0.42 l=0.15
X1170 VGND digital_0._116_.Q digital_0._112_.RESET_B VGND sky130_fd_pr__nfet_01v8 ad=0.182 pd=1.86 as=0.08775 ps=0.92 w=0.65 l=0.15
X1171 a_4701_1842# a_4545_2110# a_4846_1868# VDPWR sky130_fd_pr__pfet_01v8_hvt ad=0.07245 pd=0.765 as=0.1155 ps=0.97 w=0.42 l=0.15
X1172 LELO_GR01_0.x8.x5.CK LELO_GR01_0.x8.x3.A VGND VGND sky130_fd_pr__nfet_01v8 ad=0.468 pd=2.84 as=0.468 ps=2.84 w=0.9 l=0.16
X1173 a_12323_1476# a_12419_1298# VDPWR VDPWR sky130_fd_pr__pfet_01v8_hvt ad=0.1092 pd=1.36 as=0.14075 ps=1.325 w=0.42 l=0.5
X1174 a_8527_5498# digital_0._103_.RESET_B VGND VGND sky130_fd_pr__nfet_01v8 ad=0.0441 pd=0.63 as=0.1346 ps=1.15 w=0.42 l=0.15
X1175 VGND digital_0._110_.D a_7196_4954# VGND sky130_fd_pr__nfet_01v8 ad=0.2205 pd=1.89 as=0.066 ps=0.745 w=0.42 l=0.15
X1176 LELO_GR01_0.x7.x30.N LELO_GR01_0.x8.PWRUP_N_1V8 LELO_GR01_0.x7.x25.D VDPWR sky130_fd_pr__pfet_01v8_lvt ad=0.5088 pd=2.98 as=0.3168 ps=1.62 w=0.96 l=0.94
X1177 VGND a_5321_2386# digital_0._112_.Q VGND sky130_fd_pr__nfet_01v8 ad=0.2087 pd=2.02 as=0.08775 ps=0.92 w=0.65 l=0.15
X1178 VDPWR digital_0._102_.D a_5356_5132# VDPWR sky130_fd_pr__pfet_01v8_hvt ad=0.1092 pd=1.36 as=0.0651 ps=0.73 w=0.42 l=0.15
X1179 a_16872_18564# a_17088_16644# VGND sky130_fd_pr__res_high_po w=0.36 l=7.36
X1180 a_9677_1690# digital_0._060_.A_N VGND VGND sky130_fd_pr__nfet_01v8 ad=0.1092 pd=1.36 as=0.1092 ps=1.36 w=0.42 l=0.15
X1181 LELO_GR01_0.x7.x26.P a_27854_13144# VGND sky130_fd_pr__res_high_po w=0.36 l=7.36
X1182 a_5461_2956# digital_0._063_.B digital_0._112_.D VDPWR sky130_fd_pr__pfet_01v8_hvt ad=0.135 pd=1.27 as=0.135 ps=1.27 w=1 l=0.15
X1183 VDPWR digital_0._113_.Q a_8389_2956# VDPWR sky130_fd_pr__pfet_01v8_hvt ad=0.135 pd=1.27 as=0.26 ps=2.52 w=1 l=0.15
X1184 VGND digital_0._069_.A a_9017_4588# VGND sky130_fd_pr__nfet_01v8 ad=0.09862 pd=0.98 as=0.06615 ps=0.735 w=0.42 l=0.15
X1185 VDPWR a_3702_4018# a_3462_4282# VDPWR sky130_fd_pr__pfet_01v8_hvt ad=0.19265 pd=1.415 as=0.2173 ps=2.17 w=0.82 l=0.25
X1186 a_11665_2246# a_11315_1874# a_11570_2234# VDPWR sky130_fd_pr__pfet_01v8_hvt ad=0.07245 pd=0.765 as=0.0651 ps=0.73 w=0.42 l=0.15
X1187 LELO_GR01_0.x7.x1.x7.D LELO_GR01_0.PWRUP_1V8 VDPWR VDPWR sky130_fd_pr__pfet_01v8_lvt ad=0.3168 pd=1.62 as=0.5088 ps=2.98 w=0.96 l=0.94
X1188 VGND a_12154_5452# digital_0._108_.D VGND sky130_fd_pr__nfet_01v8 ad=0.169 pd=1.82 as=0.08775 ps=0.92 w=0.65 l=0.15
X1189 digital_0.output4.A a_14797_2172# VGND VGND sky130_fd_pr__nfet_01v8 ad=0.08775 pd=0.92 as=0.2087 ps=2.02 w=0.65 l=0.15
X1190 a_13891_2412# a_13725_2412# VDPWR VDPWR sky130_fd_pr__pfet_01v8_hvt ad=0.1664 pd=1.8 as=0.0864 ps=0.91 w=0.64 l=0.15
X1191 digital_0.load_slew17.A a_3841_3500# VDPWR VDPWR sky130_fd_pr__pfet_01v8_hvt ad=0.495 pd=2.99 as=0.2726 ps=1.61 w=1 l=0.15
X1192 a_14976_2234# digital_0._119_.RESET_B VGND VGND sky130_fd_pr__nfet_01v8 ad=0.06405 pd=0.725 as=0.12495 ps=1.015 w=0.42 l=0.15
X1193 a_6321_2206# digital_0._113_.Q VGND VGND sky130_fd_pr__nfet_01v8 ad=0.0567 pd=0.69 as=0.1118 ps=1.04 w=0.42 l=0.15
X1194 a_8252_8824# a_8036_6904# VGND sky130_fd_pr__res_high_po w=0.36 l=7.36
X1195 VDPWR a_4374_2412# a_4485_2412# VDPWR sky130_fd_pr__pfet_01v8_hvt ad=0.2726 pd=1.61 as=0.2173 ps=2.17 w=0.82 l=0.25
X1196 a_5264_1868# a_4506_1984# a_4701_1842# VDPWR sky130_fd_pr__pfet_01v8_hvt ad=0.0651 pd=0.73 as=0.07245 ps=0.765 w=0.42 l=0.15
X1197 a_5643_3500# a_5608_3752# a_5321_3474# VGND sky130_fd_pr__nfet_01v8 ad=0.06405 pd=0.725 as=0.1092 ps=1.36 w=0.42 l=0.15
X1198 a_9650_13154# a_9866_11234# VGND sky130_fd_pr__res_high_po w=0.36 l=7.36
X1199 LELO_GR01_0.x8.x1.x5.x8.S a_22292_11915# VGND sky130_fd_pr__res_high_po w=0.36 l=7.36
X1200 a_5873_4562# a_6160_4840# VDPWR VDPWR sky130_fd_pr__pfet_01v8_hvt ad=0.0567 pd=0.69 as=0.1134 ps=1.38 w=0.42 l=0.15
X1201 VGND a_11969_4018# a_11900_4044# VGND sky130_fd_pr__nfet_01v8 ad=0.1346 pd=1.15 as=0.0999 ps=0.985 w=0.64 l=0.15
X1202 VDPWR JNWTR_IVX1_CV_0.Y a_4157_2412# VDPWR sky130_fd_pr__pfet_01v8_hvt ad=0.19265 pd=1.415 as=0.27 ps=2.54 w=1 l=0.15
X1203 VGND digital_0.load_slew17.X digital_0._115_.RESET_B VGND sky130_fd_pr__nfet_01v8 ad=0.08775 pd=0.92 as=0.08775 ps=0.92 w=0.65 l=0.15
X1204 VGND digital_0._102_.RESET_B a_4355_5498# VGND sky130_fd_pr__nfet_01v8 ad=0.12495 pd=1.015 as=0.06405 ps=0.725 w=0.42 l=0.15
X1205 a_5997_4044# digital_0._116_.Q VDPWR VDPWR sky130_fd_pr__pfet_01v8_hvt ad=0.135 pd=1.27 as=0.135 ps=1.27 w=1 l=0.15
X1206 a_11813_4286# digital_0.input1.X VGND VGND sky130_fd_pr__nfet_01v8 ad=0.1092 pd=1.36 as=0.0567 ps=0.69 w=0.42 l=0.15
X1207 VDPWR a_11969_4018# a_11900_4044# VDPWR sky130_fd_pr__pfet_01v8_hvt ad=0.2184 pd=2.2 as=0.12915 ps=1.185 w=0.84 l=0.15
X1208 a_13101_4915# digital_0.hold25.X a_13101_4588# VGND sky130_fd_pr__nfet_01v8 ad=0.09975 pd=0.895 as=0.0693 ps=0.75 w=0.42 l=0.15
X1209 VGND digital_0._065_.A2_N a_7825_3500# VGND sky130_fd_pr__nfet_01v8 ad=0.18525 pd=1.87 as=0.08937 ps=0.925 w=0.65 l=0.15
X1210 digital_0._080_.A2 digital_0.input2.X VDPWR VDPWR sky130_fd_pr__pfet_01v8_hvt ad=0.135 pd=1.27 as=0.26 ps=2.52 w=1 l=0.15
X1211 LELO_GR01_0.x7.x6<3>.G LELO_GR01_0.x7.x6<3>.G LELO_GR01_0.x7.x7.S VGND sky130_fd_pr__nfet_01v8_lvt ad=0.3168 pd=1.62 as=0.5088 ps=2.98 w=0.96 l=0.94
X1212 a_7745_2412# digital_0._112_.Q VDPWR VDPWR sky130_fd_pr__pfet_01v8_hvt ad=0.07455 pd=0.775 as=0.1092 ps=1.36 w=0.42 l=0.15
X1213 VGND a_11416_3500# digital_0.clkbuf_1_0__f_clk.X VGND sky130_fd_pr__nfet_01v8 ad=0.1113 pd=1.37 as=0.0588 ps=0.7 w=0.42 l=0.15
X1214 a_11773_1868# a_11149_1874# a_11665_2246# VDPWR sky130_fd_pr__pfet_01v8_hvt ad=0.1155 pd=0.97 as=0.07245 ps=0.765 w=0.42 l=0.15
X1215 VGND digital_0.load_slew17.X a_9217_2956# VGND sky130_fd_pr__nfet_01v8 ad=0.1228 pd=1.065 as=0.1134 ps=1.38 w=0.42 l=0.15
X1216 VDPWR digital_0._110_.RESET_B a_6778_4954# VDPWR sky130_fd_pr__pfet_01v8_hvt ad=0.07035 pd=0.755 as=0.1092 ps=1.36 w=0.42 l=0.15
X1217 VGND a_14350_2386# a_14284_2412# VGND sky130_fd_pr__nfet_01v8 ad=0.0882 pd=0.84 as=0.06705 ps=0.75 w=0.42 l=0.15
X1218 VGND digital_0.load_slew15.X digital_0._107_.RESET_B VGND sky130_fd_pr__nfet_01v8 ad=0.169 pd=1.82 as=0.08775 ps=0.92 w=0.65 l=0.15
X1219 VDPWR digital_0._109_.RESET_B a_10657_4562# VDPWR sky130_fd_pr__pfet_01v8_hvt ad=0.0819 pd=0.81 as=0.0567 ps=0.69 w=0.42 l=0.15
X1220 VGND VGND VGND VGND sky130_fd_pr__nfet_01v8 ad=0.468 pd=2.84 as=0 ps=0 w=0.9 l=0.16
X1221 LELO_GR01_0.x7.x1.x5.x9<2>.G LELO_GR01_0.x7.x1.x5.x9<2>.G VGND VGND sky130_fd_pr__nfet_01v8_lvt ad=0.3168 pd=1.62 as=0.5088 ps=2.98 w=0.96 l=0.94
X1222 LELO_GR01_0.x8.x5.XA7.C LELO_GR01_0.x8.x5.CK LELO_GR01_0.x8.x8.D LELO_GR01_0.x8.x8.D sky130_fd_pr__pfet_01v8 ad=0.288 pd=1.54 as=0.468 ps=2.84 w=0.9 l=0.16
X1223 digital_0.output8.A a_7529_5106# VDPWR VDPWR sky130_fd_pr__pfet_01v8_hvt ad=0.135 pd=1.27 as=0.26 ps=2.52 w=1 l=0.15
X1224 VDPWR digital_0.output6.A a_12919_2412# VDPWR sky130_fd_pr__pfet_01v8_hvt ad=0.0567 pd=0.69 as=0.1092 ps=1.36 w=0.42 l=0.15
X1225 digital_0._113_.D digital_0._063_.A a_6851_2188# VGND sky130_fd_pr__nfet_01v8 ad=0.10563 pd=0.975 as=0.169 ps=1.82 w=0.65 l=0.15
X1226 LELO_GR01_0.x7.x11.N a_25294_16644# VGND sky130_fd_pr__res_high_po w=0.36 l=7.36
X1227 a_8081_1842# a_8368_2000# VDPWR VDPWR sky130_fd_pr__pfet_01v8_hvt ad=0.0567 pd=0.69 as=0.1134 ps=1.38 w=0.42 l=0.15
X1228 a_12230_2246# a_11315_1874# a_11883_1842# VGND sky130_fd_pr__special_nfet_01v8 ad=0.0711 pd=0.755 as=0.0999 ps=0.985 w=0.36 l=0.15
X1229 VGND a_11416_3500# digital_0.clkbuf_1_0__f_clk.X VGND sky130_fd_pr__nfet_01v8 ad=0.0588 pd=0.7 as=0.0588 ps=0.7 w=0.42 l=0.15
X1230 LELO_GR01_0.x7.x29.P a_20744_13144# VGND sky130_fd_pr__res_high_po w=0.36 l=7.36
X1231 VDPWR a_8685_2110# a_8646_1984# VDPWR sky130_fd_pr__pfet_01v8_hvt ad=0.0864 pd=0.91 as=0.1664 ps=1.8 w=0.64 l=0.15
X1232 a_21834_18564# a_21618_16644# VGND sky130_fd_pr__res_high_po w=0.36 l=7.36
X1233 a_14384_4044# a_14258_4160# a_13980_4176# VGND sky130_fd_pr__special_nfet_01v8 ad=0.0999 pd=0.985 as=0.0711 ps=0.755 w=0.36 l=0.15
X1234 VGND digital_0._111_.D a_9404_4044# VGND sky130_fd_pr__nfet_01v8 ad=0.2205 pd=1.89 as=0.066 ps=0.745 w=0.42 l=0.15
X1235 a_16440_18564# a_16224_16644# VGND sky130_fd_pr__res_high_po w=0.36 l=7.36
X1236 LELO_GR01_0.x7.x22.D LELO_GR01_0.x8.PWRUP_N_1V8 LELO_GR01_0.x7.x21.D VDPWR sky130_fd_pr__pfet_01v8_lvt ad=0.5088 pd=2.98 as=0.3168 ps=1.62 w=0.96 l=0.94
X1237 a_10412_8824# a_10628_6904# VGND sky130_fd_pr__res_high_po w=0.36 l=7.36
X1238 LELO_GR01_0.x8.x5.XA6.MP1.S LELO_GR01_0.x8.x5.XA6.A LELO_GR01_0.x8.x8.D LELO_GR01_0.x8.x8.D sky130_fd_pr__pfet_01v8 ad=0.288 pd=1.54 as=0.468 ps=2.84 w=0.9 l=0.16
X1239 VGND digital_0.output13.A a_14759_3500# VGND sky130_fd_pr__nfet_01v8 ad=0.0567 pd=0.69 as=0.1092 ps=1.36 w=0.42 l=0.15
X1240 VDPWR a_8735_3474# digital_0.clkbuf_1_1__f_clk.A VDPWR sky130_fd_pr__pfet_01v8_hvt ad=0.14 pd=1.28 as=0.14 ps=1.28 w=1 l=0.15
X1241 VDPWR clk a_8735_3474# VDPWR sky130_fd_pr__pfet_01v8_hvt ad=0.265 pd=2.53 as=0.14 ps=1.28 w=1 l=0.15
X1242 LELO_GR01_0.x7.x19.D LELO_GR01_0.x8.PWRUP_N_1V8 LELO_GR01_0.x7.x20.D VDPWR sky130_fd_pr__pfet_01v8_lvt ad=0.3168 pd=1.62 as=0.5088 ps=2.98 w=0.96 l=0.94
X1243 VGND a_9434_2956# a_9545_2956# VGND sky130_fd_pr__nfet_01v8 ad=0.1856 pd=1.26 as=0.17225 ps=1.83 w=0.65 l=0.25
X1244 LELO_GR01_0.x7.x6<3>.G LELO_GR01_0.x7.x6<3>.G LELO_GR01_0.x7.x7.S VGND sky130_fd_pr__nfet_01v8_lvt ad=0.3168 pd=1.62 as=0.5088 ps=2.98 w=0.96 l=0.94
X1245 a_23334_15064# a_23118_13144# VGND sky130_fd_pr__res_high_po w=0.36 l=7.36
X1246 digital_0.output12.A a_12405_2172# VGND VGND sky130_fd_pr__nfet_01v8 ad=0.08775 pd=0.92 as=0.2087 ps=2.02 w=0.65 l=0.15
X1247 a_8289_5106# a_8094_5248# a_8599_5498# VGND sky130_fd_pr__special_nfet_01v8 ad=0.0594 pd=0.69 as=0.1401 ps=1.1 w=0.36 l=0.15
X1248 LELO_GR01_0.x7.x1.x5.IBN LELO_GR01_0.x7.x1.x5.x9<2>.G VGND VGND sky130_fd_pr__nfet_01v8_lvt ad=0.3168 pd=1.62 as=0.5088 ps=2.98 w=0.96 l=0.94
X1249 VDPWR LELO_GR01_0.x7.xd1<4>.A LELO_GR01_0.x7.x15.I2 VDPWR sky130_fd_pr__pfet_01v8_lvt ad=0.5088 pd=2.98 as=0.3168 ps=1.62 w=0.96 l=0.94
X1250 VGND digital_0.load_slew17.A digital_0._102_.RESET_B VGND sky130_fd_pr__nfet_01v8 ad=0.169 pd=1.82 as=0.08775 ps=0.92 w=0.65 l=0.15
X1251 digital_0._103_.D a_7949_6003# VDPWR VDPWR sky130_fd_pr__pfet_01v8_hvt ad=0.26 pd=2.52 as=0.15835 ps=1.395 w=1 l=0.15
X1252 a_4858_3500# digital_0._112_.Q a_4637_3827# VGND sky130_fd_pr__nfet_01v8 ad=0.0693 pd=0.75 as=0.09975 ps=0.895 w=0.42 l=0.15
X1253 digital_0.clkload0.A a_6343_2930# VGND VGND sky130_fd_pr__nfet_01v8 ad=0.0588 pd=0.7 as=0.0588 ps=0.7 w=0.42 l=0.15
X1254 a_11209_4018# a_11496_4176# VDPWR VDPWR sky130_fd_pr__pfet_01v8_hvt ad=0.0567 pd=0.69 as=0.1134 ps=1.38 w=0.42 l=0.15
X1255 digital_0._114_.D a_9862_1690# VDPWR VDPWR sky130_fd_pr__pfet_01v8_hvt ad=0.135 pd=1.27 as=0.22895 ps=1.745 w=1 l=0.15
X1256 a_11149_2956# digital_0._115_.Q VDPWR VDPWR sky130_fd_pr__pfet_01v8_hvt ad=0.135 pd=1.27 as=0.135 ps=1.27 w=1 l=0.15
X1257 a_6372_1298# a_6498_1482# VGND VGND sky130_fd_pr__nfet_01v8 ad=0.17225 pd=1.83 as=0.1856 ps=1.26 w=0.65 l=0.25
X1258 digital_0._060_.A_N a_7745_2412# VGND VGND sky130_fd_pr__nfet_01v8 ad=0.10725 pd=0.98 as=0.17515 ps=1.265 w=0.65 l=0.15
X1259 VGND a_13901_2930# a_13832_2956# VGND sky130_fd_pr__nfet_01v8 ad=0.1346 pd=1.15 as=0.0999 ps=0.985 w=0.64 l=0.15
X1260 digital_0.clkbuf_1_1__f_clk.A a_8735_3474# VGND VGND sky130_fd_pr__nfet_01v8 ad=0.0588 pd=0.7 as=0.0588 ps=0.7 w=0.42 l=0.15
X1261 a_9151_4410# a_8772_4044# a_9079_4410# VGND sky130_fd_pr__nfet_01v8 ad=0.1401 pd=1.1 as=0.0441 ps=0.63 w=0.42 l=0.15
X1262 VGND digital_0.load_slew15.X digital_0._117_.RESET_B VGND sky130_fd_pr__nfet_01v8 ad=0.169 pd=1.82 as=0.08775 ps=0.92 w=0.65 l=0.15
X1263 a_11315_1874# a_11149_1874# VGND VGND sky130_fd_pr__nfet_01v8 ad=0.1092 pd=1.36 as=0.0567 ps=0.69 w=0.42 l=0.15
X1264 a_7547_4018# digital_0._110_.Q VDPWR VDPWR sky130_fd_pr__pfet_01v8_hvt ad=0.0567 pd=0.69 as=0.16655 ps=1.39 w=0.42 l=0.15
X1265 VDPWR VGND VDPWR VDPWR sky130_fd_pr__pfet_01v8_hvt ad=0.2262 pd=2.26 as=0 ps=0 w=0.87 l=0.59
X1266 digital_0._069_.A a_13132_4276# VGND VGND sky130_fd_pr__nfet_01v8 ad=0.08775 pd=0.92 as=0.17875 ps=1.85 w=0.65 l=0.15
X1267 a_26806_18564# a_26590_16644# VGND sky130_fd_pr__res_high_po w=0.36 l=7.36
X1268 a_4154_8824# a_4370_6904# VGND sky130_fd_pr__res_high_po w=0.36 l=7.36
X1269 a_11416_3500# digital_0.clkbuf_1_1__f_clk.A VGND VGND sky130_fd_pr__nfet_01v8 ad=0.0588 pd=0.7 as=0.0588 ps=0.7 w=0.42 l=0.15
X1270 digital_0.input1.X a_14053_1324# VDPWR VDPWR sky130_fd_pr__pfet_01v8_hvt ad=0.495 pd=2.99 as=0.2726 ps=1.61 w=1 l=0.15
X1271 digital_0._106_.D a_8869_1651# VGND VGND sky130_fd_pr__nfet_01v8 ad=0.169 pd=1.82 as=0.11285 ps=1.045 w=0.65 l=0.15
X1272 VGND a_8081_4018# digital_0._111_.Q VGND sky130_fd_pr__nfet_01v8 ad=0.2087 pd=2.02 as=0.08775 ps=0.92 w=0.65 l=0.15
X1273 VDPWR a_14806_4588# a_14981_4562# VDPWR sky130_fd_pr__pfet_01v8_hvt ad=0.1134 pd=1.38 as=0.0567 ps=0.69 w=0.42 l=0.15
X1274 a_5883_2412# a_5321_2386# VGND VGND sky130_fd_pr__nfet_01v8 ad=0.0669 pd=0.75 as=0.12495 ps=1.015 w=0.42 l=0.15
X1275 VGND digital_0._116_.Q digital_0._109_.RESET_B VGND sky130_fd_pr__nfet_01v8 ad=0.182 pd=1.86 as=0.08775 ps=0.92 w=0.65 l=0.15
X1276 a_12677_1298# digital_0.output12.A VGND VGND sky130_fd_pr__nfet_01v8 ad=0.1092 pd=1.36 as=0.0567 ps=0.69 w=0.42 l=0.15
X1277 VDPWR a_14531_1476# digital_0.hold18.X VDPWR sky130_fd_pr__pfet_01v8_hvt ad=0.14075 pd=1.325 as=0.26 ps=2.52 w=1 l=0.15
X1278 LELO_GR01_0.x7.x15.I2 LELO_GR01_0.x7.xd1<4>.A VDPWR VDPWR sky130_fd_pr__pfet_01v8_lvt ad=0.3168 pd=1.62 as=0.5088 ps=2.98 w=0.96 l=0.94
X1279 a_6575_1868# a_6631_1842# digital_0._113_.D VDPWR sky130_fd_pr__pfet_01v8_hvt ad=0.26 pd=2.52 as=0.135 ps=1.27 w=1 l=0.15
X1280 VDPWR a_6343_2930# digital_0.clkload0.A VDPWR sky130_fd_pr__pfet_01v8_hvt ad=0.14 pd=1.28 as=0.14 ps=1.28 w=1 l=0.15
X1281 VDPWR a_13969_5106# digital_0.hold28.A VDPWR sky130_fd_pr__pfet_01v8_hvt ad=0.3012 pd=2.66 as=0.135 ps=1.27 w=1 l=0.15
X1282 a_6851_2188# digital_0._063_.A digital_0._113_.D VGND sky130_fd_pr__nfet_01v8 ad=0.08775 pd=0.92 as=0.10563 ps=0.975 w=0.65 l=0.15
X1283 VGND a_13745_3198# a_13706_3072# VGND sky130_fd_pr__nfet_01v8 ad=0.0567 pd=0.69 as=0.1092 ps=1.36 w=0.42 l=0.15
X1284 VDPWR a_3389_2930# digital_0.output9.A VDPWR sky130_fd_pr__pfet_01v8_hvt ad=0.3012 pd=2.66 as=0.135 ps=1.27 w=1 l=0.15
X1285 VDPWR a_4149_2930# a_4080_2956# VDPWR sky130_fd_pr__pfet_01v8_hvt ad=0.2184 pd=2.2 as=0.12915 ps=1.185 w=0.84 l=0.15
X1286 VDPWR a_15300_2412# digital_0._116_.Q VDPWR sky130_fd_pr__pfet_01v8_hvt ad=0.26 pd=2.52 as=0.135 ps=1.27 w=1 l=0.15
X1287 VDPWR a_15506_2956# a_15617_2956# VDPWR sky130_fd_pr__pfet_01v8_hvt ad=0.2726 pd=1.61 as=0.2173 ps=2.17 w=0.82 l=0.25
X1288 VDPWR digital_0.hold28.A a_14419_3827# VDPWR sky130_fd_pr__pfet_01v8_hvt ad=0.15835 pd=1.395 as=0.07665 ps=0.785 w=0.42 l=0.15
X1289 a_7820_8824# a_7604_6904# VGND sky130_fd_pr__res_high_po w=0.36 l=7.36
X1290 VGND digital_0._118_.D a_14464_2956# VGND sky130_fd_pr__nfet_01v8 ad=0.2205 pd=1.89 as=0.066 ps=0.745 w=0.42 l=0.15
X1291 VGND VDPWR VGND VGND sky130_fd_pr__nfet_01v8 ad=0.143 pd=1.62 as=0 ps=0 w=0.55 l=0.59
X1292 LELO_GR01_0.x7.x1.x7.D LELO_GR01_0.x7.x7.G LELO_GR01_0.x7.x1.x5.IBN VGND sky130_fd_pr__nfet_01v8_lvt ad=0.3168 pd=1.62 as=0.5088 ps=2.98 w=0.96 l=0.94
X1293 a_11715_5452# digital_0._108_.Q VGND VGND sky130_fd_pr__nfet_01v8 ad=0.06825 pd=0.86 as=0.10725 ps=0.98 w=0.65 l=0.15
X1294 digital_0.input3.X a_4485_2412# VDPWR VDPWR sky130_fd_pr__pfet_01v8_hvt ad=0.495 pd=2.99 as=0.2726 ps=1.61 w=1 l=0.15
X1295 digital_0._116_.D a_13042_1476# VDPWR VDPWR sky130_fd_pr__pfet_01v8_hvt ad=0.14 pd=1.28 as=0.265 ps=2.53 w=1 l=0.15
X1296 VGND VGND LELO_GR01_0.x7.x15.I1 sky130_fd_pr__pnp_05v5_W3p40L3p40
**devattr s=462400,2720
X1297 LELO_GR01_0.x7.x23.D LELO_GR01_0.x8.PWRUP_N_1V8 LELO_GR01_0.x7.x24.D VDPWR sky130_fd_pr__pfet_01v8_lvt ad=0.3168 pd=1.62 as=0.5088 ps=2.98 w=0.96 l=0.94
X1298 VDPWR digital_0._116_.Q a_13189_3750# VDPWR sky130_fd_pr__pfet_01v8_hvt ad=0.135 pd=1.27 as=0.135 ps=1.27 w=1 l=0.15
X1299 VDPWR a_3336_4018# uio_out<4> VDPWR sky130_fd_pr__pfet_01v8_hvt ad=0.2726 pd=1.61 as=0.495 ps=2.99 w=1 l=0.15
X1300 VGND LELO_GR01_0.x8.x5.CK LELO_GR01_0.x8.IBP_BG VGND sky130_fd_pr__nfet_01v8_lvt ad=0.5088 pd=2.98 as=0.3168 ps=1.62 w=0.96 l=0.94
X1301 a_14146_4588# digital_0._100_.D VDPWR VDPWR sky130_fd_pr__pfet_01v8_hvt ad=0.0651 pd=0.73 as=0.1092 ps=1.36 w=0.42 l=0.15
X1302 VDPWR digital_0._112_.D a_6644_2778# VDPWR sky130_fd_pr__pfet_01v8_hvt ad=0.1092 pd=1.36 as=0.0651 ps=0.73 w=0.42 l=0.15
X1303 VGND a_3730_3500# a_3841_3500# VGND sky130_fd_pr__nfet_01v8 ad=0.1856 pd=1.26 as=0.17225 ps=1.83 w=0.65 l=0.25
X1304 VGND digital_0.load_slew15.X digital_0._118_.RESET_B VGND sky130_fd_pr__nfet_01v8 ad=0.169 pd=1.82 as=0.08775 ps=0.92 w=0.65 l=0.15
X1305 VDPWR digital_0.output8.A a_6939_5676# VDPWR sky130_fd_pr__pfet_01v8_hvt ad=0.0567 pd=0.69 as=0.1092 ps=1.36 w=0.42 l=0.15
X1306 a_8368_2000# a_8685_2110# a_8643_2234# VGND sky130_fd_pr__special_nfet_01v8 ad=0.0711 pd=0.755 as=0.0669 ps=0.75 w=0.36 l=0.15
X1307 VGND digital_0.output13.A a_12512_5452# VGND sky130_fd_pr__nfet_01v8 ad=0.08775 pd=0.92 as=0.169 ps=1.82 w=0.65 l=0.15
X1308 digital_0.load_slew15.A a_9545_2956# VGND VGND sky130_fd_pr__nfet_01v8 ad=0.2079 pd=1.83 as=0.1856 ps=1.26 w=0.42 l=0.15
X1309 a_8735_3474# clk VDPWR VDPWR sky130_fd_pr__pfet_01v8_hvt ad=0.14 pd=1.28 as=0.14 ps=1.28 w=1 l=0.15
X1310 VDPWR digital_0._069_.A a_8793_4562# VDPWR sky130_fd_pr__pfet_01v8_hvt ad=0.154 pd=1.335 as=0.173 ps=1.4 w=0.64 l=0.15
X1311 a_7385_3750# digital_0._069_.A VDPWR VDPWR sky130_fd_pr__pfet_01v8_hvt ad=0.14 pd=1.28 as=0.135 ps=1.27 w=1 l=0.15
X1312 VDPWR a_5925_3642# a_5886_3768# VDPWR sky130_fd_pr__pfet_01v8_hvt ad=0.0864 pd=0.91 as=0.1664 ps=1.8 w=0.64 l=0.15
X1313 VDPWR a_14995_3500# a_15101_3500# VDPWR sky130_fd_pr__pfet_01v8_hvt ad=0.14075 pd=1.325 as=0.1092 ps=1.36 w=0.42 l=0.5
X1314 VGND digital_0._100_.RESET_B a_14503_4588# VGND sky130_fd_pr__nfet_01v8 ad=0.1346 pd=1.15 as=0.0441 ps=0.63 w=0.42 l=0.15
X1315 VGND VDPWR VGND VGND sky130_fd_pr__nfet_01v8 ad=0.143 pd=1.62 as=0 ps=0 w=0.55 l=0.59
X1316 VDPWR VGND VDPWR VDPWR sky130_fd_pr__pfet_01v8_hvt ad=0.2262 pd=2.26 as=0 ps=0 w=0.87 l=0.59
X1317 VDPWR a_14297_4286# a_14258_4160# VDPWR sky130_fd_pr__pfet_01v8_hvt ad=0.0864 pd=0.91 as=0.1664 ps=1.8 w=0.64 l=0.15
X1318 a_28502_15064# a_28286_13144# VGND sky130_fd_pr__res_high_po w=0.36 l=7.36
X1319 VDPWR a_13942_1324# a_14053_1324# VDPWR sky130_fd_pr__pfet_01v8_hvt ad=0.2726 pd=1.61 as=0.2173 ps=2.17 w=0.82 l=0.25
X1320 a_5925_3642# digital_0.input1.X VGND VGND sky130_fd_pr__nfet_01v8 ad=0.1092 pd=1.36 as=0.0567 ps=0.69 w=0.42 l=0.15
X1321 VDPWR VGND VDPWR VDPWR sky130_fd_pr__pfet_01v8_hvt ad=0.2262 pd=2.26 as=0 ps=0 w=0.87 l=0.59
X1322 a_13371_4404# digital_0._108_.Q VGND VGND sky130_fd_pr__nfet_01v8 ad=0.05355 pd=0.675 as=0.1304 ps=1.105 w=0.42 l=0.15
X1323 VGND digital_0._060_.B a_9947_1324# VGND sky130_fd_pr__nfet_01v8 ad=0.10187 pd=0.99 as=0.0567 ps=0.69 w=0.42 l=0.15
X1324 VGND digital_0.clkbuf_1_1__f_clk.A a_6343_2930# VGND sky130_fd_pr__nfet_01v8 ad=0.0588 pd=0.7 as=0.0588 ps=0.7 w=0.42 l=0.15
X1325 digital_0._112_.D digital_0._063_.B VGND VGND sky130_fd_pr__nfet_01v8 ad=0.08775 pd=0.92 as=0.169 ps=1.82 w=0.65 l=0.15
X1326 a_11980_4954# a_11261_4730# a_11417_4825# VGND sky130_fd_pr__special_nfet_01v8 ad=0.066 pd=0.745 as=0.0594 ps=0.69 w=0.36 l=0.15
X1327 a_7820_8824# a_8036_6904# VGND sky130_fd_pr__res_high_po w=0.36 l=7.36
X1328 LELO_GR01_0.x8.x5.Q uo_out<0> LELO_GR01_0.x8.x8.D LELO_GR01_0.x8.x8.D sky130_fd_pr__pfet_01v8 ad=0.468 pd=2.84 as=0.468 ps=2.84 w=0.9 l=0.16
X1329 VGND a_13141_2930# digital_0.output13.A VGND sky130_fd_pr__nfet_01v8 ad=0.2087 pd=2.02 as=0.08775 ps=0.92 w=0.65 l=0.15
X1330 a_8403_2234# a_8368_2000# a_8081_1842# VGND sky130_fd_pr__nfet_01v8 ad=0.06405 pd=0.725 as=0.1092 ps=1.36 w=0.42 l=0.15
X1331 a_9079_2234# digital_0._106_.RESET_B VGND VGND sky130_fd_pr__nfet_01v8 ad=0.0441 pd=0.63 as=0.1346 ps=1.15 w=0.42 l=0.15
X1332 VGND VDPWR VGND VGND sky130_fd_pr__nfet_01v8 ad=0.143 pd=1.62 as=0 ps=0 w=0.55 l=0.59
X1333 digital_0._100_.RESET_B digital_0.load_slew15.X VDPWR VDPWR sky130_fd_pr__pfet_01v8_hvt ad=0.135 pd=1.27 as=0.26 ps=2.52 w=1 l=0.15
X1334 a_14926_2412# a_13725_2412# a_14726_2778# VGND sky130_fd_pr__nfet_01v8 ad=0.0441 pd=0.63 as=0.0735 ps=0.77 w=0.42 l=0.15
X1335 digital_0.hold19.X a_15101_3500# VDPWR VDPWR sky130_fd_pr__pfet_01v8_hvt ad=0.26 pd=2.52 as=0.14075 ps=1.325 w=1 l=0.15
X1336 VGND digital_0.load_slew17.X digital_0._112_.RESET_B VGND sky130_fd_pr__nfet_01v8 ad=0.08775 pd=0.92 as=0.08775 ps=0.92 w=0.65 l=0.15
X1337 VDPWR digital_0._101_.RESET_B a_14598_4044# VDPWR sky130_fd_pr__pfet_01v8_hvt ad=0.07035 pd=0.755 as=0.1092 ps=1.36 w=0.42 l=0.15
X1338 VGND VDPWR VGND VGND sky130_fd_pr__nfet_01v8 ad=0.143 pd=1.62 as=0 ps=0 w=0.55 l=0.59
X1339 VDPWR a_6633_4825# a_6564_4954# VDPWR sky130_fd_pr__pfet_01v8_hvt ad=0.2184 pd=2.2 as=0.12915 ps=1.185 w=0.84 l=0.15
X1340 a_10861_3474# digital_0.load_slew15.A VGND VGND sky130_fd_pr__nfet_01v8 ad=0.169 pd=1.82 as=0.08775 ps=0.92 w=0.65 l=0.15
X1341 a_7949_5676# a_7695_6003# VGND VGND sky130_fd_pr__nfet_01v8 ad=0.0693 pd=0.75 as=0.1449 ps=1.11 w=0.42 l=0.15
X1342 VGND a_6280_5650# uio_out<3> VGND sky130_fd_pr__nfet_01v8 ad=0.1856 pd=1.26 as=0.2079 ps=1.83 w=0.42 l=0.15
X1343 a_14165_1868# digital_0._119_.RESET_B VDPWR VDPWR sky130_fd_pr__pfet_01v8_hvt ad=0.1092 pd=1.36 as=0.07035 ps=0.755 w=0.42 l=0.15
X1344 a_27670_18564# a_27886_16644# VGND sky130_fd_pr__res_high_po w=0.36 l=7.36
X1345 a_4637_3827# digital_0._112_.Q a_4565_3827# VDPWR sky130_fd_pr__pfet_01v8_hvt ad=0.1932 pd=1.34 as=0.0441 ps=0.63 w=0.42 l=0.15
X1346 VDPWR a_4033_5106# digital_0.output7.A VDPWR sky130_fd_pr__pfet_01v8_hvt ad=0.3012 pd=2.66 as=0.135 ps=1.27 w=1 l=0.15
X1347 VDPWR a_4545_2110# a_4506_1984# VDPWR sky130_fd_pr__pfet_01v8_hvt ad=0.0864 pd=0.91 as=0.1664 ps=1.8 w=0.64 l=0.15
X1348 LELO_GR01_0.x8.x7.D LELO_GR01_0.x8.VREF_BG LELO_GR01_0.x8.x1.x5.IBN VGND sky130_fd_pr__nfet_01v8_lvt ad=0.3168 pd=1.62 as=0.5088 ps=2.98 w=0.96 l=0.94
X1349 VGND VDPWR VGND VGND sky130_fd_pr__nfet_01v8 ad=0.143 pd=1.62 as=0 ps=0 w=0.55 l=0.59
X1350 LELO_GR01_0.x7.x6<3>.G LELO_GR01_0.x7.x18.D LELO_GR01_0.x7.xd1<4>.A VGND sky130_fd_pr__nfet_01v8_lvt ad=0.5088 pd=2.98 as=0.3168 ps=1.62 w=0.96 l=0.94
X1351 a_9404_1868# a_8685_2110# a_8841_1842# VGND sky130_fd_pr__special_nfet_01v8 ad=0.066 pd=0.745 as=0.0594 ps=0.69 w=0.36 l=0.15
X1352 digital_0._105_.D a_5189_1651# VGND VGND sky130_fd_pr__nfet_01v8 ad=0.169 pd=1.82 as=0.11285 ps=1.045 w=0.65 l=0.15
X1353 VGND VDPWR VGND VGND sky130_fd_pr__nfet_01v8 ad=0.143 pd=1.62 as=0 ps=0 w=0.55 l=0.59
X1354 VDPWR a_7871_4616# digital_0._067_.A VDPWR sky130_fd_pr__pfet_01v8_hvt ad=0.38 pd=2.76 as=0.195 ps=1.39 w=1 l=0.15
X1355 a_25270_15064# a_25486_13144# VGND sky130_fd_pr__res_high_po w=0.36 l=7.36
X1356 VDPWR VGND VDPWR VDPWR sky130_fd_pr__pfet_01v8_hvt ad=0.2262 pd=2.26 as=0 ps=0 w=0.87 l=0.59
X1357 a_11727_4588# a_11348_4954# a_11655_4588# VGND sky130_fd_pr__nfet_01v8 ad=0.1401 pd=1.1 as=0.0441 ps=0.63 w=0.42 l=0.15
X1358 a_9104_2664# a_9382_2680# a_9338_2778# VDPWR sky130_fd_pr__pfet_01v8_hvt ad=0.0588 pd=0.7 as=0.0567 ps=0.69 w=0.42 l=0.15
X1359 VDPWR VGND VDPWR VDPWR sky130_fd_pr__pfet_01v8_hvt ad=0.2262 pd=2.26 as=0 ps=0 w=0.87 l=0.59
X1360 a_11219_4588# a_10657_4562# VGND VGND sky130_fd_pr__nfet_01v8 ad=0.0669 pd=0.75 as=0.12495 ps=1.015 w=0.42 l=0.15
X1361 VDPWR LELO_GR01_0.x7.xd1<4>.A LELO_GR01_0.x7.x7.G VDPWR sky130_fd_pr__pfet_01v8_lvt ad=0.5088 pd=2.98 as=0.3168 ps=1.62 w=0.96 l=0.94
X1362 digital_0.output13.A a_13141_2930# VDPWR VDPWR sky130_fd_pr__pfet_01v8_hvt ad=0.135 pd=1.27 as=0.26 ps=2.52 w=1 l=0.15
X1363 VGND a_4139_1324# a_4245_1324# VGND sky130_fd_pr__nfet_01v8 ad=0.097 pd=0.975 as=0.1092 ps=1.36 w=0.42 l=0.5
X1364 digital_0.clkload0.A a_6343_2930# VGND VGND sky130_fd_pr__nfet_01v8 ad=0.0588 pd=0.7 as=0.0588 ps=0.7 w=0.42 l=0.15
X1365 a_10657_4562# a_10944_4840# VDPWR VDPWR sky130_fd_pr__pfet_01v8_hvt ad=0.0567 pd=0.69 as=0.1134 ps=1.38 w=0.42 l=0.15
X1366 digital_0.clkbuf_1_1__f_clk.A a_8735_3474# VGND VGND sky130_fd_pr__nfet_01v8 ad=0.0588 pd=0.7 as=0.05775 ps=0.695 w=0.42 l=0.15
X1367 digital_0._069_.B digital_0._109_.Q a_11433_5132# VDPWR sky130_fd_pr__pfet_01v8_hvt ad=0.135 pd=1.27 as=0.36 ps=2.72 w=1 l=0.15
X1368 VDPWR VGND VDPWR VDPWR sky130_fd_pr__pfet_01v8_hvt ad=0.2262 pd=2.26 as=0 ps=0 w=0.87 l=0.59
X1369 VGND VDPWR VGND VGND sky130_fd_pr__nfet_01v8 ad=0.143 pd=1.62 as=0 ps=0 w=0.55 l=0.59
X1370 a_14876_2626# a_14726_2778# VGND VGND sky130_fd_pr__nfet_01v8 ad=0.1404 pd=1.6 as=0.1137 ps=1.01 w=0.54 l=0.15
X1371 VDPWR digital_0.hold28.A a_11935_1651# VDPWR sky130_fd_pr__pfet_01v8_hvt ad=0.15835 pd=1.395 as=0.07665 ps=0.785 w=0.42 l=0.15
X1372 LELO_GR01_0.x7.x15.I2 LELO_GR01_0.x7.xd1<4>.A VDPWR VDPWR sky130_fd_pr__pfet_01v8_lvt ad=0.3168 pd=1.62 as=0.5088 ps=2.98 w=0.96 l=0.94
X1373 VGND digital_0._104_.RESET_B a_3711_3322# VGND sky130_fd_pr__nfet_01v8 ad=0.12495 pd=1.015 as=0.06405 ps=0.725 w=0.42 l=0.15
X1374 a_13962_2234# digital_0.hold28.X VDPWR VDPWR sky130_fd_pr__pfet_01v8_hvt ad=0.0651 pd=0.73 as=0.1092 ps=1.36 w=0.42 l=0.15
X1375 VGND digital_0.input2.X a_15593_3528# VGND sky130_fd_pr__nfet_01v8 ad=0.1118 pd=1.04 as=0.0567 ps=0.69 w=0.42 l=0.15
X1376 VGND digital_0._069_.A a_7957_4616# VGND sky130_fd_pr__nfet_01v8 ad=0.1118 pd=1.04 as=0.0567 ps=0.69 w=0.42 l=0.15
X1377 digital_0._063_.B digital_0._112_.Q VGND VGND sky130_fd_pr__nfet_01v8 ad=0.08775 pd=0.92 as=0.26 ps=2.1 w=0.65 l=0.15
X1378 VGND digital_0._116_.Q digital_0._113_.RESET_B VGND sky130_fd_pr__nfet_01v8 ad=0.182 pd=1.86 as=0.08775 ps=0.92 w=0.65 l=0.15
X1379 digital_0.clkbuf_1_1__f_clk.A a_8735_3474# VDPWR VDPWR sky130_fd_pr__pfet_01v8_hvt ad=0.14 pd=1.28 as=0.265 ps=2.53 w=1 l=0.15
X1380 VGND digital_0.hold28.A a_11942_1324# VGND sky130_fd_pr__nfet_01v8 ad=0.11285 pd=1.045 as=0.0693 ps=0.75 w=0.42 l=0.15
X1381 a_3702_4018# digital_0.output9.A VDPWR VDPWR sky130_fd_pr__pfet_01v8_hvt ad=0.27 pd=2.54 as=0.19265 ps=1.415 w=1 l=0.15
X1382 a_8220_5132# a_8094_5248# a_7816_5264# VGND sky130_fd_pr__special_nfet_01v8 ad=0.0999 pd=0.985 as=0.0711 ps=0.755 w=0.36 l=0.15
X1383 a_14275_1842# a_14057_2246# VDPWR VDPWR sky130_fd_pr__pfet_01v8_hvt ad=0.12915 pd=1.185 as=0.2184 ps=2.2 w=0.84 l=0.15
X1384 a_3993_3198# digital_0.clkload0.A VGND VGND sky130_fd_pr__nfet_01v8 ad=0.1092 pd=1.36 as=0.0567 ps=0.69 w=0.42 l=0.15
X1385 VGND VDPWR VGND VGND sky130_fd_pr__nfet_01v8 ad=0.143 pd=1.62 as=0 ps=0 w=0.55 l=0.59
X1386 a_14885_1298# digital_0.output4.A VDPWR VDPWR sky130_fd_pr__pfet_01v8_hvt ad=0.1092 pd=1.36 as=0.0567 ps=0.69 w=0.42 l=0.15
X1387 VDPWR a_8133_5374# a_8094_5248# VDPWR sky130_fd_pr__pfet_01v8_hvt ad=0.0864 pd=0.91 as=0.1664 ps=1.8 w=0.64 l=0.15
X1388 VGND LELO_GR01_0.x8.x1.x5.x9<2>.G LELO_GR01_0.x8.x1.x5.IBN VGND sky130_fd_pr__nfet_01v8_lvt ad=0.5088 pd=2.98 as=0.3168 ps=1.62 w=0.96 l=0.94
X1389 a_8552_20000# a_10472_20216# VGND sky130_fd_pr__res_high_po w=0.36 l=7.36
X1390 VGND VDPWR VGND VGND sky130_fd_pr__nfet_01v8 ad=0.143 pd=1.62 as=0 ps=0 w=0.55 l=0.59
X1391 VGND LELO_GR01_0.x7.x1.x5.x9<2>.G LELO_GR01_0.x7.x1.x5.IBN VGND sky130_fd_pr__nfet_01v8_lvt ad=0.5088 pd=2.98 as=0.3168 ps=1.62 w=0.96 l=0.94
X1392 digital_0.clkbuf_1_0__f_clk.X a_11416_3500# VGND VGND sky130_fd_pr__nfet_01v8 ad=0.0588 pd=0.7 as=0.0588 ps=0.7 w=0.42 l=0.15
X1393 a_11773_1868# digital_0._107_.RESET_B VDPWR VDPWR sky130_fd_pr__pfet_01v8_hvt ad=0.1092 pd=1.36 as=0.07035 ps=0.755 w=0.42 l=0.15
X1394 a_4701_1842# a_4506_1984# a_5011_2234# VGND sky130_fd_pr__special_nfet_01v8 ad=0.0594 pd=0.69 as=0.1401 ps=1.1 w=0.36 l=0.15
X1395 a_8685_4286# digital_0.input1.X VGND VGND sky130_fd_pr__nfet_01v8 ad=0.1092 pd=1.36 as=0.0567 ps=0.69 w=0.42 l=0.15
X1396 a_4154_8824# a_3938_6904# VGND sky130_fd_pr__res_high_po w=0.36 l=7.36
X1397 LELO_GR01_0.x7.x1.x5.x8.S LELO_GR01_0.x8.PWRUP_N_1V8 VDPWR VDPWR sky130_fd_pr__pfet_01v8_lvt ad=0.3168 pd=1.62 as=0.5088 ps=2.98 w=0.96 l=0.94
X1398 VGND digital_0._067_.A digital_0._110_.D VGND sky130_fd_pr__nfet_01v8 ad=0.182 pd=1.86 as=0.08775 ps=0.92 w=0.65 l=0.15
X1399 a_11234_3276# digital_0._115_.Q VGND VGND sky130_fd_pr__nfet_01v8 ad=0.08775 pd=0.92 as=0.17875 ps=1.85 w=0.65 l=0.15
X1400 LELO_GR01_0.x8.x5.XA5.A LELO_GR01_0.x8.x5.XA7.C LELO_GR01_0.x8.x5.XA4.MP1.S LELO_GR01_0.x8.x8.D sky130_fd_pr__pfet_01v8 ad=0.468 pd=2.84 as=0.288 ps=1.54 w=0.9 l=0.16
X1401 digital_0.output9.A a_3389_2930# VGND VGND sky130_fd_pr__nfet_01v8 ad=0.08775 pd=0.92 as=0.169 ps=1.82 w=0.65 l=0.15
X1402 LELO_GR01_0.x7.x15.I1 a_7364_11234# VGND sky130_fd_pr__res_high_po w=0.36 l=7.36
X1403 VDPWR digital_0._106_.RESET_B a_8986_1868# VDPWR sky130_fd_pr__pfet_01v8_hvt ad=0.07035 pd=0.755 as=0.1092 ps=1.36 w=0.42 l=0.15
X1404 VGND a_6343_2930# digital_0.clkload0.A VGND sky130_fd_pr__nfet_01v8 ad=0.0588 pd=0.7 as=0.0588 ps=0.7 w=0.42 l=0.15
X1405 a_8220_5132# a_8133_5374# a_7816_5264# VDPWR sky130_fd_pr__pfet_01v8_hvt ad=0.12915 pd=1.185 as=0.0588 ps=0.7 w=0.42 l=0.15
X1406 a_14622_2246# a_13541_1874# a_14275_1842# VDPWR sky130_fd_pr__pfet_01v8_hvt ad=0.0588 pd=0.7 as=0.12915 ps=1.185 w=0.42 l=0.15
X1407 VDPWR VGND VDPWR VDPWR sky130_fd_pr__pfet_01v8_hvt ad=0.2262 pd=2.26 as=0 ps=0 w=0.87 l=0.59
X1408 VDPWR VGND VDPWR VDPWR sky130_fd_pr__pfet_01v8_hvt ad=0.2262 pd=2.26 as=0 ps=0 w=0.87 l=0.59
X1409 digital_0._108_.Q a_11209_4018# VGND VGND sky130_fd_pr__nfet_01v8 ad=0.08775 pd=0.92 as=0.169 ps=1.82 w=0.65 l=0.15
X1410 LELO_GR01_0.x7.x31.N a_7604_6904# VGND sky130_fd_pr__res_high_po w=0.36 l=7.36
X1411 VDPWR VGND VDPWR VDPWR sky130_fd_pr__pfet_01v8_hvt ad=0.2262 pd=2.26 as=0 ps=0 w=0.87 l=0.59
X1412 VGND a_5925_2554# a_5886_2680# VGND sky130_fd_pr__nfet_01v8 ad=0.0567 pd=0.69 as=0.1092 ps=1.36 w=0.42 l=0.15
X1413 a_4228_2000# a_4545_2110# a_4503_2234# VGND sky130_fd_pr__special_nfet_01v8 ad=0.0711 pd=0.755 as=0.0669 ps=0.75 w=0.36 l=0.15
X1414 digital_0._111_.Q a_8081_4018# VDPWR VDPWR sky130_fd_pr__pfet_01v8_hvt ad=0.135 pd=1.27 as=0.26 ps=2.52 w=1 l=0.15
X1415 a_14531_1476# a_14627_1298# VGND VGND sky130_fd_pr__nfet_01v8 ad=0.1092 pd=1.36 as=0.097 ps=0.975 w=0.42 l=0.5
X1416 digital_0._067_.A a_7871_4616# VDPWR VDPWR sky130_fd_pr__pfet_01v8_hvt ad=0.195 pd=1.39 as=0.16655 ps=1.39 w=1 l=0.15
X1417 VGND digital_0._112_.D a_6644_2778# VGND sky130_fd_pr__nfet_01v8 ad=0.2205 pd=1.89 as=0.066 ps=0.745 w=0.42 l=0.15
X1418 VDPWR digital_0._116_.Q a_3437_1574# VDPWR sky130_fd_pr__pfet_01v8_hvt ad=0.135 pd=1.27 as=0.135 ps=1.27 w=1 l=0.15
X1419 VDPWR a_6738_1298# a_6498_1482# VDPWR sky130_fd_pr__pfet_01v8_hvt ad=0.19265 pd=1.415 as=0.2173 ps=2.17 w=0.82 l=0.25
X1420 VGND a_8739_4910# digital_0._111_.D VGND sky130_fd_pr__nfet_01v8 ad=0.18525 pd=1.87 as=0.08775 ps=0.92 w=0.65 l=0.15
X1421 a_9017_4588# digital_0._065_.A2_N a_8793_4562# VGND sky130_fd_pr__nfet_01v8 ad=0.06615 pd=0.735 as=0.1092 ps=1.36 w=0.42 l=0.15
X1422 digital_0.hold28.A a_13969_5106# VDPWR VDPWR sky130_fd_pr__pfet_01v8_hvt ad=0.135 pd=1.27 as=0.26 ps=2.52 w=1 l=0.15
X1423 VDPWR digital_0._116_.Q a_9969_2956# VDPWR sky130_fd_pr__pfet_01v8_hvt ad=0.135 pd=1.27 as=0.135 ps=1.27 w=1 l=0.15
X1424 VDPWR VGND VDPWR VDPWR sky130_fd_pr__pfet_01v8_hvt ad=0.2262 pd=2.26 as=0 ps=0 w=0.87 l=0.59
X1425 VGND digital_0.load_slew15.A digital_0._109_.RESET_B VGND sky130_fd_pr__nfet_01v8 ad=0.08775 pd=0.92 as=0.08775 ps=0.92 w=0.65 l=0.15
X1426 a_23562_18564# a_23346_16644# VGND sky130_fd_pr__res_high_po w=0.36 l=7.36
X1427 VGND VDPWR VGND VGND sky130_fd_pr__nfet_01v8 ad=0.143 pd=1.62 as=0 ps=0 w=0.55 l=0.59
X1428 VGND digital_0.clkbuf_1_1__f_clk.A a_11416_3500# VGND sky130_fd_pr__nfet_01v8 ad=0.0588 pd=0.7 as=0.0588 ps=0.7 w=0.42 l=0.15
X1429 VDPWR a_12603_2956# a_12709_2956# VDPWR sky130_fd_pr__pfet_01v8_hvt ad=0.14075 pd=1.325 as=0.1092 ps=1.36 w=0.42 l=0.5
X1430 a_6046_5364# digital_0.hold24.X a_6188_5171# VDPWR sky130_fd_pr__pfet_01v8_hvt ad=0.1932 pd=1.34 as=0.07665 ps=0.785 w=0.42 l=0.15
X1431 VDPWR a_14726_2778# a_15300_2412# VDPWR sky130_fd_pr__pfet_01v8_hvt ad=0.135 pd=1.27 as=0.26 ps=2.52 w=1 l=0.15
X1432 a_4462_1868# a_3941_1842# VDPWR VDPWR sky130_fd_pr__pfet_01v8_hvt ad=0.0567 pd=0.69 as=0.0819 ps=0.81 w=0.42 l=0.15
R3 uio_oe<0> JNWTR_TIEH_CV_0.Y sky130_fd_pr__res_generic_m4 w=0.3 l=0.3
X1433 a_14763_4410# a_14384_4044# a_14691_4410# VGND sky130_fd_pr__nfet_01v8 ad=0.1401 pd=1.1 as=0.0441 ps=0.63 w=0.42 l=0.15
X1434 a_9421_2554# digital_0.input1.X VGND VGND sky130_fd_pr__nfet_01v8 ad=0.1092 pd=1.36 as=0.0567 ps=0.69 w=0.42 l=0.15
X1435 digital_0._109_.D digital_0._069_.B VGND VGND sky130_fd_pr__nfet_01v8 ad=0.08775 pd=0.92 as=0.08775 ps=0.92 w=0.65 l=0.15
X1436 VGND digital_0.output7.A a_4455_5676# VGND sky130_fd_pr__nfet_01v8 ad=0.0567 pd=0.69 as=0.1092 ps=1.36 w=0.42 l=0.15
X1437 a_14255_4410# a_13693_4018# VGND VGND sky130_fd_pr__nfet_01v8 ad=0.0669 pd=0.75 as=0.12495 ps=1.015 w=0.42 l=0.15
X1438 VDPWR digital_0.load_slew17.X digital_0._106_.RESET_B VDPWR sky130_fd_pr__pfet_01v8_hvt ad=0.26 pd=2.52 as=0.135 ps=1.27 w=1 l=0.15
X1439 VDPWR clk a_8735_3474# VDPWR sky130_fd_pr__pfet_01v8_hvt ad=0.14 pd=1.28 as=0.14 ps=1.28 w=1 l=0.15
X1440 VGND a_13693_4018# digital_0.output6.A VGND sky130_fd_pr__nfet_01v8 ad=0.2087 pd=2.02 as=0.08775 ps=0.92 w=0.65 l=0.15
X1441 a_12069_5132# digital_0._108_.Q a_12154_5452# VDPWR sky130_fd_pr__pfet_01v8_hvt ad=0.26 pd=2.52 as=0.135 ps=1.27 w=1 l=0.15
X1442 VGND digital_0._103_.D a_8852_5132# VGND sky130_fd_pr__nfet_01v8 ad=0.2205 pd=1.89 as=0.066 ps=0.745 w=0.42 l=0.15
X1443 a_4938_5132# a_4724_5132# VDPWR VDPWR sky130_fd_pr__pfet_01v8_hvt ad=0.1155 pd=0.97 as=0.07035 ps=0.755 w=0.42 l=0.15
X1444 VGND VDPWR VGND VGND sky130_fd_pr__nfet_01v8 ad=0.143 pd=1.62 as=0 ps=0 w=0.55 l=0.59
X1445 a_8643_2234# a_8081_1842# VGND VGND sky130_fd_pr__nfet_01v8 ad=0.0669 pd=0.75 as=0.12495 ps=1.015 w=0.42 l=0.15
X1446 LELO_GR01_0.x7.x15.I2 LELO_GR01_0.x7.xd1<4>.A VDPWR VDPWR sky130_fd_pr__pfet_01v8_lvt ad=0.3168 pd=1.62 as=0.5088 ps=2.98 w=0.96 l=0.94
X1447 VGND VDPWR VGND VGND sky130_fd_pr__nfet_01v8 ad=0.143 pd=1.62 as=0 ps=0 w=0.55 l=0.59
X1448 digital_0.clkload0.A a_6343_2930# VGND VGND sky130_fd_pr__nfet_01v8 ad=0.0588 pd=0.7 as=0.05775 ps=0.695 w=0.42 l=0.15
X1449 VDPWR digital_0._103_.RESET_B a_7529_5106# VDPWR sky130_fd_pr__pfet_01v8_hvt ad=0.0819 pd=0.81 as=0.0567 ps=0.69 w=0.42 l=0.15
X1450 a_10137_4838# digital_0.load_slew15.A digital_0._108_.RESET_B VDPWR sky130_fd_pr__pfet_01v8_hvt ad=0.26 pd=2.52 as=0.135 ps=1.27 w=1 l=0.15
X1451 LELO_GR01_0.x7.x11.P a_28318_16644# VGND sky130_fd_pr__res_high_po w=0.36 l=7.36
X1452 VDPWR LELO_GR01_0.x7.xd1<4>.A LELO_GR01_0.x7.x15.I2 VDPWR sky130_fd_pr__pfet_01v8_lvt ad=0.5088 pd=2.98 as=0.3168 ps=1.62 w=0.96 l=0.94
X1453 VGND a_7253_2386# digital_0.clkload0.X VGND sky130_fd_pr__nfet_01v8 ad=0.0588 pd=0.7 as=0.0588 ps=0.7 w=0.42 l=0.15
X1454 digital_0.clkbuf_1_1__f_clk.A a_8735_3474# VGND VGND sky130_fd_pr__nfet_01v8 ad=0.0588 pd=0.7 as=0.0588 ps=0.7 w=0.42 l=0.15
X1455 JNWTR_TIEH_CV_0.MP0.G JNWTR_TIEH_CV_0.MP0.G VGND VGND sky130_fd_pr__nfet_01v8 ad=0.468 pd=2.84 as=0.468 ps=2.84 w=0.9 l=0.16
X1456 LELO_GR01_0.x8.x5.XA7.CN LELO_GR01_0.x8.x5.XA7.C LELO_GR01_0.x8.x8.D LELO_GR01_0.x8.x8.D sky130_fd_pr__pfet_01v8 ad=0.468 pd=2.84 as=0.468 ps=2.84 w=0.9 l=0.16
X1457 a_11348_4954# a_11261_4730# a_10944_4840# VDPWR sky130_fd_pr__pfet_01v8_hvt ad=0.12915 pd=1.185 as=0.0588 ps=0.7 w=0.42 l=0.15
X1458 a_8599_5498# a_8220_5132# a_8527_5498# VGND sky130_fd_pr__nfet_01v8 ad=0.1401 pd=1.1 as=0.0441 ps=0.63 w=0.42 l=0.15
X1459 a_11416_3500# digital_0.clkbuf_1_1__f_clk.A VGND VGND sky130_fd_pr__nfet_01v8 ad=0.0588 pd=0.7 as=0.1113 ps=1.37 w=0.42 l=0.15
X1460 VGND VDPWR VGND VGND sky130_fd_pr__nfet_01v8 ad=0.143 pd=1.62 as=0 ps=0 w=0.55 l=0.59
X1461 digital_0.output11.A a_8081_1842# VGND VGND sky130_fd_pr__nfet_01v8 ad=0.08775 pd=0.92 as=0.169 ps=1.82 w=0.65 l=0.15
X1462 VDPWR a_10786_1842# a_10546_2106# VDPWR sky130_fd_pr__pfet_01v8_hvt ad=0.19265 pd=1.415 as=0.2173 ps=2.17 w=0.82 l=0.25
X1463 VDPWR digital_0._103_.RESET_B a_8434_5132# VDPWR sky130_fd_pr__pfet_01v8_hvt ad=0.07035 pd=0.755 as=0.1092 ps=1.36 w=0.42 l=0.15
X1464 LELO_GR01_0.x7.x1.x7.D LELO_GR01_0.x7.x1.x7.D VDPWR VDPWR sky130_fd_pr__pfet_01v8_lvt ad=0.3168 pd=1.62 as=0.5088 ps=2.98 w=0.96 l=0.94
X1465 a_3722_8824# a_3506_6904# VGND sky130_fd_pr__res_high_po w=0.36 l=7.36
X1466 VGND VDPWR VGND VGND sky130_fd_pr__nfet_01v8 ad=0.143 pd=1.62 as=0 ps=0 w=0.55 l=0.59
X1467 VGND VDPWR VGND VGND sky130_fd_pr__nfet_01v8 ad=0.143 pd=1.62 as=0 ps=0 w=0.55 l=0.59
X1468 LELO_GR01_0.x8.PWRUP_N_1V8 LELO_GR01_0.PWRUP_1V8 VGND VGND sky130_fd_pr__nfet_01v8 ad=0.468 pd=2.84 as=0.468 ps=2.84 w=0.9 l=0.16
X1469 VGND digital_0._119_.RESET_B a_14319_2234# VGND sky130_fd_pr__nfet_01v8 ad=0.1346 pd=1.15 as=0.0441 ps=0.63 w=0.42 l=0.15
X1470 a_14797_2172# a_14622_2246# a_14976_2234# VGND sky130_fd_pr__nfet_01v8 ad=0.1092 pd=1.36 as=0.06405 ps=0.725 w=0.42 l=0.15
X1471 LELO_GR01_0.x7.x29.N a_17724_13144# VGND sky130_fd_pr__res_high_po w=0.36 l=7.36
X1472 a_26134_15064# a_25918_13144# VGND sky130_fd_pr__res_high_po w=0.36 l=7.36
X1473 LELO_GR01_0.x8.x8.D VDPWR LELO_GR01_0.x8.x5.XA7.MP1.S LELO_GR01_0.x8.x8.D sky130_fd_pr__pfet_01v8 ad=0.288 pd=1.54 as=0.468 ps=2.84 w=0.9 l=0.16
X1474 VDPWR VGND VDPWR VDPWR sky130_fd_pr__pfet_01v8_hvt ad=0.2262 pd=2.26 as=0 ps=0 w=0.87 l=0.59
X1475 VDPWR LELO_GR01_0.x8.PWRUP_N_1V8 LELO_GR01_0.x7.x1.x5.x8.S VDPWR sky130_fd_pr__pfet_01v8_lvt ad=0.5088 pd=2.98 as=0.3168 ps=1.62 w=0.96 l=0.94
X1476 VDPWR a_14350_2386# a_14260_2778# VDPWR sky130_fd_pr__pfet_01v8_hvt ad=0.0798 pd=0.8 as=0.0945 ps=0.87 w=0.42 l=0.15
X1477 LELO_GR01_0.x8.x1.x5.IBN LELO_GR01_0.x8.x1.x5.x9<2>.G VGND VGND sky130_fd_pr__nfet_01v8_lvt ad=0.3168 pd=1.62 as=0.5088 ps=2.98 w=0.96 l=0.94
X1478 digital_0.hold20.X a_7281_5676# VGND VGND sky130_fd_pr__nfet_01v8 ad=0.169 pd=1.82 as=0.097 ps=0.975 w=0.65 l=0.15
X1479 VDPWR digital_0.hold28.A a_4383_3827# VDPWR sky130_fd_pr__pfet_01v8_hvt ad=0.0693 pd=0.75 as=0.1176 ps=1.4 w=0.42 l=0.15
X1480 VGND digital_0._067_.A a_8573_4588# VGND sky130_fd_pr__nfet_01v8 ad=0.0567 pd=0.69 as=0.1092 ps=1.36 w=0.42 l=0.15
X1481 VGND digital_0._110_.RESET_B a_6195_4588# VGND sky130_fd_pr__nfet_01v8 ad=0.12495 pd=1.015 as=0.06405 ps=0.725 w=0.42 l=0.15
X1482 a_13322_4588# digital_0._108_.Q a_13101_4915# VGND sky130_fd_pr__nfet_01v8 ad=0.0693 pd=0.75 as=0.09975 ps=0.895 w=0.42 l=0.15
X1483 VDPWR digital_0._105_.RESET_B a_3941_1842# VDPWR sky130_fd_pr__pfet_01v8_hvt ad=0.0819 pd=0.81 as=0.0567 ps=0.69 w=0.42 l=0.15
X1484 a_4637_3827# digital_0.hold23.X a_4637_3500# VGND sky130_fd_pr__nfet_01v8 ad=0.09975 pd=0.895 as=0.0693 ps=0.75 w=0.42 l=0.15
X1485 VGND VDPWR VGND VGND sky130_fd_pr__nfet_01v8 ad=0.143 pd=1.62 as=0 ps=0 w=0.55 l=0.59
X1486 a_12512_5132# digital_0._108_.Q VDPWR VDPWR sky130_fd_pr__pfet_01v8_hvt ad=0.26 pd=2.52 as=0.1625 ps=1.325 w=1 l=0.15
X1487 VGND VDPWR VGND VGND sky130_fd_pr__nfet_01v8 ad=0.143 pd=1.62 as=0 ps=0 w=0.55 l=0.59
X1488 VDPWR digital_0.clkbuf_1_0__f_clk.X a_13541_1874# VDPWR sky130_fd_pr__pfet_01v8_hvt ad=0.0864 pd=0.91 as=0.1664 ps=1.8 w=0.64 l=0.15
X1489 VDPWR digital_0.output13.A a_14759_3500# VDPWR sky130_fd_pr__pfet_01v8_hvt ad=0.0567 pd=0.69 as=0.1092 ps=1.36 w=0.42 l=0.15
X1490 a_12114_4044# a_11900_4044# VDPWR VDPWR sky130_fd_pr__pfet_01v8_hvt ad=0.1155 pd=0.97 as=0.07035 ps=0.755 w=0.42 l=0.15
X1491 VDPWR VGND VDPWR VDPWR sky130_fd_pr__pfet_01v8_hvt ad=0.2262 pd=2.26 as=0 ps=0 w=0.87 l=0.59
X1492 a_7957_4616# digital_0._110_.Q a_7871_4616# VGND sky130_fd_pr__nfet_01v8 ad=0.0567 pd=0.69 as=0.1176 ps=1.4 w=0.42 l=0.15
X1493 LELO_GR01_0.x8.x1.x5.x9<2>.G LELO_GR01_0.x8.x1.x5.x9<2>.G VGND VGND sky130_fd_pr__nfet_01v8_lvt ad=0.3168 pd=1.62 as=0.5088 ps=2.98 w=0.96 l=0.94
R4 uio_oe<6> JNWTR_TIEH_CV_0.Y sky130_fd_pr__res_generic_m4 w=0.3 l=0.3
X1494 a_14915_4588# a_13725_4588# a_14806_4588# VGND sky130_fd_pr__special_nfet_01v8 ad=0.0669 pd=0.75 as=0.0711 ps=0.755 w=0.36 l=0.15
X1495 VGND VGND VGND VGND sky130_fd_pr__nfet_01v8 ad=0.468 pd=2.84 as=0 ps=0 w=0.9 l=0.16
X1496 VGND a_9577_2649# a_9508_2778# VGND sky130_fd_pr__nfet_01v8 ad=0.1346 pd=1.15 as=0.0999 ps=0.985 w=0.64 l=0.15
X1497 LELO_GR01_0.x7.xd1<4>.A LELO_GR01_0.x7.x1.x7.D VDPWR VDPWR sky130_fd_pr__pfet_01v8_lvt ad=0.3168 pd=1.62 as=0.5088 ps=2.98 w=0.96 l=0.94
X1498 a_8671_3276# digital_0._069_.A a_8555_3276# VGND sky130_fd_pr__nfet_01v8 ad=0.08775 pd=0.92 as=0.13975 ps=1.08 w=0.65 l=0.15
X1499 a_13452_4404# digital_0._109_.Q a_13371_4404# VGND sky130_fd_pr__nfet_01v8 ad=0.0441 pd=0.63 as=0.05355 ps=0.675 w=0.42 l=0.15
X1500 a_6457_4044# digital_0._069_.A digital_0._067_.B VDPWR sky130_fd_pr__pfet_01v8_hvt ad=0.26 pd=2.52 as=0.135 ps=1.27 w=1 l=0.15
X1501 uo_out<1> a_14881_5676# VGND VGND sky130_fd_pr__nfet_01v8 ad=0.2079 pd=1.83 as=0.1856 ps=1.26 w=0.42 l=0.15
X1502 VGND a_6343_2930# digital_0.clkload0.A VGND sky130_fd_pr__nfet_01v8 ad=0.0588 pd=0.7 as=0.0588 ps=0.7 w=0.42 l=0.15
X1503 digital_0._116_.SET_B digital_0.load_slew15.X VDPWR VDPWR sky130_fd_pr__pfet_01v8_hvt ad=0.135 pd=1.27 as=0.26 ps=2.52 w=1 l=0.15
X1504 a_11649_1651# a_11467_1651# VDPWR VDPWR sky130_fd_pr__pfet_01v8_hvt ad=0.0441 pd=0.63 as=0.0693 ps=0.75 w=0.42 l=0.15
X1505 VGND digital_0.input3.X digital_0._113_.RESET_B VGND sky130_fd_pr__nfet_01v8 ad=0.08775 pd=0.92 as=0.08775 ps=0.92 w=0.65 l=0.15
X1506 LELO_GR01_0.x7.x3.P a_7796_11234# VGND sky130_fd_pr__res_high_po w=0.36 l=7.36
X1507 VDPWR a_14459_4830# a_14349_4954# VDPWR sky130_fd_pr__pfet_01v8_hvt ad=0.07035 pd=0.755 as=0.1155 ps=0.97 w=0.42 l=0.15
X1508 VDPWR VGND VDPWR VDPWR sky130_fd_pr__pfet_01v8_hvt ad=0.2262 pd=2.26 as=0 ps=0 w=0.87 l=0.59
X1509 VGND a_11416_3500# digital_0.clkbuf_1_0__f_clk.X VGND sky130_fd_pr__nfet_01v8 ad=0.0588 pd=0.7 as=0.0588 ps=0.7 w=0.42 l=0.15
X1510 VGND a_11601_2649# a_11532_2778# VGND sky130_fd_pr__nfet_01v8 ad=0.1346 pd=1.15 as=0.0999 ps=0.985 w=0.64 l=0.15
X1511 a_12405_2172# a_12230_2246# a_12584_2234# VGND sky130_fd_pr__nfet_01v8 ad=0.1092 pd=1.36 as=0.06405 ps=0.725 w=0.42 l=0.15
X1512 VDPWR a_8735_3474# digital_0.clkbuf_1_1__f_clk.A VDPWR sky130_fd_pr__pfet_01v8_hvt ad=0.14 pd=1.28 as=0.14 ps=1.28 w=1 l=0.15
X1513 VDPWR digital_0._067_.A a_7025_5132# VDPWR sky130_fd_pr__pfet_01v8_hvt ad=0.135 pd=1.27 as=0.135 ps=1.27 w=1 l=0.15
X1514 VGND VGND LELO_GR01_0.x7.x15.I1 sky130_fd_pr__pnp_05v5_W3p40L3p40
**devattr s=462400,2720
X1515 LELO_GR01_0.x8.x3.A LELO_GR01_0.x8.x7.D VDPWR VDPWR sky130_fd_pr__pfet_01v8 ad=0.468 pd=2.84 as=0.468 ps=2.84 w=0.9 l=0.16
X1516 VGND digital_0.output13.A a_15289_1324# VGND sky130_fd_pr__nfet_01v8 ad=0.1228 pd=1.065 as=0.1134 ps=1.38 w=0.42 l=0.15
X1517 VGND VDPWR VGND VGND sky130_fd_pr__nfet_01v8 ad=0.143 pd=1.62 as=0 ps=0 w=0.55 l=0.59
X1518 a_17736_18564# a_17520_16644# VGND sky130_fd_pr__res_high_po w=0.36 l=7.36
X1519 digital_0._117_.RESET_B digital_0.load_slew15.X VDPWR VDPWR sky130_fd_pr__pfet_01v8_hvt ad=0.135 pd=1.27 as=0.26 ps=2.52 w=1 l=0.15
X1520 VDPWR VGND VDPWR VDPWR sky130_fd_pr__pfet_01v8_hvt ad=0.2262 pd=2.26 as=0 ps=0 w=0.87 l=0.59
X1521 a_20970_18564# a_20754_16644# VGND sky130_fd_pr__res_high_po w=0.36 l=7.36
X1522 a_9508_2778# a_9382_2680# a_9104_2664# VGND sky130_fd_pr__special_nfet_01v8 ad=0.0999 pd=0.985 as=0.0711 ps=0.755 w=0.36 l=0.15
X1523 a_8389_3276# digital_0._114_.Q a_8389_2956# VDPWR sky130_fd_pr__pfet_01v8_hvt ad=0.26 pd=2.52 as=0.135 ps=1.27 w=1 l=0.15
X1524 a_11496_4176# a_11774_4160# a_11730_4044# VDPWR sky130_fd_pr__pfet_01v8_hvt ad=0.0588 pd=0.7 as=0.0567 ps=0.69 w=0.42 l=0.15
X1525 VGND a_13942_1324# a_14053_1324# VGND sky130_fd_pr__nfet_01v8 ad=0.1856 pd=1.26 as=0.17225 ps=1.83 w=0.65 l=0.25
X1526 a_6633_4825# a_6477_4730# a_6778_4954# VDPWR sky130_fd_pr__pfet_01v8_hvt ad=0.07245 pd=0.765 as=0.1155 ps=0.97 w=0.42 l=0.15
X1527 a_14291_5498# a_14256_5264# a_13969_5106# VGND sky130_fd_pr__nfet_01v8 ad=0.06405 pd=0.725 as=0.1092 ps=1.36 w=0.42 l=0.15
X1528 VGND a_4374_2412# a_4485_2412# VGND sky130_fd_pr__nfet_01v8 ad=0.1856 pd=1.26 as=0.17225 ps=1.83 w=0.65 l=0.25
R5 uio_oe<1> JNWTR_TIEH_CV_0.Y sky130_fd_pr__res_generic_m4 w=0.3 l=0.3
X1529 VGND digital_0.load_slew15.A digital_0._114_.RESET_B VGND sky130_fd_pr__nfet_01v8 ad=0.08775 pd=0.92 as=0.08775 ps=0.92 w=0.65 l=0.15
X1530 VGND digital_0.load_slew15.X digital_0._100_.RESET_B VGND sky130_fd_pr__nfet_01v8 ad=0.169 pd=1.82 as=0.08775 ps=0.92 w=0.65 l=0.15
X1531 a_9577_2649# a_9421_2554# a_9722_2778# VDPWR sky130_fd_pr__pfet_01v8_hvt ad=0.07245 pd=0.765 as=0.1155 ps=0.97 w=0.42 l=0.15
X1532 VDPWR LELO_GR01_0.x7.xd1<4>.A LELO_GR01_0.x7.x15.I2 VDPWR sky130_fd_pr__pfet_01v8_lvt ad=0.5088 pd=2.98 as=0.3168 ps=1.62 w=0.96 l=0.94
X1533 VGND digital_0._116_.Q digital_0._115_.RESET_B VGND sky130_fd_pr__nfet_01v8 ad=0.182 pd=1.86 as=0.08775 ps=0.92 w=0.65 l=0.15
X1534 VGND digital_0.output10.A a_3903_1324# VGND sky130_fd_pr__nfet_01v8 ad=0.0567 pd=0.69 as=0.1092 ps=1.36 w=0.42 l=0.15
X1535 LELO_GR01_0.x8.x5.XA6.A LELO_GR01_0.x8.x5.XA5.A VGND VGND sky130_fd_pr__nfet_01v8 ad=0.468 pd=2.84 as=0.468 ps=2.84 w=0.9 l=0.16
X1536 digital_0._106_.RESET_B digital_0.load_slew17.X VGND VGND sky130_fd_pr__nfet_01v8 ad=0.08775 pd=0.92 as=0.169 ps=1.82 w=0.65 l=0.15
X1537 a_5011_2234# a_4632_1868# a_4939_2234# VGND sky130_fd_pr__nfet_01v8 ad=0.1401 pd=1.1 as=0.0441 ps=0.63 w=0.42 l=0.15
X1538 a_11532_2778# a_11406_2680# a_11128_2664# VGND sky130_fd_pr__special_nfet_01v8 ad=0.0999 pd=0.985 as=0.0711 ps=0.755 w=0.36 l=0.15
X1539 digital_0.clkload0.A a_6343_2930# VGND VGND sky130_fd_pr__nfet_01v8 ad=0.0588 pd=0.7 as=0.0588 ps=0.7 w=0.42 l=0.15
X1540 VGND a_14453_4018# a_14384_4044# VGND sky130_fd_pr__nfet_01v8 ad=0.1346 pd=1.15 as=0.0999 ps=0.985 w=0.64 l=0.15
X1541 a_22470_15064# a_22254_13144# VGND sky130_fd_pr__res_high_po w=0.36 l=7.36
X1542 VDPWR a_12230_2246# a_12405_2172# VDPWR sky130_fd_pr__pfet_01v8_hvt ad=0.1134 pd=1.38 as=0.0567 ps=0.69 w=0.42 l=0.15
X1543 a_14784_1868# a_13707_1874# a_14622_2246# VDPWR sky130_fd_pr__pfet_01v8_hvt ad=0.0567 pd=0.69 as=0.0588 ps=0.7 w=0.42 l=0.15
X1544 VDPWR LELO_GR01_0.x7.xd1<4>.A sky130_fd_pr__cap_mim_m3_1 l=5 w=5
X1545 a_6226_2778# a_6012_2778# VDPWR VDPWR sky130_fd_pr__pfet_01v8_hvt ad=0.1155 pd=0.97 as=0.07035 ps=0.755 w=0.42 l=0.15
X1546 a_11793_5926# digital_0._069_.B digital_0._109_.D VDPWR sky130_fd_pr__pfet_01v8_hvt ad=0.26 pd=2.52 as=0.135 ps=1.27 w=1 l=0.15
X1547 a_4503_2234# a_3941_1842# VGND VGND sky130_fd_pr__nfet_01v8 ad=0.0669 pd=0.75 as=0.12495 ps=1.015 w=0.42 l=0.15
X1548 a_9434_2956# a_9217_2956# VDPWR VDPWR sky130_fd_pr__pfet_01v8_hvt ad=0.2173 pd=2.17 as=0.19265 ps=1.415 w=0.82 l=0.25
X1549 digital_0.hold24.X a_4797_5676# VDPWR VDPWR sky130_fd_pr__pfet_01v8_hvt ad=0.26 pd=2.52 as=0.14075 ps=1.325 w=1 l=0.15
X1550 digital_0._112_.RESET_B digital_0.load_slew17.X a_3437_1574# VDPWR sky130_fd_pr__pfet_01v8_hvt ad=0.135 pd=1.27 as=0.26 ps=2.52 w=1 l=0.15
X1551 VGND digital_0.output7.A a_5169_5676# VGND sky130_fd_pr__nfet_01v8 ad=0.1228 pd=1.065 as=0.1134 ps=1.38 w=0.42 l=0.15
X1552 a_7949_6003# digital_0.hold20.X a_7949_5676# VGND sky130_fd_pr__nfet_01v8 ad=0.09975 pd=0.895 as=0.0693 ps=0.75 w=0.42 l=0.15
X1553 a_8841_1842# a_8685_2110# a_8986_1868# VDPWR sky130_fd_pr__pfet_01v8_hvt ad=0.07245 pd=0.765 as=0.1155 ps=0.97 w=0.42 l=0.15
X1554 digital_0._069_.B digital_0.output13.A a_11715_5452# VGND sky130_fd_pr__nfet_01v8 ad=0.091 pd=0.93 as=0.06825 ps=0.86 w=0.65 l=0.15
X1555 a_7196_4954# a_6438_4856# a_6633_4825# VDPWR sky130_fd_pr__pfet_01v8_hvt ad=0.0651 pd=0.73 as=0.07245 ps=0.765 w=0.42 l=0.15
X1556 a_7916_2412# digital_0._069_.A a_7827_2412# VGND sky130_fd_pr__nfet_01v8 ad=0.0798 pd=0.8 as=0.06195 ps=0.715 w=0.42 l=0.15
X1557 a_10140_2778# a_9382_2680# a_9577_2649# VDPWR sky130_fd_pr__pfet_01v8_hvt ad=0.0651 pd=0.73 as=0.07245 ps=0.765 w=0.42 l=0.15
X1558 VGND a_14297_4286# a_14258_4160# VGND sky130_fd_pr__nfet_01v8 ad=0.0567 pd=0.69 as=0.1092 ps=1.36 w=0.42 l=0.15
X1559 a_25942_18564# a_25726_16644# VGND sky130_fd_pr__res_high_po w=0.36 l=7.36
X1560 VGND VDPWR VGND VGND sky130_fd_pr__nfet_01v8 ad=0.143 pd=1.62 as=0 ps=0 w=0.55 l=0.59
X1561 a_28070_15064# a_28286_13144# VGND sky130_fd_pr__res_high_po w=0.36 l=7.36
X1562 a_13745_3198# digital_0.clkbuf_1_0__f_clk.X VDPWR VDPWR sky130_fd_pr__pfet_01v8_hvt ad=0.1664 pd=1.8 as=0.0864 ps=0.91 w=0.64 l=0.15
X1563 VGND a_13795_5828# digital_0.hold25.X VGND sky130_fd_pr__nfet_01v8 ad=0.097 pd=0.975 as=0.169 ps=1.82 w=0.65 l=0.15
X1564 digital_0.output6.A a_13693_4018# VDPWR VDPWR sky130_fd_pr__pfet_01v8_hvt ad=0.135 pd=1.27 as=0.26 ps=2.52 w=1 l=0.15
X1565 VDPWR digital_0._114_.RESET_B a_9722_2778# VDPWR sky130_fd_pr__pfet_01v8_hvt ad=0.07035 pd=0.755 as=0.1092 ps=1.36 w=0.42 l=0.15
X1566 VDPWR a_10861_3474# digital_0.load_slew15.X VDPWR sky130_fd_pr__pfet_01v8_hvt ad=0.135 pd=1.27 as=0.135 ps=1.27 w=1 l=0.15
X1567 VDPWR a_15506_1324# a_15617_1324# VDPWR sky130_fd_pr__pfet_01v8_hvt ad=0.2726 pd=1.61 as=0.2173 ps=2.17 w=0.82 l=0.25
X1568 digital_0.clkbuf_1_0__f_clk.X a_11416_3500# VGND VGND sky130_fd_pr__nfet_01v8 ad=0.0588 pd=0.7 as=0.0588 ps=0.7 w=0.42 l=0.15
X1569 digital_0.clkbuf_1_0__f_clk.X a_11416_3500# VDPWR VDPWR sky130_fd_pr__pfet_01v8_hvt ad=0.14 pd=1.28 as=0.14 ps=1.28 w=1 l=0.15
X1570 digital_0._114_.RESET_B digital_0.load_slew15.A a_9969_2956# VDPWR sky130_fd_pr__pfet_01v8_hvt ad=0.135 pd=1.27 as=0.26 ps=2.52 w=1 l=0.15
X1571 digital_0._110_.RESET_B digital_0.load_slew17.A VGND VGND sky130_fd_pr__nfet_01v8 ad=0.08775 pd=0.92 as=0.08775 ps=0.92 w=0.65 l=0.15
X1572 VDPWR a_10420_1842# digital_0.input2.X VDPWR sky130_fd_pr__pfet_01v8_hvt ad=0.2726 pd=1.61 as=0.495 ps=2.99 w=1 l=0.15
X1573 VGND a_8685_2110# a_8646_1984# VGND sky130_fd_pr__nfet_01v8 ad=0.0567 pd=0.69 as=0.1092 ps=1.36 w=0.42 l=0.15
X1574 VDPWR a_9421_2554# a_9382_2680# VDPWR sky130_fd_pr__pfet_01v8_hvt ad=0.0864 pd=0.91 as=0.1664 ps=1.8 w=0.64 l=0.15
X1575 digital_0.hold28.X a_12709_2956# VGND VGND sky130_fd_pr__nfet_01v8 ad=0.169 pd=1.82 as=0.097 ps=0.975 w=0.65 l=0.15
X1576 a_3290_8824# a_3506_6904# VGND sky130_fd_pr__res_high_po w=0.36 l=7.36
X1577 a_9404_1868# a_8646_1984# a_8841_1842# VDPWR sky130_fd_pr__pfet_01v8_hvt ad=0.0651 pd=0.73 as=0.07245 ps=0.765 w=0.42 l=0.15
X1578 a_7667_3500# digital_0._065_.A2_N VGND VGND sky130_fd_pr__nfet_01v8 ad=0.06825 pd=0.86 as=0.10725 ps=0.98 w=0.65 l=0.15
X1579 LELO_GR01_0.x8.x5.XA3.MN1.S uo_out<0> VGND VGND sky130_fd_pr__nfet_01v8 ad=0.288 pd=1.54 as=0.468 ps=2.84 w=0.9 l=0.16
X1580 VGND VDPWR VGND VGND sky130_fd_pr__nfet_01v8 ad=0.143 pd=1.62 as=0 ps=0 w=0.55 l=0.59
X1581 VDPWR digital_0._115_.RESET_B a_11746_2778# VDPWR sky130_fd_pr__pfet_01v8_hvt ad=0.07035 pd=0.755 as=0.1092 ps=1.36 w=0.42 l=0.15
X1582 a_10841_2386# a_11128_2664# VDPWR VDPWR sky130_fd_pr__pfet_01v8_hvt ad=0.0567 pd=0.69 as=0.1134 ps=1.38 w=0.42 l=0.15
X1583 digital_0._069_.A a_13132_4276# VDPWR VDPWR sky130_fd_pr__pfet_01v8_hvt ad=0.135 pd=1.27 as=0.26 ps=2.52 w=1 l=0.15
X1584 a_8735_3474# clk VDPWR VDPWR sky130_fd_pr__pfet_01v8_hvt ad=0.14 pd=1.28 as=0.14 ps=1.28 w=1 l=0.15
X1585 a_6633_4825# a_6438_4856# a_6943_4588# VGND sky130_fd_pr__special_nfet_01v8 ad=0.0594 pd=0.69 as=0.1401 ps=1.1 w=0.36 l=0.15
X1586 VDPWR a_6477_4730# a_6438_4856# VDPWR sky130_fd_pr__pfet_01v8_hvt ad=0.0864 pd=0.91 as=0.1664 ps=1.8 w=0.64 l=0.15
X1587 VGND a_7529_5106# digital_0.output8.A VGND sky130_fd_pr__nfet_01v8 ad=0.2087 pd=2.02 as=0.08775 ps=0.92 w=0.65 l=0.15
X1588 digital_0._115_.Q a_10841_2386# VGND VGND sky130_fd_pr__nfet_01v8 ad=0.08775 pd=0.92 as=0.169 ps=1.82 w=0.65 l=0.15
X1589 VGND VDPWR VGND VGND sky130_fd_pr__nfet_01v8 ad=0.143 pd=1.62 as=0 ps=0 w=0.55 l=0.59
X1590 LELO_GR01_0.x8.x5.XA5.A LELO_GR01_0.x8.x5.XA7.CN LELO_GR01_0.x8.x5.XA3.MP1.S LELO_GR01_0.x8.x8.D sky130_fd_pr__pfet_01v8 ad=0.468 pd=2.84 as=0.288 ps=1.54 w=0.9 l=0.16
X1591 a_4691_5676# a_4455_5676# VDPWR VDPWR sky130_fd_pr__pfet_01v8_hvt ad=0.1092 pd=1.36 as=0.0567 ps=0.69 w=0.42 l=0.5
X1592 a_5608_2664# a_5886_2680# a_5842_2778# VDPWR sky130_fd_pr__pfet_01v8_hvt ad=0.0588 pd=0.7 as=0.0567 ps=0.69 w=0.42 l=0.15
X1593 VDPWR digital_0._060_.A_N a_11592_2956# VDPWR sky130_fd_pr__pfet_01v8_hvt ad=0.1625 pd=1.325 as=0.135 ps=1.27 w=1 l=0.15
X1594 a_8655_4910# digital_0._067_.A VDPWR VDPWR sky130_fd_pr__pfet_01v8_hvt ad=0.0864 pd=0.91 as=0.1664 ps=1.8 w=0.64 l=0.15
X1595 a_4355_5498# a_4320_5264# a_4033_5106# VGND sky130_fd_pr__nfet_01v8 ad=0.06405 pd=0.725 as=0.1092 ps=1.36 w=0.42 l=0.15
X1596 a_14079_2412# digital_0._116_.D VDPWR VDPWR sky130_fd_pr__pfet_01v8_hvt ad=0.12495 pd=1.175 as=0.2184 ps=2.2 w=0.84 l=0.15
X1597 a_6475_5430# digital_0.hold28.A VGND VGND sky130_fd_pr__nfet_01v8 ad=0.1092 pd=1.36 as=0.1449 ps=1.11 w=0.42 l=0.15
X1598 a_14998_2412# a_14876_2626# a_14926_2412# VGND sky130_fd_pr__nfet_01v8 ad=0.0441 pd=0.63 as=0.0441 ps=0.63 w=0.42 l=0.15
X1599 a_14133_3827# a_13951_3827# VDPWR VDPWR sky130_fd_pr__pfet_01v8_hvt ad=0.0441 pd=0.63 as=0.0693 ps=0.75 w=0.42 l=0.15
X1600 a_10137_4838# digital_0._116_.Q VDPWR VDPWR sky130_fd_pr__pfet_01v8_hvt ad=0.135 pd=1.27 as=0.135 ps=1.27 w=1 l=0.15
X1601 VDPWR digital_0.hold28.A a_7695_6003# VDPWR sky130_fd_pr__pfet_01v8_hvt ad=0.0693 pd=0.75 as=0.1176 ps=1.4 w=0.42 l=0.15
X1602 JNWTR_ORX1_CV_0.A a_15617_1324# VGND VGND sky130_fd_pr__nfet_01v8 ad=0.2079 pd=1.83 as=0.1856 ps=1.26 w=0.42 l=0.15
R6 uio_oe<7> JNWTR_TIEH_CV_0.Y sky130_fd_pr__res_generic_m4 w=0.3 l=0.3
X1603 VDPWR a_5386_5676# a_5497_5676# VDPWR sky130_fd_pr__pfet_01v8_hvt ad=0.2726 pd=1.61 as=0.2173 ps=2.17 w=0.82 l=0.25
X1604 VGND a_7547_4018# digital_0._065_.A2_N VGND sky130_fd_pr__nfet_01v8 ad=0.1118 pd=1.04 as=0.12675 ps=1.04 w=0.65 l=0.15
X1605 VGND digital_0.clkbuf_1_1__f_clk.A a_6343_2930# VGND sky130_fd_pr__nfet_01v8 ad=0.1113 pd=1.37 as=0.0588 ps=0.7 w=0.42 l=0.15
X1606 VGND rst_n sky130_fd_pr__diode_pw2nd_05v5 perim=1.8e+06 area=2.025e+11
X1607 a_22266_18564# a_22050_16644# VGND sky130_fd_pr__res_high_po w=0.36 l=7.36
X1608 digital_0.clkload0.X a_7253_2386# VGND VGND sky130_fd_pr__nfet_01v8 ad=0.0588 pd=0.7 as=0.0588 ps=0.7 w=0.42 l=0.15
X1609 VGND a_8735_3474# digital_0.clkbuf_1_1__f_clk.A VGND sky130_fd_pr__nfet_01v8 ad=0.0588 pd=0.7 as=0.0588 ps=0.7 w=0.42 l=0.15
X1610 LELO_GR01_0.x7.x1.x5.x9<2>.G LELO_GR01_0.x7.x1.x5.x8.G LELO_GR01_0.x7.x1.x5.x6.N LELO_GR01_0.x7.x1.x5.x6.N sky130_fd_pr__pfet_01v8_lvt ad=0.3168 pd=1.62 as=0.5088 ps=2.98 w=0.96 l=0.94
X1611 digital_0.hold22.X a_13261_2412# VGND VGND sky130_fd_pr__nfet_01v8 ad=0.169 pd=1.82 as=0.097 ps=0.975 w=0.65 l=0.15
X1612 VGND digital_0.clkbuf_1_1__f_clk.A a_11416_3500# VGND sky130_fd_pr__nfet_01v8 ad=0.0588 pd=0.7 as=0.0588 ps=0.7 w=0.42 l=0.15
X1613 VGND digital_0.output10.A a_7009_1324# VGND sky130_fd_pr__nfet_01v8 ad=0.1228 pd=1.065 as=0.1134 ps=1.38 w=0.42 l=0.15
X1614 VDPWR a_4637_5374# a_4598_5248# VDPWR sky130_fd_pr__pfet_01v8_hvt ad=0.0864 pd=0.91 as=0.1664 ps=1.8 w=0.64 l=0.15
X1615 a_12154_5452# digital_0.output13.A VGND VGND sky130_fd_pr__nfet_01v8 ad=0.08775 pd=0.92 as=0.17875 ps=1.85 w=0.65 l=0.15
X1616 a_6160_4840# a_6477_4730# a_6435_4588# VGND sky130_fd_pr__special_nfet_01v8 ad=0.0711 pd=0.755 as=0.0669 ps=0.75 w=0.36 l=0.15
X1617 a_7547_4018# digital_0._111_.Q a_7793_4382# VGND sky130_fd_pr__nfet_01v8 ad=0.1176 pd=1.4 as=0.0567 ps=0.69 w=0.42 l=0.15
X1618 VGND a_10861_3474# digital_0.load_slew15.X VGND sky130_fd_pr__nfet_01v8 ad=0.08775 pd=0.92 as=0.08775 ps=0.92 w=0.65 l=0.15
X1619 VDPWR a_12677_1298# a_12419_1298# VDPWR sky130_fd_pr__pfet_01v8_hvt ad=0.0567 pd=0.69 as=0.1092 ps=1.36 w=0.42 l=0.5
X1620 VGND VDPWR VGND VGND sky130_fd_pr__nfet_01v8 ad=0.143 pd=1.62 as=0 ps=0 w=0.55 l=0.59
X1621 uo_out<0> LELO_GR01_0.x8.x5.XA7.C LELO_GR01_0.x8.x5.XA7.MP1.S VGND sky130_fd_pr__nfet_01v8 ad=0.468 pd=2.84 as=0.288 ps=1.54 w=0.9 l=0.16
X1622 a_9650_13154# a_9434_11234# VGND sky130_fd_pr__res_high_po w=0.36 l=7.36
X1623 LELO_GR01_0.x7.x1.x5.x6.N a_10472_19784# VGND sky130_fd_pr__res_high_po w=0.36 l=7.36
X1624 VGND LELO_GR01_0.x7.x1.x5.x9<2>.G LELO_GR01_0.x7.x1.x5.IBN VGND sky130_fd_pr__nfet_01v8_lvt ad=0.5088 pd=2.98 as=0.3168 ps=1.62 w=0.96 l=0.94
X1625 VDPWR LELO_GR01_0.x7.xd1<4>.A LELO_GR01_0.x7.x15.I2 VDPWR sky130_fd_pr__pfet_01v8_lvt ad=0.5088 pd=2.98 as=0.3168 ps=1.62 w=0.96 l=0.94
X1626 VGND a_6738_1298# a_6498_1482# VGND sky130_fd_pr__nfet_01v8 ad=0.1228 pd=1.065 as=0.17225 ps=1.83 w=0.65 l=0.25
X1627 LELO_GR01_0.x7.xd1<4>.A LELO_GR01_0.x7.x18.D LELO_GR01_0.x7.x6<3>.G VGND sky130_fd_pr__nfet_01v8_lvt ad=0.3168 pd=1.62 as=0.5088 ps=2.98 w=0.96 l=0.94
X1628 uio_out<2> a_5497_5676# VGND VGND sky130_fd_pr__nfet_01v8 ad=0.2079 pd=1.83 as=0.1856 ps=1.26 w=0.42 l=0.15
X1629 a_4724_5132# a_4637_5374# a_4320_5264# VDPWR sky130_fd_pr__pfet_01v8_hvt ad=0.12915 pd=1.185 as=0.0588 ps=0.7 w=0.42 l=0.15
X1630 a_11942_1324# digital_0._115_.Q a_11721_1651# VGND sky130_fd_pr__nfet_01v8 ad=0.0693 pd=0.75 as=0.09975 ps=0.895 w=0.42 l=0.15
X1631 a_11592_2956# a_11234_3276# digital_0._115_.D VDPWR sky130_fd_pr__pfet_01v8_hvt ad=0.28 pd=2.56 as=0.135 ps=1.27 w=1 l=0.15
X1632 a_13795_5828# a_13891_5650# VGND VGND sky130_fd_pr__nfet_01v8 ad=0.1092 pd=1.36 as=0.097 ps=0.975 w=0.42 l=0.5
X1633 LELO_GR01_0.x8.x5.XA7.C VDPWR LELO_GR01_0.x8.x5.XA1.MN1.S VGND sky130_fd_pr__nfet_01v8 ad=0.468 pd=2.84 as=0.288 ps=1.54 w=0.9 l=0.16
X1634 a_27238_18564# a_27022_16644# VGND sky130_fd_pr__res_high_po w=0.36 l=7.36
X1635 a_6475_5430# digital_0.hold28.A VDPWR VDPWR sky130_fd_pr__pfet_01v8_hvt ad=0.1176 pd=1.4 as=0.0693 ps=0.75 w=0.42 l=0.15
X1636 VGND digital_0.output11.A a_7767_1324# VGND sky130_fd_pr__nfet_01v8 ad=0.0567 pd=0.69 as=0.1092 ps=1.36 w=0.42 l=0.15
X1637 digital_0.clkbuf_1_1__f_clk.A a_8735_3474# VGND VGND sky130_fd_pr__nfet_01v8 ad=0.0588 pd=0.7 as=0.0588 ps=0.7 w=0.42 l=0.15
X1638 VGND VDPWR VGND VGND sky130_fd_pr__nfet_01v8 ad=0.143 pd=1.62 as=0 ps=0 w=0.55 l=0.59
X1639 LELO_GR01_0.x7.x15.I2 LELO_GR01_0.x7.xd1<4>.A VDPWR VDPWR sky130_fd_pr__pfet_01v8_lvt ad=0.3168 pd=1.62 as=0.5088 ps=2.98 w=0.96 l=0.94
X1640 a_7302_1868# digital_0._113_.Q VDPWR VDPWR sky130_fd_pr__pfet_01v8_hvt ad=0.275 pd=2.55 as=0.135 ps=1.27 w=1 l=0.15
X1641 digital_0._112_.D digital_0._063_.A VGND VGND sky130_fd_pr__nfet_01v8 ad=0.08775 pd=0.92 as=0.08775 ps=0.92 w=0.65 l=0.15
X1642 VDPWR VGND VDPWR VDPWR sky130_fd_pr__pfet_01v8_hvt ad=0.2262 pd=2.26 as=0 ps=0 w=0.87 l=0.59
X1643 a_9338_2778# a_8817_2386# VDPWR VDPWR sky130_fd_pr__pfet_01v8_hvt ad=0.0567 pd=0.69 as=0.0819 ps=0.81 w=0.42 l=0.15
X1644 LELO_GR01_0.x8.x1.x7.D LELO_GR01_0.x8.IBP_BG LELO_GR01_0.x8.x1.x5.IBN VGND sky130_fd_pr__nfet_01v8_lvt ad=0.3168 pd=1.62 as=0.5088 ps=2.98 w=0.96 l=0.94
X1645 a_6457_4044# digital_0._110_.Q VDPWR VDPWR sky130_fd_pr__pfet_01v8_hvt ad=0.135 pd=1.27 as=0.135 ps=1.27 w=1 l=0.15
X1646 a_10786_1298# digital_0.output12.A VDPWR VDPWR sky130_fd_pr__pfet_01v8_hvt ad=0.27 pd=2.54 as=0.19265 ps=1.415 w=1 l=0.15
X1647 LELO_GR01_0.x7.x23.D LELO_GR01_0.x8.PWRUP_N_1V8 LELO_GR01_0.x7.x22.D VDPWR sky130_fd_pr__pfet_01v8_lvt ad=0.5088 pd=2.98 as=0.3168 ps=1.62 w=0.96 l=0.94
X1648 a_12164_2778# a_11445_2554# a_11601_2649# VGND sky130_fd_pr__special_nfet_01v8 ad=0.066 pd=0.745 as=0.0594 ps=0.69 w=0.36 l=0.15
X1649 VDPWR a_8817_2386# digital_0._114_.Q VDPWR sky130_fd_pr__pfet_01v8_hvt ad=0.3012 pd=2.66 as=0.135 ps=1.27 w=1 l=0.15
X1650 a_11900_4044# a_11774_4160# a_11496_4176# VGND sky130_fd_pr__special_nfet_01v8 ad=0.0999 pd=0.985 as=0.0711 ps=0.755 w=0.36 l=0.15
X1651 VDPWR a_4793_5106# a_4724_5132# VDPWR sky130_fd_pr__pfet_01v8_hvt ad=0.2184 pd=2.2 as=0.12915 ps=1.185 w=0.84 l=0.15
X1652 VDPWR a_7226_1324# a_7337_1324# VDPWR sky130_fd_pr__pfet_01v8_hvt ad=0.2726 pd=1.61 as=0.2173 ps=2.17 w=0.82 l=0.25
X1653 VDPWR digital_0._060_.B a_9862_1690# VDPWR sky130_fd_pr__pfet_01v8_hvt ad=0.22895 pd=1.745 as=0.0609 ps=0.71 w=0.42 l=0.15
X1654 a_15506_2956# a_15289_2956# VGND VGND sky130_fd_pr__nfet_01v8 ad=0.17225 pd=1.83 as=0.1228 ps=1.065 w=0.65 l=0.25
X1655 a_14531_5498# a_13969_5106# VGND VGND sky130_fd_pr__nfet_01v8 ad=0.0669 pd=0.75 as=0.12495 ps=1.015 w=0.42 l=0.15
X1656 LELO_GR01_0.x7.x1.x5.x9<2>.G LELO_GR01_0.x7.x1.x5.x8.G LELO_GR01_0.x7.x1.x5.x8.G VGND sky130_fd_pr__nfet_01v8_lvt ad=0.5088 pd=2.98 as=0.3168 ps=1.62 w=0.96 l=0.94
X1657 a_13428_3088# a_13706_3072# a_13662_2956# VDPWR sky130_fd_pr__pfet_01v8_hvt ad=0.0588 pd=0.7 as=0.0567 ps=0.69 w=0.42 l=0.15
X1658 digital_0._065_.A2_N a_7547_4018# VGND VGND sky130_fd_pr__nfet_01v8 ad=0.12675 pd=1.04 as=0.247 ps=2.06 w=0.65 l=0.15
X1659 a_15292_5132# a_14573_5374# a_14729_5106# VGND sky130_fd_pr__special_nfet_01v8 ad=0.066 pd=0.745 as=0.0594 ps=0.69 w=0.36 l=0.15
X1660 digital_0._105_.RESET_B digital_0.load_slew17.X VGND VGND sky130_fd_pr__nfet_01v8 ad=0.08775 pd=0.92 as=0.169 ps=1.82 w=0.65 l=0.15
X1661 a_13101_4915# digital_0._108_.Q a_13029_4915# VDPWR sky130_fd_pr__pfet_01v8_hvt ad=0.1932 pd=1.34 as=0.0441 ps=0.63 w=0.42 l=0.15
X1662 a_8986_4044# a_8772_4044# VDPWR VDPWR sky130_fd_pr__pfet_01v8_hvt ad=0.1155 pd=0.97 as=0.07035 ps=0.755 w=0.42 l=0.15
X1663 digital_0._111_.RESET_B digital_0._116_.Q VGND VGND sky130_fd_pr__nfet_01v8 ad=0.08775 pd=0.92 as=0.08775 ps=0.92 w=0.65 l=0.15
X1664 digital_0._110_.D digital_0._067_.B a_7025_5132# VDPWR sky130_fd_pr__pfet_01v8_hvt ad=0.135 pd=1.27 as=0.26 ps=2.52 w=1 l=0.15
X1665 VDPWR a_6372_1298# uio_out<6> VDPWR sky130_fd_pr__pfet_01v8_hvt ad=0.2726 pd=1.61 as=0.495 ps=2.99 w=1 l=0.15
X1666 VGND digital_0.output5.A a_15289_5676# VGND sky130_fd_pr__nfet_01v8 ad=0.1228 pd=1.065 as=0.1134 ps=1.38 w=0.42 l=0.15
X1667 VDPWR a_10841_2386# digital_0._115_.Q VDPWR sky130_fd_pr__pfet_01v8_hvt ad=0.3012 pd=2.66 as=0.135 ps=1.27 w=1 l=0.15
X1668 VGND a_6343_2930# digital_0.clkload0.A VGND sky130_fd_pr__nfet_01v8 ad=0.0588 pd=0.7 as=0.0588 ps=0.7 w=0.42 l=0.15
X1669 VDPWR VGND VDPWR VDPWR sky130_fd_pr__pfet_01v8_hvt ad=0.2262 pd=2.26 as=0 ps=0 w=0.87 l=0.59
X1670 VDPWR VGND VDPWR VDPWR sky130_fd_pr__pfet_01v8_hvt ad=0.2262 pd=2.26 as=0 ps=0 w=0.87 l=0.59
X1671 VDPWR a_9577_2649# a_9508_2778# VDPWR sky130_fd_pr__pfet_01v8_hvt ad=0.2184 pd=2.2 as=0.12915 ps=1.185 w=0.84 l=0.15
X1672 VGND digital_0.input2.X digital_0._080_.A2 VGND sky130_fd_pr__nfet_01v8 ad=0.169 pd=1.82 as=0.08775 ps=0.92 w=0.65 l=0.15
X1673 VGND digital_0.clkbuf_1_0__f_clk.X a_13725_4588# VGND sky130_fd_pr__nfet_01v8 ad=0.0567 pd=0.69 as=0.1092 ps=1.36 w=0.42 l=0.15
X1674 VDPWR digital_0.output4.A a_14553_5676# VDPWR sky130_fd_pr__pfet_01v8_hvt ad=0.19265 pd=1.415 as=0.27 ps=2.54 w=1 l=0.15
X1675 uo_out<0> LELO_GR01_0.x8.x5.XA7.CN LELO_GR01_0.x8.x5.XA6.MN1.S VGND sky130_fd_pr__nfet_01v8 ad=0.468 pd=2.84 as=0.288 ps=1.54 w=0.9 l=0.16
X1676 VGND a_4545_2110# a_4506_1984# VGND sky130_fd_pr__nfet_01v8 ad=0.0567 pd=0.69 as=0.1092 ps=1.36 w=0.42 l=0.15
X1677 digital_0.output5.A a_14981_4562# VDPWR VDPWR sky130_fd_pr__pfet_01v8_hvt ad=0.135 pd=1.27 as=0.3012 ps=2.66 w=1 l=0.15
X1678 LELO_GR01_0.x8.x1.x5.IBN LELO_GR01_0.x8.x1.x5.x9<2>.G VGND VGND sky130_fd_pr__nfet_01v8_lvt ad=0.3168 pd=1.62 as=0.5088 ps=2.98 w=0.96 l=0.94
X1679 VGND digital_0._105_.D a_5264_1868# VGND sky130_fd_pr__nfet_01v8 ad=0.2205 pd=1.89 as=0.066 ps=0.745 w=0.42 l=0.15
X1680 a_8003_1324# a_7767_1324# VDPWR VDPWR sky130_fd_pr__pfet_01v8_hvt ad=0.1092 pd=1.36 as=0.0567 ps=0.69 w=0.42 l=0.5
X1681 a_11900_4044# a_11813_4286# a_11496_4176# VDPWR sky130_fd_pr__pfet_01v8_hvt ad=0.12915 pd=1.185 as=0.0588 ps=0.7 w=0.42 l=0.15
X1682 digital_0._067_.B digital_0._110_.Q VGND VGND sky130_fd_pr__nfet_01v8 ad=0.08775 pd=0.92 as=0.182 ps=1.86 w=0.65 l=0.15
X1683 a_14337_4588# a_13891_4588# a_14241_4588# VGND sky130_fd_pr__special_nfet_01v8 ad=0.1401 pd=1.1 as=0.0594 ps=0.69 w=0.36 l=0.15
X1684 a_6319_3500# digital_0._113_.RESET_B VGND VGND sky130_fd_pr__nfet_01v8 ad=0.0441 pd=0.63 as=0.1346 ps=1.15 w=0.42 l=0.15
X1685 VDPWR VGND VDPWR VDPWR sky130_fd_pr__pfet_01v8_hvt ad=0.2262 pd=2.26 as=0 ps=0 w=0.87 l=0.59
X1686 a_8793_4562# digital_0._065_.A2_N VDPWR VDPWR sky130_fd_pr__pfet_01v8_hvt ad=0.173 pd=1.4 as=0.2272 ps=1.35 w=0.64 l=0.15
X1687 VDPWR a_6081_3737# a_6012_3866# VDPWR sky130_fd_pr__pfet_01v8_hvt ad=0.2184 pd=2.2 as=0.12915 ps=1.185 w=0.84 l=0.15
X1688 VDPWR digital_0._108_.Q a_11433_5132# VDPWR sky130_fd_pr__pfet_01v8_hvt ad=0.135 pd=1.27 as=0.135 ps=1.27 w=1 l=0.15
X1689 VDPWR VGND VDPWR VDPWR sky130_fd_pr__pfet_01v8_hvt ad=0.2262 pd=2.26 as=0 ps=0 w=0.87 l=0.59
X1690 uio_out<5> a_7337_1324# VGND VGND sky130_fd_pr__nfet_01v8 ad=0.2079 pd=1.83 as=0.1856 ps=1.26 w=0.42 l=0.15
X1691 LELO_GR01_0.x8.x1.x5.x6.N a_22292_11483# VGND sky130_fd_pr__res_high_po w=0.36 l=7.36
X1692 VGND VDPWR VGND VGND sky130_fd_pr__nfet_01v8 ad=0.143 pd=1.62 as=0 ps=0 w=0.55 l=0.59
X1693 a_14284_2412# a_13891_2412# a_14174_2412# VGND sky130_fd_pr__special_nfet_01v8 ad=0.06705 pd=0.75 as=0.072 ps=0.76 w=0.36 l=0.15
X1694 LELO_GR01_0.x8.x8.D LELO_GR01_0.x8.PWRUP_N_1V8 VDPWR VDPWR sky130_fd_pr__pfet_01v8_lvt ad=0.3168 pd=1.62 as=0.5088 ps=2.98 w=0.96 l=0.94
X1695 VGND a_6343_2930# digital_0.clkload0.A VGND sky130_fd_pr__nfet_01v8 ad=0.0588 pd=0.7 as=0.0588 ps=0.7 w=0.42 l=0.15
X1696 a_11592_3276# digital_0._115_.Q VGND VGND sky130_fd_pr__nfet_01v8 ad=0.08775 pd=0.92 as=0.08775 ps=0.92 w=0.65 l=0.15
X1697 a_9577_2649# a_9382_2680# a_9887_2412# VGND sky130_fd_pr__special_nfet_01v8 ad=0.0594 pd=0.69 as=0.1401 ps=1.1 w=0.36 l=0.15
X1698 VGND a_8735_3474# digital_0.clkbuf_1_1__f_clk.A VGND sky130_fd_pr__nfet_01v8 ad=0.0588 pd=0.7 as=0.0588 ps=0.7 w=0.42 l=0.15
X1699 a_11839_2412# digital_0._115_.RESET_B VGND VGND sky130_fd_pr__nfet_01v8 ad=0.0441 pd=0.63 as=0.1346 ps=1.15 w=0.42 l=0.15
X1700 VDPWR VGND VDPWR VDPWR sky130_fd_pr__pfet_01v8_hvt ad=0.2262 pd=2.26 as=0 ps=0 w=0.87 l=0.59
X1701 a_10514_13154# a_10298_11234# VGND sky130_fd_pr__res_high_po w=0.36 l=7.36
X1702 VDPWR a_7745_2412# digital_0._060_.A_N VDPWR sky130_fd_pr__pfet_01v8_hvt ad=0.3 pd=2.6 as=0.165 ps=1.33 w=1 l=0.15
X1703 a_4033_5106# a_4320_5264# VDPWR VDPWR sky130_fd_pr__pfet_01v8_hvt ad=0.0567 pd=0.69 as=0.1134 ps=1.38 w=0.42 l=0.15
X1704 LELO_GR01_0.x7.x24.D LELO_GR01_0.x8.PWRUP_N_1V8 LELO_GR01_0.x7.x25.D VDPWR sky130_fd_pr__pfet_01v8_lvt ad=0.3168 pd=1.62 as=0.5088 ps=2.98 w=0.96 l=0.94
X1705 VDPWR a_11601_2649# a_11532_2778# VDPWR sky130_fd_pr__pfet_01v8_hvt ad=0.2184 pd=2.2 as=0.12915 ps=1.185 w=0.84 l=0.15
X1706 VGND digital_0._109_.Q digital_0._069_.B VGND sky130_fd_pr__nfet_01v8 ad=0.10725 pd=0.98 as=0.08775 ps=0.92 w=0.65 l=0.15
X1707 LELO_GR01_0.x7.x1.x5.IBN LELO_GR01_0.x7.x7.G LELO_GR01_0.x7.x1.x7.D VGND sky130_fd_pr__nfet_01v8_lvt ad=0.5088 pd=2.98 as=0.3168 ps=1.62 w=0.96 l=0.94
X1708 a_9116_8824# a_9332_6904# VGND sky130_fd_pr__res_high_po w=0.36 l=7.36
X1709 a_8368_4176# a_8646_4160# a_8602_4044# VDPWR sky130_fd_pr__pfet_01v8_hvt ad=0.0588 pd=0.7 as=0.0567 ps=0.69 w=0.42 l=0.15
X1710 a_6871_4588# digital_0._110_.RESET_B VGND VGND sky130_fd_pr__nfet_01v8 ad=0.0441 pd=0.63 as=0.1346 ps=1.15 w=0.42 l=0.15
X1711 a_13132_4276# digital_0._108_.Q VDPWR VDPWR sky130_fd_pr__pfet_01v8_hvt ad=0.07438 pd=0.815 as=0.15075 ps=1.345 w=0.42 l=0.15
X1712 VDPWR VGND VDPWR VDPWR sky130_fd_pr__pfet_01v8_hvt ad=0.2262 pd=2.26 as=0 ps=0 w=0.87 l=0.59
X1713 a_11873_5452# digital_0.output13.A digital_0._069_.B VGND sky130_fd_pr__nfet_01v8 ad=0.08937 pd=0.925 as=0.091 ps=0.93 w=0.65 l=0.15
X1714 a_7253_2386# digital_0.clkload0.A VDPWR VDPWR sky130_fd_pr__pfet_01v8_hvt ad=0.265 pd=2.53 as=0.165 ps=1.33 w=1 l=0.15
X1715 LELO_GR01_0.x8.VREF_BG a_19248_16644# VGND sky130_fd_pr__res_high_po w=0.36 l=7.36
X1716 VDPWR digital_0.clkload0.A a_11149_1874# VDPWR sky130_fd_pr__pfet_01v8_hvt ad=0.0864 pd=0.91 as=0.1664 ps=1.8 w=0.64 l=0.15
X1717 a_14573_5374# digital_0.clkbuf_1_0__f_clk.X VDPWR VDPWR sky130_fd_pr__pfet_01v8_hvt ad=0.1664 pd=1.8 as=0.0864 ps=0.91 w=0.64 l=0.15
X1718 LELO_GR01_0.x8.x5.XA4.MN1.S LELO_GR01_0.x8.x5.XA6.A VGND VGND sky130_fd_pr__nfet_01v8 ad=0.288 pd=1.54 as=0.468 ps=2.84 w=0.9 l=0.16
X1719 VDPWR digital_0._108_.D a_12532_4044# VDPWR sky130_fd_pr__pfet_01v8_hvt ad=0.1092 pd=1.36 as=0.0651 ps=0.73 w=0.42 l=0.15
X1720 VDPWR a_15506_5676# a_15617_5676# VDPWR sky130_fd_pr__pfet_01v8_hvt ad=0.2726 pd=1.61 as=0.2173 ps=2.17 w=0.82 l=0.25
X1721 digital_0._109_.RESET_B digital_0.load_slew15.A VGND VGND sky130_fd_pr__nfet_01v8 ad=0.08775 pd=0.92 as=0.169 ps=1.82 w=0.65 l=0.15
X1722 LELO_GR01_0.x7.xd1<4>.A LELO_GR01_0.x7.x18.D LELO_GR01_0.x7.x6<3>.G VGND sky130_fd_pr__nfet_01v8_lvt ad=0.3168 pd=1.62 as=0.5088 ps=2.98 w=0.96 l=0.94
X1723 a_5356_5132# a_4637_5374# a_4793_5106# VGND sky130_fd_pr__special_nfet_01v8 ad=0.066 pd=0.745 as=0.0594 ps=0.69 w=0.36 l=0.15
X1724 digital_0._110_.RESET_B digital_0._116_.Q VGND VGND sky130_fd_pr__nfet_01v8 ad=0.08775 pd=0.92 as=0.182 ps=1.86 w=0.65 l=0.15
X1725 VGND a_3941_1842# digital_0.output10.A VGND sky130_fd_pr__nfet_01v8 ad=0.2087 pd=2.02 as=0.08775 ps=0.92 w=0.65 l=0.15
X1726 a_11234_3276# digital_0._060_.A_N VGND VGND sky130_fd_pr__nfet_01v8 ad=0.08775 pd=0.92 as=0.08775 ps=0.92 w=0.65 l=0.15
X1727 VDPWR a_11416_3500# digital_0.clkbuf_1_0__f_clk.X VDPWR sky130_fd_pr__pfet_01v8_hvt ad=0.1375 pd=1.275 as=0.14 ps=1.28 w=1 l=0.15
X1728 LELO_GR01_0.x8.IBP_BG VGND sky130_fd_pr__cap_mim_m3_1 l=5 w=5
X1729 VDPWR VGND VDPWR VDPWR sky130_fd_pr__pfet_01v8_hvt ad=0.2262 pd=2.26 as=0 ps=0 w=0.87 l=0.59
X1730 a_6778_4954# a_6564_4954# VDPWR VDPWR sky130_fd_pr__pfet_01v8_hvt ad=0.1155 pd=0.97 as=0.07035 ps=0.755 w=0.42 l=0.15
X1731 VGND a_5321_3474# digital_0._113_.Q VGND sky130_fd_pr__nfet_01v8 ad=0.2087 pd=2.02 as=0.08775 ps=0.92 w=0.65 l=0.15
X1732 digital_0.clkbuf_1_1__f_clk.A a_8735_3474# VGND VGND sky130_fd_pr__nfet_01v8 ad=0.0588 pd=0.7 as=0.0588 ps=0.7 w=0.42 l=0.15
X1733 VGND VDPWR VGND VGND sky130_fd_pr__nfet_01v8 ad=0.143 pd=1.62 as=0 ps=0 w=0.55 l=0.59
X1734 LELO_GR01_0.x8.x1.x5.x8.S LELO_GR01_0.x8.x1.x5.x8.G LELO_GR01_0.x8.x1.x5.x8.G LELO_GR01_0.x8.x1.x5.x8.S sky130_fd_pr__pfet_01v8_lvt ad=0.5088 pd=2.98 as=0.3168 ps=1.62 w=0.96 l=0.94
X1735 VGND a_5873_4562# digital_0._110_.Q VGND sky130_fd_pr__nfet_01v8 ad=0.2087 pd=2.02 as=0.08775 ps=0.92 w=0.65 l=0.15
X1736 a_4139_1324# a_3903_1324# VDPWR VDPWR sky130_fd_pr__pfet_01v8_hvt ad=0.1092 pd=1.36 as=0.0567 ps=0.69 w=0.42 l=0.5
X1737 VDPWR digital_0._115_.Q a_11592_2956# VDPWR sky130_fd_pr__pfet_01v8_hvt ad=0.135 pd=1.27 as=0.26 ps=2.52 w=1 l=0.15
X1738 LELO_GR01_0.x8.IBP_BG VGND sky130_fd_pr__cap_mim_m3_1 l=5 w=5
X1739 VGND a_6475_5430# a_6409_5498# VGND sky130_fd_pr__nfet_01v8 ad=0.1449 pd=1.11 as=0.0693 ps=0.75 w=0.42 l=0.15
X1740 a_6012_2778# a_5925_2554# a_5608_2664# VDPWR sky130_fd_pr__pfet_01v8_hvt ad=0.12915 pd=1.185 as=0.0588 ps=0.7 w=0.42 l=0.15
X1741 VDPWR VGND VDPWR VDPWR sky130_fd_pr__pfet_01v8_hvt ad=0.2262 pd=2.26 as=0 ps=0 w=0.87 l=0.59
X1742 a_3711_3322# a_3676_3088# a_3389_2930# VGND sky130_fd_pr__nfet_01v8 ad=0.06405 pd=0.725 as=0.1092 ps=1.36 w=0.42 l=0.15
X1743 a_4387_3322# digital_0._104_.RESET_B VGND VGND sky130_fd_pr__nfet_01v8 ad=0.0441 pd=0.63 as=0.1346 ps=1.15 w=0.42 l=0.15
X1744 VDPWR digital_0.load_slew17.X digital_0._105_.RESET_B VDPWR sky130_fd_pr__pfet_01v8_hvt ad=0.26 pd=2.52 as=0.135 ps=1.27 w=1 l=0.15
X1745 a_6738_1298# digital_0.output11.A VDPWR VDPWR sky130_fd_pr__pfet_01v8_hvt ad=0.27 pd=2.54 as=0.19265 ps=1.415 w=1 l=0.15
X1746 uio_out<0> a_15617_5676# VGND VGND sky130_fd_pr__nfet_01v8 ad=0.2079 pd=1.83 as=0.1856 ps=1.26 w=0.42 l=0.15
X1747 VGND a_14149_5650# a_13891_5650# VGND sky130_fd_pr__nfet_01v8 ad=0.0567 pd=0.69 as=0.1092 ps=1.36 w=0.42 l=0.5
X1748 a_11531_4410# a_11496_4176# a_11209_4018# VGND sky130_fd_pr__nfet_01v8 ad=0.06405 pd=0.725 as=0.1092 ps=1.36 w=0.42 l=0.15
X1749 a_27670_18564# a_27454_16644# VGND sky130_fd_pr__res_high_po w=0.36 l=7.36
X1750 a_14654_2778# a_14174_2412# VDPWR VDPWR sky130_fd_pr__pfet_01v8_hvt ad=0.0441 pd=0.63 as=0.0567 ps=0.69 w=0.42 l=0.15
X1751 a_4080_2956# a_3993_3198# a_3676_3088# VDPWR sky130_fd_pr__pfet_01v8_hvt ad=0.12915 pd=1.185 as=0.0588 ps=0.7 w=0.42 l=0.15
X1752 digital_0.load_slew17.A a_3841_3500# VGND VGND sky130_fd_pr__nfet_01v8 ad=0.2079 pd=1.83 as=0.1856 ps=1.26 w=0.42 l=0.15
X1753 LELO_GR01_0.x7.x20.D LELO_GR01_0.x8.PWRUP_N_1V8 LELO_GR01_0.x7.x21.D VDPWR sky130_fd_pr__pfet_01v8_lvt ad=0.3168 pd=1.62 as=0.5088 ps=2.98 w=0.96 l=0.94
X1754 VGND a_7253_2386# digital_0.clkload0.X VGND sky130_fd_pr__nfet_01v8 ad=0.07035 pd=0.755 as=0.0588 ps=0.7 w=0.42 l=0.15
X1755 a_8841_1842# a_8646_1984# a_9151_2234# VGND sky130_fd_pr__special_nfet_01v8 ad=0.0594 pd=0.69 as=0.1401 ps=1.1 w=0.36 l=0.15
X1756 VDPWR VGND VDPWR VDPWR sky130_fd_pr__pfet_01v8_hvt ad=0.2262 pd=2.26 as=0 ps=0 w=0.87 l=0.59
X1757 VGND JNWTR_IVX1_CV_0.Y a_4157_2412# VGND sky130_fd_pr__nfet_01v8 ad=0.1228 pd=1.065 as=0.1134 ps=1.38 w=0.42 l=0.15
X1758 VDPWR digital_0.hold28.A a_12367_2956# VDPWR sky130_fd_pr__pfet_01v8_hvt ad=0.0567 pd=0.69 as=0.1092 ps=1.36 w=0.42 l=0.15
X1759 a_4712_2956# a_3993_3198# a_4149_2930# VGND sky130_fd_pr__special_nfet_01v8 ad=0.066 pd=0.745 as=0.0594 ps=0.69 w=0.36 l=0.15
X1760 digital_0.clkbuf_1_0__f_clk.X a_11416_3500# VDPWR VDPWR sky130_fd_pr__pfet_01v8_hvt ad=0.14 pd=1.28 as=0.14 ps=1.28 w=1 l=0.15
X1761 a_25270_15064# a_25054_13144# VGND sky130_fd_pr__res_high_po w=0.36 l=7.36
X1762 VDPWR a_4341_4052# digital_0.load_slew17.X VDPWR sky130_fd_pr__pfet_01v8_hvt ad=0.265 pd=2.53 as=0.135 ps=1.27 w=1 l=0.15
X1763 a_12532_4044# a_11813_4286# a_11969_4018# VGND sky130_fd_pr__special_nfet_01v8 ad=0.066 pd=0.745 as=0.0594 ps=0.69 w=0.36 l=0.15
X1764 VDPWR digital_0.load_slew15.X digital_0._119_.RESET_B VDPWR sky130_fd_pr__pfet_01v8_hvt ad=0.26 pd=2.52 as=0.135 ps=1.27 w=1 l=0.15
X1765 a_13348_1574# digital_0._080_.A2 VDPWR VDPWR sky130_fd_pr__pfet_01v8_hvt ad=0.26 pd=2.52 as=0.1575 ps=1.315 w=1 l=0.15
X1766 a_5450_8824# a_5234_6904# VGND sky130_fd_pr__res_high_po w=0.36 l=7.36
R7 uio_oe<2> JNWTR_TIEH_CV_0.Y sky130_fd_pr__res_generic_m4 w=0.3 l=0.3
X1767 VDPWR VGND VDPWR VDPWR sky130_fd_pr__pfet_01v8_hvt ad=0.2262 pd=2.26 as=0 ps=0 w=0.87 l=0.59
X1768 a_13980_4176# a_14297_4286# a_14255_4410# VGND sky130_fd_pr__special_nfet_01v8 ad=0.0711 pd=0.755 as=0.0669 ps=0.75 w=0.36 l=0.15
X1769 a_6851_2188# digital_0._113_.Q VGND VGND sky130_fd_pr__nfet_01v8 ad=0.169 pd=1.82 as=0.08775 ps=0.92 w=0.65 l=0.15
X1770 a_9417_4838# digital_0._116_.Q VDPWR VDPWR sky130_fd_pr__pfet_01v8_hvt ad=0.28 pd=2.56 as=0.135 ps=1.27 w=1 l=0.15
X1771 a_6394_4954# a_5873_4562# VDPWR VDPWR sky130_fd_pr__pfet_01v8_hvt ad=0.0567 pd=0.69 as=0.0819 ps=0.81 w=0.42 l=0.15
X1772 digital_0.load_slew17.X a_4341_4052# VGND VGND sky130_fd_pr__nfet_01v8 ad=0.08775 pd=0.92 as=0.097 ps=0.975 w=0.65 l=0.15
X1773 LELO_GR01_0.x8.x1.x7.D LELO_GR01_0.PWRUP_1V8 VDPWR VDPWR sky130_fd_pr__pfet_01v8_lvt ad=0.3168 pd=1.62 as=0.5088 ps=2.98 w=0.96 l=0.94
X1774 VDPWR VGND VDPWR VDPWR sky130_fd_pr__pfet_01v8_hvt ad=0.2262 pd=2.26 as=0 ps=0 w=0.87 l=0.59
X1775 a_6505_5171# digital_0._110_.Q a_6046_5364# VDPWR sky130_fd_pr__pfet_01v8_hvt ad=0.0441 pd=0.63 as=0.1932 ps=1.34 w=0.42 l=0.15
X1776 LELO_GR01_0.x7.x29.P a_19234_13144# VGND sky130_fd_pr__res_high_po w=0.36 l=7.36
X1777 a_8684_8824# a_8900_6904# VGND sky130_fd_pr__res_high_po w=0.36 l=7.36
X1778 a_14726_2778# a_13891_2412# a_14754_2412# VGND sky130_fd_pr__nfet_01v8 ad=0.0735 pd=0.77 as=0.0441 ps=0.63 w=0.42 l=0.15
X1779 a_14459_4830# a_14241_4588# VDPWR VDPWR sky130_fd_pr__pfet_01v8_hvt ad=0.12915 pd=1.185 as=0.2184 ps=2.2 w=0.84 l=0.15
X1780 VGND a_14573_5374# a_14534_5248# VGND sky130_fd_pr__nfet_01v8 ad=0.0567 pd=0.69 as=0.1092 ps=1.36 w=0.42 l=0.15
X1781 JNWTR_ORX1_CV_0.XA2.A JNWTR_ORX1_CV_0.A VGND VGND sky130_fd_pr__nfet_01v8 ad=0.288 pd=1.54 as=0.468 ps=2.84 w=0.9 l=0.16
X1782 VGND a_15506_1324# a_15617_1324# VGND sky130_fd_pr__nfet_01v8 ad=0.1856 pd=1.26 as=0.17225 ps=1.83 w=0.65 l=0.25
X1783 a_14211_3322# a_13832_2956# a_14139_3322# VGND sky130_fd_pr__nfet_01v8 ad=0.1401 pd=1.1 as=0.0441 ps=0.63 w=0.42 l=0.15
X1784 LELO_GR01_0.x8.VREF_BG LELO_GR01_0.x7.xd1<4>.A VDPWR VDPWR sky130_fd_pr__pfet_01v8_lvt ad=0.3168 pd=1.62 as=0.5088 ps=2.98 w=0.96 l=0.94
X1785 a_7302_1868# digital_0._063_.A a_6631_1842# VDPWR sky130_fd_pr__pfet_01v8_hvt ad=0.135 pd=1.27 as=0.135 ps=1.27 w=1 l=0.15
X1786 digital_0.clkload0.X a_7253_2386# VGND VGND sky130_fd_pr__nfet_01v8 ad=0.0588 pd=0.7 as=0.1218 ps=1.42 w=0.42 l=0.15
X1787 VGND a_8735_3474# digital_0.clkbuf_1_1__f_clk.A VGND sky130_fd_pr__nfet_01v8 ad=0.0588 pd=0.7 as=0.0588 ps=0.7 w=0.42 l=0.15
X1788 VGND clk a_8735_3474# VGND sky130_fd_pr__nfet_01v8 ad=0.1113 pd=1.37 as=0.0588 ps=0.7 w=0.42 l=0.15
X1789 a_10944_4840# a_11222_4856# a_11178_4954# VDPWR sky130_fd_pr__pfet_01v8_hvt ad=0.0588 pd=0.7 as=0.0567 ps=0.69 w=0.42 l=0.15
X1790 a_6968_4276# digital_0._065_.A2_N VDPWR VDPWR sky130_fd_pr__pfet_01v8_hvt ad=0.07438 pd=0.815 as=0.15075 ps=1.345 w=0.42 l=0.15
X1791 a_14981_4562# a_14806_4588# a_15160_4588# VGND sky130_fd_pr__nfet_01v8 ad=0.1092 pd=1.36 as=0.06405 ps=0.725 w=0.42 l=0.15
X1792 a_8602_1868# a_8081_1842# VDPWR VDPWR sky130_fd_pr__pfet_01v8_hvt ad=0.0567 pd=0.69 as=0.0819 ps=0.81 w=0.42 l=0.15
X1793 a_11445_2554# digital_0.input1.X VGND VGND sky130_fd_pr__nfet_01v8 ad=0.1092 pd=1.36 as=0.0567 ps=0.69 w=0.42 l=0.15
X1794 VDPWR a_8735_3474# digital_0.clkbuf_1_1__f_clk.A VDPWR sky130_fd_pr__pfet_01v8_hvt ad=0.14 pd=1.28 as=0.14 ps=1.28 w=1 l=0.15
X1795 a_6646_5650# digital_0.output8.A VDPWR VDPWR sky130_fd_pr__pfet_01v8_hvt ad=0.27 pd=2.54 as=0.19265 ps=1.415 w=1 l=0.15
X1796 a_15039_5498# a_14660_5132# a_14967_5498# VGND sky130_fd_pr__nfet_01v8 ad=0.1401 pd=1.1 as=0.0441 ps=0.63 w=0.42 l=0.15
X1797 VDPWR digital_0.hold28.A a_9083_1651# VDPWR sky130_fd_pr__pfet_01v8_hvt ad=0.15835 pd=1.395 as=0.07665 ps=0.785 w=0.42 l=0.15
X1798 a_9947_1324# a_9677_1690# a_9862_1690# VGND sky130_fd_pr__nfet_01v8 ad=0.0567 pd=0.69 as=0.1092 ps=1.36 w=0.42 l=0.15
X1799 a_5321_2386# a_5608_2664# VDPWR VDPWR sky130_fd_pr__pfet_01v8_hvt ad=0.0567 pd=0.69 as=0.1134 ps=1.38 w=0.42 l=0.15
X1800 a_8739_4910# a_8793_4562# a_8573_4588# VGND sky130_fd_pr__nfet_01v8 ad=0.1092 pd=1.36 as=0.0567 ps=0.69 w=0.42 l=0.15
X1801 VGND a_6046_5364# digital_0._102_.D VGND sky130_fd_pr__nfet_01v8 ad=0.11285 pd=1.045 as=0.169 ps=1.82 w=0.65 l=0.15
X1802 VGND VDPWR VGND VGND sky130_fd_pr__nfet_01v8 ad=0.143 pd=1.62 as=0 ps=0 w=0.55 l=0.59
X1803 a_5883_3500# a_5321_3474# VGND VGND sky130_fd_pr__nfet_01v8 ad=0.0669 pd=0.75 as=0.12495 ps=1.015 w=0.42 l=0.15
X1804 VDPWR digital_0.load_slew17.A digital_0._104_.RESET_B VDPWR sky130_fd_pr__pfet_01v8_hvt ad=0.26 pd=2.52 as=0.135 ps=1.27 w=1 l=0.15
X1805 digital_0._111_.RESET_B digital_0.load_slew17.A VGND VGND sky130_fd_pr__nfet_01v8 ad=0.08775 pd=0.92 as=0.169 ps=1.82 w=0.65 l=0.15
X1806 digital_0._114_.D a_9862_1690# VGND VGND sky130_fd_pr__nfet_01v8 ad=0.08775 pd=0.92 as=0.10187 ps=0.99 w=0.65 l=0.15
X1807 a_13832_2956# a_13745_3198# a_13428_3088# VDPWR sky130_fd_pr__pfet_01v8_hvt ad=0.12915 pd=1.185 as=0.0588 ps=0.7 w=0.42 l=0.15
X1808 VGND VDPWR VGND VGND sky130_fd_pr__nfet_01v8 ad=0.143 pd=1.62 as=0 ps=0 w=0.55 l=0.59
X1809 VDPWR digital_0._113_.Q a_6575_1868# VDPWR sky130_fd_pr__pfet_01v8_hvt ad=0.135 pd=1.27 as=0.135 ps=1.27 w=1 l=0.15
X1810 VGND digital_0.hold28.A a_9090_1324# VGND sky130_fd_pr__nfet_01v8 ad=0.11285 pd=1.045 as=0.0693 ps=0.75 w=0.42 l=0.15
X1811 a_8869_1651# digital_0.hold21.X a_8869_1324# VGND sky130_fd_pr__nfet_01v8 ad=0.09975 pd=0.895 as=0.0693 ps=0.75 w=0.42 l=0.15
X1812 VDPWR digital_0._104_.RESET_B a_4294_2956# VDPWR sky130_fd_pr__pfet_01v8_hvt ad=0.07035 pd=0.755 as=0.1092 ps=1.36 w=0.42 l=0.15
X1813 a_4080_2956# a_3954_3072# a_3676_3088# VGND sky130_fd_pr__special_nfet_01v8 ad=0.0999 pd=0.985 as=0.0711 ps=0.755 w=0.36 l=0.15
X1814 a_8170_5676# digital_0._111_.Q a_7949_6003# VGND sky130_fd_pr__nfet_01v8 ad=0.0693 pd=0.75 as=0.09975 ps=0.895 w=0.42 l=0.15
X1815 digital_0.input1.X a_14053_1324# VGND VGND sky130_fd_pr__nfet_01v8 ad=0.2079 pd=1.83 as=0.1856 ps=1.26 w=0.42 l=0.15
X1816 digital_0.clkload0.A a_6343_2930# VGND VGND sky130_fd_pr__nfet_01v8 ad=0.0588 pd=0.7 as=0.0588 ps=0.7 w=0.42 l=0.15
X1817 a_9116_8824# a_8900_6904# VGND sky130_fd_pr__res_high_po w=0.36 l=7.36
X1818 VGND a_5386_5676# a_5497_5676# VGND sky130_fd_pr__nfet_01v8 ad=0.1856 pd=1.26 as=0.17225 ps=1.83 w=0.65 l=0.25
X1819 a_16872_18564# a_16656_16644# VGND sky130_fd_pr__res_high_po w=0.36 l=7.36
X1820 VDPWR VGND VDPWR VDPWR sky130_fd_pr__pfet_01v8_hvt ad=0.2262 pd=2.26 as=0 ps=0 w=0.87 l=0.59
X1821 VDPWR LELO_GR01_0.x7.xd1<4>.A LELO_GR01_0.x8.IBP_BG VDPWR sky130_fd_pr__pfet_01v8_lvt ad=0.5088 pd=2.98 as=0.3168 ps=1.62 w=0.96 l=0.94
X1822 a_8389_2956# digital_0._112_.Q VDPWR VDPWR sky130_fd_pr__pfet_01v8_hvt ad=0.215 pd=1.43 as=0.135 ps=1.27 w=1 l=0.15
X1823 digital_0._104_.RESET_B digital_0.load_slew17.A VGND VGND sky130_fd_pr__nfet_01v8 ad=0.08775 pd=0.92 as=0.169 ps=1.82 w=0.65 l=0.15
X1824 VGND a_14531_1476# digital_0.hold18.X VGND sky130_fd_pr__nfet_01v8 ad=0.097 pd=0.975 as=0.169 ps=1.82 w=0.65 l=0.15
X1825 VDPWR digital_0._069_.A a_11793_5926# VDPWR sky130_fd_pr__pfet_01v8_hvt ad=0.135 pd=1.27 as=0.28 ps=2.56 w=1 l=0.15
X1826 a_9083_1651# digital_0.hold21.X a_8869_1651# VDPWR sky130_fd_pr__pfet_01v8_hvt ad=0.07665 pd=0.785 as=0.1932 ps=1.34 w=0.42 l=0.15
X1827 VGND a_8389_3276# digital_0._060_.B VGND sky130_fd_pr__nfet_01v8 ad=0.169 pd=1.82 as=0.08775 ps=0.92 w=0.65 l=0.15
X1828 LELO_GR01_0.x8.x1.x7.D LELO_GR01_0.x8.x1.x7.D VDPWR VDPWR sky130_fd_pr__pfet_01v8_lvt ad=0.3168 pd=1.62 as=0.5088 ps=2.98 w=0.96 l=0.94
X1829 digital_0._108_.RESET_B digital_0.load_slew15.A VGND VGND sky130_fd_pr__nfet_01v8 ad=0.08775 pd=0.92 as=0.08775 ps=0.92 w=0.65 l=0.15
X1830 VGND a_14797_2172# digital_0.output4.A VGND sky130_fd_pr__nfet_01v8 ad=0.169 pd=1.82 as=0.08775 ps=0.92 w=0.65 l=0.15
X1831 VGND VDPWR VGND VGND sky130_fd_pr__nfet_01v8 ad=0.143 pd=1.62 as=0 ps=0 w=0.55 l=0.59
X1832 a_14598_4044# a_14384_4044# VDPWR VDPWR sky130_fd_pr__pfet_01v8_hvt ad=0.1155 pd=0.97 as=0.07035 ps=0.755 w=0.42 l=0.15
X1833 a_8772_4044# a_8646_4160# a_8368_4176# VGND sky130_fd_pr__special_nfet_01v8 ad=0.0999 pd=0.985 as=0.0711 ps=0.755 w=0.36 l=0.15
X1834 a_15507_3528# digital_0._116_.Q VDPWR VDPWR sky130_fd_pr__pfet_01v8_hvt ad=0.0567 pd=0.69 as=0.1176 ps=1.4 w=0.42 l=0.15
X1835 LELO_GR01_0.x7.x28.e a_16214_13144# VGND sky130_fd_pr__res_high_po w=0.36 l=7.36
X1836 LELO_GR01_0.x8.x1.x5.x8.G LELO_GR01_0.x8.x1.x5.x9<2>.G VGND VGND sky130_fd_pr__nfet_01v8_lvt ad=0.3168 pd=1.62 as=0.5088 ps=2.98 w=0.96 l=0.94
X1837 VGND a_15300_2412# digital_0._116_.Q VGND sky130_fd_pr__nfet_01v8 ad=0.169 pd=1.82 as=0.08775 ps=0.92 w=0.65 l=0.15
X1838 a_13891_2412# a_13725_2412# VGND VGND sky130_fd_pr__nfet_01v8 ad=0.1092 pd=1.36 as=0.0567 ps=0.69 w=0.42 l=0.15
X1839 a_6075_1842# digital_0._114_.Q a_6321_2206# VGND sky130_fd_pr__nfet_01v8 ad=0.1176 pd=1.4 as=0.0567 ps=0.69 w=0.42 l=0.15
X1840 VDPWR digital_0._113_.D a_6644_3866# VDPWR sky130_fd_pr__pfet_01v8_hvt ad=0.1092 pd=1.36 as=0.0651 ps=0.73 w=0.42 l=0.15
X1841 a_6968_4276# digital_0._112_.Q VDPWR VDPWR sky130_fd_pr__pfet_01v8_hvt ad=0.1092 pd=1.36 as=0.0567 ps=0.69 w=0.42 l=0.15
X1842 VDPWR a_13901_2930# a_13832_2956# VDPWR sky130_fd_pr__pfet_01v8_hvt ad=0.2184 pd=2.2 as=0.12915 ps=1.185 w=0.84 l=0.15
X1843 LELO_GR01_0.x7.x29.P a_23550_13144# VGND sky130_fd_pr__res_high_po w=0.36 l=7.36
X1844 VGND digital_0.clkbuf_1_0__f_clk.X a_13541_1874# VGND sky130_fd_pr__nfet_01v8 ad=0.0567 pd=0.69 as=0.1092 ps=1.36 w=0.42 l=0.15
X1845 a_9139_2412# a_9104_2664# a_8817_2386# VGND sky130_fd_pr__nfet_01v8 ad=0.06405 pd=0.725 as=0.1092 ps=1.36 w=0.42 l=0.15
X1846 VDPWR VGND VDPWR VDPWR sky130_fd_pr__pfet_01v8_hvt ad=0.2262 pd=2.26 as=0 ps=0 w=0.87 l=0.59
X1847 digital_0.input3.X a_4485_2412# VGND VGND sky130_fd_pr__nfet_01v8 ad=0.2079 pd=1.83 as=0.1856 ps=1.26 w=0.42 l=0.15
X1848 VDPWR digital_0._110_.RESET_B a_5873_4562# VDPWR sky130_fd_pr__pfet_01v8_hvt ad=0.0819 pd=0.81 as=0.0567 ps=0.69 w=0.42 l=0.15
X1849 VGND a_14885_1298# a_14627_1298# VGND sky130_fd_pr__nfet_01v8 ad=0.0567 pd=0.69 as=0.1092 ps=1.36 w=0.42 l=0.5
X1850 digital_0.output7.A a_4033_5106# VGND VGND sky130_fd_pr__nfet_01v8 ad=0.08775 pd=0.92 as=0.169 ps=1.82 w=0.65 l=0.15
X1851 digital_0._115_.RESET_B digital_0._116_.Q VGND VGND sky130_fd_pr__nfet_01v8 ad=0.08775 pd=0.92 as=0.08775 ps=0.92 w=0.65 l=0.15
X1852 VDPWR digital_0._118_.D a_14464_2956# VDPWR sky130_fd_pr__pfet_01v8_hvt ad=0.1092 pd=1.36 as=0.0651 ps=0.73 w=0.42 l=0.15
X1853 VGND VDPWR VGND VGND sky130_fd_pr__nfet_01v8 ad=0.143 pd=1.62 as=0 ps=0 w=0.55 l=0.59
X1854 VGND digital_0._108_.RESET_B a_11531_4410# VGND sky130_fd_pr__nfet_01v8 ad=0.12495 pd=1.015 as=0.06405 ps=0.725 w=0.42 l=0.15
X1855 a_11721_1651# digital_0.hold26.X a_11721_1324# VGND sky130_fd_pr__nfet_01v8 ad=0.09975 pd=0.895 as=0.0693 ps=0.75 w=0.42 l=0.15
X1856 a_10412_8824# a_10196_6904# VGND sky130_fd_pr__res_high_po w=0.36 l=7.36
X1857 a_4846_1868# a_4632_1868# VDPWR VDPWR sky130_fd_pr__pfet_01v8_hvt ad=0.1155 pd=0.97 as=0.07035 ps=0.755 w=0.42 l=0.15
X1858 a_8735_3474# clk VGND VGND sky130_fd_pr__nfet_01v8 ad=0.0588 pd=0.7 as=0.0588 ps=0.7 w=0.42 l=0.15
X1859 LELO_GR01_0.x8.x1.x5.IBN LELO_GR01_0.x8.VREF_BG LELO_GR01_0.x8.x7.D VGND sky130_fd_pr__nfet_01v8_lvt ad=0.5088 pd=2.98 as=0.3168 ps=1.62 w=0.96 l=0.94
X1860 digital_0._063_.B digital_0._069_.A a_7667_3500# VGND sky130_fd_pr__nfet_01v8 ad=0.091 pd=0.93 as=0.06825 ps=0.86 w=0.65 l=0.15
X1861 VDPWR digital_0.load_slew15.X digital_0._101_.RESET_B VDPWR sky130_fd_pr__pfet_01v8_hvt ad=0.26 pd=2.52 as=0.135 ps=1.27 w=1 l=0.15
X1862 VGND digital_0._108_.Q a_11873_5452# VGND sky130_fd_pr__nfet_01v8 ad=0.18525 pd=1.87 as=0.08937 ps=0.925 w=0.65 l=0.15
X1863 VDPWR VGND VDPWR VDPWR sky130_fd_pr__pfet_01v8_hvt ad=0.2262 pd=2.26 as=0 ps=0 w=0.87 l=0.59
X1864 VGND digital_0.hold28.A a_14426_3500# VGND sky130_fd_pr__nfet_01v8 ad=0.11285 pd=1.045 as=0.0693 ps=0.75 w=0.42 l=0.15
X1865 VGND VGND LELO_GR01_0.x7.x15.I1 sky130_fd_pr__pnp_05v5_W3p40L3p40
**devattr s=462400,2720
X1866 a_8772_4044# a_8685_4286# a_8368_4176# VDPWR sky130_fd_pr__pfet_01v8_hvt ad=0.12915 pd=1.185 as=0.0588 ps=0.7 w=0.42 l=0.15
X1867 VDPWR VGND VDPWR VDPWR sky130_fd_pr__pfet_01v8_hvt ad=0.2262 pd=2.26 as=0 ps=0 w=0.87 l=0.59
X1868 a_6195_4588# a_6160_4840# a_5873_4562# VGND sky130_fd_pr__nfet_01v8 ad=0.06405 pd=0.725 as=0.1092 ps=1.36 w=0.42 l=0.15
X1869 VDPWR a_11209_4018# digital_0._108_.Q VDPWR sky130_fd_pr__pfet_01v8_hvt ad=0.3012 pd=2.66 as=0.135 ps=1.27 w=1 l=0.15
X1870 VDPWR digital_0._106_.RESET_B a_8081_1842# VDPWR sky130_fd_pr__pfet_01v8_hvt ad=0.0819 pd=0.81 as=0.0567 ps=0.69 w=0.42 l=0.15
X1871 a_8685_2110# digital_0.clkload0.A VDPWR VDPWR sky130_fd_pr__pfet_01v8_hvt ad=0.1664 pd=1.8 as=0.0864 ps=0.91 w=0.64 l=0.15
X1872 VGND VDPWR VGND VGND sky130_fd_pr__nfet_01v8 ad=0.143 pd=1.62 as=0 ps=0 w=0.55 l=0.59
C0 JNWTR_IVX1_CV_0.Y JNWTR_ORX1_CV_0.A 1.56869f
C1 JNWTR_IVX1_CV_0.Y JNWTR_ORX1_CV_0.XA1.MP1.S 0.01314f
C2 JNWTR_IVX1_CV_0.Y JNWTR_ORX1_CV_0.XA2.A 0.07115f
C3 JNWTR_TIEH_CV_0.Y JNWTR_IVX1_CV_0.Y 0.0136f
C4 JNWTR_IVX1_CV_0.Y LELO_GR01_0.PWRUP_1V8 0.47412f
C5 JNWTR_IVX1_CV_0.Y LELO_GR01_0.x7.x11.N 0.2164f
C6 JNWTR_IVX1_CV_0.Y LELO_GR01_0.x7.x11.P 0.02326f
C7 JNWTR_IVX1_CV_0.Y VDPWR 1.27335f
C8 JNWTR_IVX1_CV_0.Y VGND 22.3983f
C9 JNWTR_IVX1_CV_0.Y a_14627_1298# 0.01464f
C10 JNWTR_IVX1_CV_0.Y a_14885_1298# 0.01063f
C11 a_29432_21305# JNWTR_IVX1_CV_0.Y 0.01812f
C12 JNWTR_IVX1_CV_0.Y a_29582_13144# 0.03319f
C13 a_30272_21305# JNWTR_IVX1_CV_0.Y 0.01812f
C14 JNWTR_IVX1_CV_0.Y a_3443_2412# 0.01246f
C15 JNWTR_IVX1_CV_0.Y a_3679_2412# 0.02826f
C16 JNWTR_IVX1_CV_0.Y a_3785_2412# 0.03653f
C17 JNWTR_IVX1_CV_0.Y a_3903_1324# 0.01339f
C18 JNWTR_IVX1_CV_0.Y a_3941_1842# 0.02295f
C19 JNWTR_IVX1_CV_0.Y a_4139_1324# 0.0118f
C20 JNWTR_IVX1_CV_0.Y a_4157_2412# 0.20287f
C21 JNWTR_IVX1_CV_0.Y clk 3.37642f
C22 JNWTR_IVX1_CV_0.Y digital_0._112_.RESET_B 0.1378f
C23 JNWTR_IVX1_CV_0.Y digital_0._113_.Q 0.01094f
C24 JNWTR_IVX1_CV_0.Y digital_0._113_.RESET_B 0.05756f
C25 JNWTR_IVX1_CV_0.Y digital_0._114_.Q 0.01003f
C26 JNWTR_IVX1_CV_0.Y digital_0._116_.Q 0.10622f
C27 JNWTR_IVX1_CV_0.Y digital_0.hold23.X 0.04709f
C28 JNWTR_IVX1_CV_0.Y digital_0.hold28.A 0.056f
C29 JNWTR_IVX1_CV_0.Y digital_0.input3.X 0.07684f
C30 JNWTR_IVX1_CV_0.Y digital_0.load_slew17.X 0.02296f
C31 JNWTR_IVX1_CV_0.Y digital_0.output10.A 0.02233f
C32 JNWTR_IVX1_CV_0.Y digital_0.output9.A 0.01237f
C33 JNWTR_IVX1_CV_0.Y rst_n 0.14732f
C34 JNWTR_IVX1_CV_0.Y ui_in<1> 0.07036f
C35 JNWTR_IVX1_CV_0.Y uio_out<4> 0.03071f
C36 JNWTR_IVX1_CV_0.Y uio_out<5> 0.15378f
C37 JNWTR_IVX1_CV_0.Y uio_out<6> 0.09326f
C38 JNWTR_IVX1_CV_0.Y uio_out<7> 0.0668f
C39 JNWTR_IVX1_CV_0.Y uo_out<0> 0.91152f
C40 JNWTR_ORX1_CV_0.XA2.A JNWTR_ORX1_CV_0.A 0.02991f
C41 LELO_GR01_0.PWRUP_1V8 JNWTR_ORX1_CV_0.A 0.03929f
C42 JNWTR_ORX1_CV_0.A VDPWR 1.56464f
C43 JNWTR_ORX1_CV_0.A VGND 15.0001f
C44 JNWTR_ORX1_CV_0.A a_15617_1324# 0.09163f
C45 JNWTR_ORX1_CV_0.A a_29432_20186# 0.05952f
C46 JNWTR_ORX1_CV_0.A a_30272_20186# 0.0872f
C47 JNWTR_ORX1_CV_0.A clk 1.83337f
C48 JNWTR_ORX1_CV_0.A digital_0.output13.A 0.03674f
C49 JNWTR_ORX1_CV_0.A rst_n 0.0484f
C50 JNWTR_ORX1_CV_0.A ui_in<0> 1.00901f
C51 JNWTR_ORX1_CV_0.A ui_in<1> 0.38849f
C52 JNWTR_ORX1_CV_0.A uio_out<1> 0.28925f
C53 JNWTR_ORX1_CV_0.A uo_out<0> 0.06244f
C54 JNWTR_ORX1_CV_0.A uo_out<1> 0.18861f
C55 JNWTR_ORX1_CV_0.XA2.A JNWTR_ORX1_CV_0.XA1.MP1.S 0.05059f
C56 JNWTR_ORX1_CV_0.XA1.MP1.S VDPWR 0.10451f
C57 LELO_GR01_0.PWRUP_1V8 JNWTR_ORX1_CV_0.XA2.A 0.18637f
C58 JNWTR_ORX1_CV_0.XA2.A VDPWR 0.53289f
C59 JNWTR_ORX1_CV_0.XA2.A VGND 0.87185f
C60 JNWTR_ORX1_CV_0.XA2.A a_29432_20666# 0.07737f
C61 a_29432_20986# JNWTR_ORX1_CV_0.XA2.A 0.06129f
C62 JNWTR_ORX1_CV_0.XA2.A a_30272_20666# 0.09104f
C63 a_30272_20986# JNWTR_ORX1_CV_0.XA2.A 0.06219f
C64 JNWTR_ORX1_CV_0.XA2.A rst_n 0.07613f
C65 JNWTR_ORX1_CV_0.XA2.A ui_in<1> 0.19182f
C66 JNWTR_TIEH_CV_0.Y JNWTR_TIEH_CV_0.MP0.G 0.06303f
C67 JNWTR_TIEH_CV_0.MP0.G VDPWR 0.37827f
C68 JNWTR_TIEH_CV_0.MP0.G VGND 0.69533f
C69 JNWTR_TIEH_CV_0.MP0.G a_29432_21624# 0.05973f
C70 a_29432_21944# JNWTR_TIEH_CV_0.MP0.G 0.06129f
C71 JNWTR_TIEH_CV_0.MP0.G a_30272_21624# 0.06712f
C72 a_30272_21944# JNWTR_TIEH_CV_0.MP0.G 0.08348f
C73 JNWTR_TIEH_CV_0.Y LELO_GR01_0.PWRUP_1V8 0.54723f
C74 LELO_GR01_0.x7.x1.x5.x8.S JNWTR_TIEH_CV_0.Y 0.01104f
C75 JNWTR_TIEH_CV_0.Y LELO_GR01_0.x7.x11.P 0.01109f
C76 JNWTR_TIEH_CV_0.Y LELO_GR01_0.x7.xd1<4>.A 0.25786f
C77 JNWTR_TIEH_CV_0.Y LELO_GR01_0.x8.PWRUP_N_1V8 0.08181f
C78 JNWTR_TIEH_CV_0.Y VDPWR 0.91862f
C79 JNWTR_TIEH_CV_0.Y VGND 9.02251f
C80 a_29432_21944# JNWTR_TIEH_CV_0.Y 0.03581f
C81 JNWTR_TIEH_CV_0.Y a_8552_20648# 0.01225f
C82 JNWTR_TIEH_CV_0.Y clk 0.04038f
C83 JNWTR_TIEH_CV_0.Y rst_n 0.13199f
C84 JNWTR_TIEH_CV_0.Y ui_in<0> 0.06258f
C85 JNWTR_TIEH_CV_0.Y ui_in<1> 0.08498f
C86 JNWTR_TIEH_CV_0.Y uio_out<0> 0.05202f
C87 JNWTR_TIEH_CV_0.Y uio_out<1> 0.24602f
C88 JNWTR_TIEH_CV_0.Y uio_out<2> 0.03628f
C89 JNWTR_TIEH_CV_0.Y uio_out<3> 0.03029f
C90 JNWTR_TIEH_CV_0.Y uio_out<4> 0.12041f
C91 JNWTR_TIEH_CV_0.Y uio_out<5> 0.03381f
C92 JNWTR_TIEH_CV_0.Y uio_out<6> 0.07118f
C93 JNWTR_TIEH_CV_0.Y uio_out<7> 0.15224f
C94 JNWTR_TIEH_CV_0.Y uo_out<0> 0.48954f
C95 JNWTR_TIEH_CV_0.Y uo_out<1> 0.27971f
C96 LELO_GR01_0.PWRUP_1V8 LELO_GR01_0.x7.x1.x7.D 0.33964f
C97 LELO_GR01_0.PWRUP_1V8 LELO_GR01_0.x7.x10.P 0.98948f
C98 LELO_GR01_0.PWRUP_1V8 LELO_GR01_0.x7.x11.P 0.56832f
C99 LELO_GR01_0.PWRUP_1V8 LELO_GR01_0.x7.x15.I2 0.23085f
C100 LELO_GR01_0.PWRUP_1V8 LELO_GR01_0.x7.x29.N 0.1724f
C101 LELO_GR01_0.PWRUP_1V8 LELO_GR01_0.x7.x29.P 0.15208f
C102 LELO_GR01_0.x7.xd1<4>.A LELO_GR01_0.PWRUP_1V8 0.70697f
C103 LELO_GR01_0.PWRUP_1V8 LELO_GR01_0.x8.IBP_BG 0.31149f
C104 LELO_GR01_0.x8.PWRUP_N_1V8 LELO_GR01_0.PWRUP_1V8 1.40139f
C105 LELO_GR01_0.PWRUP_1V8 LELO_GR01_0.x8.VREF_BG 0.8965f
C106 LELO_GR01_0.PWRUP_1V8 LELO_GR01_0.x8.x1.x5.IBN 0.0123f
C107 LELO_GR01_0.x8.x1.x5.x6.N LELO_GR01_0.PWRUP_1V8 0.23206f
C108 LELO_GR01_0.PWRUP_1V8 LELO_GR01_0.x8.x1.x5.x8.G 0.01555f
C109 LELO_GR01_0.x8.x1.x5.x8.S LELO_GR01_0.PWRUP_1V8 0.04338f
C110 LELO_GR01_0.PWRUP_1V8 LELO_GR01_0.x8.x1.x5.x9<2>.G 0.06327f
C111 LELO_GR01_0.PWRUP_1V8 LELO_GR01_0.x8.x1.x7.D 0.31323f
C112 LELO_GR01_0.PWRUP_1V8 VDPWR 13.3521f
C113 LELO_GR01_0.PWRUP_1V8 VGND 13.7592f
C114 LELO_GR01_0.PWRUP_1V8 a_11996_18042# 0.07044f
C115 LELO_GR01_0.PWRUP_1V8 a_11996_18842# 0.07815f
C116 LELO_GR01_0.PWRUP_1V8 a_12688_20180# 0.07212f
C117 a_12688_20980# LELO_GR01_0.PWRUP_1V8 0.0709f
C118 LELO_GR01_0.PWRUP_1V8 a_16440_18564# 0.05655f
C119 LELO_GR01_0.PWRUP_1V8 a_16872_18564# 0.02331f
C120 LELO_GR01_0.PWRUP_1V8 a_17304_18564# 0.03068f
C121 LELO_GR01_0.PWRUP_1V8 a_17736_18564# 0.05818f
C122 LELO_GR01_0.PWRUP_1V8 a_18168_18564# 0.02877f
C123 LELO_GR01_0.PWRUP_1V8 a_18600_18564# 0.02013f
C124 LELO_GR01_0.PWRUP_1V8 a_19032_18564# 0.02035f
C125 LELO_GR01_0.PWRUP_1V8 a_19666_13144# 0.01763f
C126 LELO_GR01_0.PWRUP_1V8 a_19680_16644# 0.03984f
C127 LELO_GR01_0.PWRUP_1V8 a_20372_11267# 0.04072f
C128 LELO_GR01_0.PWRUP_1V8 a_20372_11699# 0.02291f
C129 LELO_GR01_0.PWRUP_1V8 a_20372_12347# 0.0132f
C130 LELO_GR01_0.PWRUP_1V8 a_20412_20378# 0.07973f
C131 LELO_GR01_0.PWRUP_1V8 a_20412_20698# 0.08617f
C132 LELO_GR01_0.PWRUP_1V8 a_20528_13144# 0.04388f
C133 LELO_GR01_0.PWRUP_1V8 a_20538_16644# 0.04171f
C134 LELO_GR01_0.PWRUP_1V8 a_20744_13144# 0.02749f
C135 LELO_GR01_0.PWRUP_1V8 a_20754_16644# 0.02697f
C136 LELO_GR01_0.PWRUP_1V8 a_21252_20378# 0.06139f
C137 LELO_GR01_0.PWRUP_1V8 a_21252_20698# 0.06041f
C138 LELO_GR01_0.PWRUP_1V8 a_21554_10625# 0.01037f
C139 LELO_GR01_0.PWRUP_1V8 a_23816_10541# 0.07606f
C140 LELO_GR01_0.PWRUP_1V8 a_23816_9741# 0.07044f
C141 LELO_GR01_0.PWRUP_1V8 a_29432_20186# 0.02451f
C142 LELO_GR01_0.PWRUP_1V8 a_29432_20986# 0.01783f
C143 LELO_GR01_0.PWRUP_1V8 a_30272_20986# 0.01772f
C144 LELO_GR01_0.PWRUP_1V8 clk 0.0163f
C145 LELO_GR01_0.PWRUP_1V8 rst_n 0.14849f
C146 LELO_GR01_0.PWRUP_1V8 ui_in<0> 0.01114f
C147 LELO_GR01_0.PWRUP_1V8 ui_in<1> 0.10597f
C148 LELO_GR01_0.PWRUP_1V8 uio_out<0> 0.01913f
C149 LELO_GR01_0.PWRUP_1V8 uio_out<1> 0.01927f
C150 LELO_GR01_0.PWRUP_1V8 uio_out<2> 0.0226f
C151 LELO_GR01_0.PWRUP_1V8 uio_out<3> 0.04653f
C152 LELO_GR01_0.PWRUP_1V8 uio_out<6> 0.07643f
C153 LELO_GR01_0.PWRUP_1V8 uo_out<0> 0.42255f
C154 LELO_GR01_0.PWRUP_1V8 uo_out<1> 0.02825f
C155 LELO_GR01_0.x7.x1.x5.x9<2>.G LELO_GR01_0.x7.x1.x5.IBN 0.95897f
C156 LELO_GR01_0.x7.x1.x5.IBN LELO_GR01_0.x7.x1.x7.D 0.76824f
C157 LELO_GR01_0.x7.x1.x5.IBN LELO_GR01_0.x7.x15.I2 0.85196f
C158 LELO_GR01_0.x7.x1.x5.IBN LELO_GR01_0.x7.x7.G 0.71167f
C159 LELO_GR01_0.x7.xd1<4>.A LELO_GR01_0.x7.x1.x5.IBN 0.52888f
C160 LELO_GR01_0.x8.PWRUP_N_1V8 LELO_GR01_0.x7.x1.x5.IBN 0.37056f
C161 LELO_GR01_0.x7.x1.x5.IBN VDPWR 0.52822f
C162 LELO_GR01_0.x7.x1.x5.IBN VGND 4.2508f
C163 LELO_GR01_0.x7.x1.x5.IBN a_11318_15928# 0.04924f
C164 LELO_GR01_0.x7.x1.x5.IBN a_11318_16728# 0.04626f
C165 LELO_GR01_0.x7.x1.x5.IBN a_12688_15928# 0.04366f
C166 LELO_GR01_0.x7.x1.x5.IBN a_12688_16728# 0.04351f
C167 LELO_GR01_0.x7.x1.x5.IBN a_9734_17074# 0.03188f
C168 LELO_GR01_0.x7.x1.x5.IBN a_9734_17874# 0.03039f
C169 LELO_GR01_0.x7.x1.x5.IBN a_9734_18126# 0.03033f
C170 a_9734_18926# LELO_GR01_0.x7.x1.x5.IBN 0.01243f
C171 LELO_GR01_0.x7.x1.x5.IBN a_9738_16010# 0.01549f
C172 LELO_GR01_0.x7.x1.x5.IBN a_9738_16810# 0.0318f
C173 LELO_GR01_0.x7.x1.x5.IBN uio_out<4> 0.0543f
C174 LELO_GR01_0.x7.x1.x5.IBN uio_out<5> 0.10671f
C175 LELO_GR01_0.x7.x1.x5.IBN uio_out<6> 0.097f
C176 LELO_GR01_0.x7.x1.x5.IBN uio_out<7> 0.15899f
C177 LELO_GR01_0.x7.x1.x5.x6.N LELO_GR01_0.x7.x1.x5.x8.G 2.32381f
C178 LELO_GR01_0.x7.x1.x5.x8.S LELO_GR01_0.x7.x1.x5.x6.N 0.15326f
C179 LELO_GR01_0.x7.x1.x5.x6.N LELO_GR01_0.x7.x1.x5.x9<2>.G 0.83165f
C180 LELO_GR01_0.x7.x1.x5.x6.N LELO_GR01_0.x8.PWRUP_N_1V8 0.01151f
C181 LELO_GR01_0.x7.x1.x5.x6.N VDPWR 0.10812f
C182 LELO_GR01_0.x7.x1.x5.x6.N VGND 6.17663f
C183 LELO_GR01_0.x7.x1.x5.x6.N a_7886_17860# 0.03679f
C184 LELO_GR01_0.x7.x1.x5.x6.N a_8336_18210# 0.39909f
C185 LELO_GR01_0.x7.x1.x5.x6.N a_8336_19010# 0.43217f
C186 LELO_GR01_0.x7.x1.x5.x6.N a_8552_19568# 0.03752f
C187 LELO_GR01_0.x7.x1.x5.x6.N a_8552_20000# 0.22481f
C188 LELO_GR01_0.x7.x1.x5.x6.N uio_out<7> 0.03398f
C189 LELO_GR01_0.x7.x1.x5.x8.S LELO_GR01_0.x7.x1.x5.x8.G 3.06086f
C190 LELO_GR01_0.x7.x1.x5.x8.G LELO_GR01_0.x7.x1.x5.x9<2>.G 2.09666f
C191 LELO_GR01_0.x8.PWRUP_N_1V8 LELO_GR01_0.x7.x1.x5.x8.G 0.87314f
C192 LELO_GR01_0.x7.x1.x5.x8.G VGND 4.8751f
C193 LELO_GR01_0.x7.x1.x5.x8.G a_6636_18210# 0.13066f
C194 a_6636_19010# LELO_GR01_0.x7.x1.x5.x8.G 0.08382f
C195 LELO_GR01_0.x7.x1.x5.x8.G a_6936_16010# 0.01247f
C196 LELO_GR01_0.x7.x1.x5.x8.G a_6936_16810# 0.0438f
C197 LELO_GR01_0.x7.x1.x5.x8.G a_7886_17060# 0.08329f
C198 LELO_GR01_0.x7.x1.x5.x8.G a_7886_17860# 0.11889f
C199 LELO_GR01_0.x7.x1.x5.x8.G a_8336_18210# 0.0824f
C200 LELO_GR01_0.x7.x1.x5.x8.G a_8336_19010# 0.07053f
C201 LELO_GR01_0.x7.x1.x5.x8.S LELO_GR01_0.x8.PWRUP_N_1V8 0.68664f
C202 LELO_GR01_0.x7.x1.x5.x8.S VDPWR 2.01079f
C203 LELO_GR01_0.x7.x1.x5.x8.S VGND 6.02147f
C204 LELO_GR01_0.x7.x1.x5.x8.S a_6636_18210# 0.3991f
C205 LELO_GR01_0.x7.x1.x5.x8.S a_6636_19010# 0.45344f
C206 LELO_GR01_0.x7.x1.x5.x8.S a_6636_19810# 0.04689f
C207 LELO_GR01_0.x7.x1.x5.x8.S a_6636_20610# 0.03292f
C208 LELO_GR01_0.x7.x1.x5.x8.S a_8552_20000# 0.22449f
C209 LELO_GR01_0.x7.x1.x5.x8.S a_8552_20648# 0.01766f
C210 LELO_GR01_0.x8.PWRUP_N_1V8 LELO_GR01_0.x7.x1.x5.x9<2>.G 1.24064f
C211 LELO_GR01_0.x7.x1.x5.x9<2>.G VDPWR 0.0998f
C212 LELO_GR01_0.x7.x1.x5.x9<2>.G VGND 17.4163f
C213 LELO_GR01_0.x7.x1.x5.x9<2>.G a_6936_16010# 0.07336f
C214 LELO_GR01_0.x7.x1.x5.x9<2>.G a_6936_16810# 0.0876f
C215 LELO_GR01_0.x7.x1.x5.x9<2>.G a_7536_14960# 0.0124f
C216 LELO_GR01_0.x7.x1.x5.x9<2>.G a_7536_15760# 0.03436f
C217 LELO_GR01_0.x7.x1.x5.x9<2>.G a_7886_17060# 0.09093f
C218 LELO_GR01_0.x7.x1.x5.x9<2>.G a_7886_17860# 0.0438f
C219 LELO_GR01_0.x7.x1.x5.x9<2>.G a_8336_16010# 0.08521f
C220 LELO_GR01_0.x7.x1.x5.x9<2>.G a_8336_16810# 0.12529f
C221 LELO_GR01_0.x7.x1.x5.x9<2>.G a_8336_18210# 0.0408f
C222 a_8336_19010# LELO_GR01_0.x7.x1.x5.x9<2>.G 0.01325f
C223 LELO_GR01_0.x7.x1.x5.x9<2>.G a_9734_17074# 0.07821f
C224 LELO_GR01_0.x7.x1.x5.x9<2>.G a_9734_17874# 0.07742f
C225 LELO_GR01_0.x7.x1.x5.x9<2>.G a_9734_18126# 0.07793f
C226 LELO_GR01_0.x7.x1.x5.x9<2>.G a_9734_18926# 0.07164f
C227 LELO_GR01_0.x7.x1.x5.x9<2>.G a_9738_16010# 0.07064f
C228 LELO_GR01_0.x7.x1.x5.x9<2>.G a_9738_16810# 0.07542f
C229 LELO_GR01_0.x7.x1.x5.x9<2>.G uio_out<5> 0.01805f
C230 LELO_GR01_0.x7.x1.x5.x9<2>.G uio_out<7> 0.10204f
C231 LELO_GR01_0.x7.x1.x7.D LELO_GR01_0.x7.x15.I2 0.05291f
C232 LELO_GR01_0.x7.x1.x7.D LELO_GR01_0.x7.x7.G 0.32129f
C233 LELO_GR01_0.x7.xd1<4>.A LELO_GR01_0.x7.x1.x7.D 0.3639f
C234 LELO_GR01_0.x8.PWRUP_N_1V8 LELO_GR01_0.x7.x1.x7.D 0.61217f
C235 LELO_GR01_0.x7.x1.x7.D VDPWR 7.31029f
C236 LELO_GR01_0.x7.x1.x7.D VGND 1.10877f
C237 LELO_GR01_0.x7.x1.x7.D a_11318_15928# 0.01243f
C238 LELO_GR01_0.x7.x1.x7.D a_11318_16728# 0.03662f
C239 LELO_GR01_0.x7.x1.x7.D a_11318_16986# 0.10629f
C240 LELO_GR01_0.x7.x1.x7.D a_11318_17786# 0.098f
C241 LELO_GR01_0.x7.x1.x7.D a_11996_18042# 0.04055f
C242 a_11996_18842# LELO_GR01_0.x7.x1.x7.D 0.01242f
C243 LELO_GR01_0.x7.x1.x7.D a_12688_16988# 0.07102f
C244 LELO_GR01_0.x7.x1.x7.D a_12688_17788# 0.07449f
C245 LELO_GR01_0.x7.x1.x7.D uio_out<4> 0.01f
C246 LELO_GR01_0.x7.x1.x7.D uio_out<6> 0.10988f
C247 LELO_GR01_0.x7.x10.P LELO_GR01_0.x7.x11.P 0.63589f
C248 LELO_GR01_0.x7.x15.I2 LELO_GR01_0.x7.x10.P 0.03015f
C249 LELO_GR01_0.x8.IBP_BG LELO_GR01_0.x7.x10.P 2.7181f
C250 LELO_GR01_0.x8.PWRUP_N_1V8 LELO_GR01_0.x7.x10.P 0.06805f
C251 LELO_GR01_0.x8.VREF_BG LELO_GR01_0.x7.x10.P 1.44036f
C252 LELO_GR01_0.x7.x10.P VDPWR 0.3368f
C253 LELO_GR01_0.x7.x10.P VGND 7.81512f
C254 a_16008_16644# LELO_GR01_0.x7.x10.P 0.06314f
C255 LELO_GR01_0.x7.x10.P a_16440_18564# 0.4588f
C256 LELO_GR01_0.x7.x10.P a_16872_18564# 0.21389f
C257 LELO_GR01_0.x7.x10.P a_17304_18564# 0.21331f
C258 LELO_GR01_0.x7.x10.P a_17736_18564# 0.21306f
C259 LELO_GR01_0.x7.x10.P a_18168_18564# 0.21304f
C260 LELO_GR01_0.x7.x10.P a_18600_18564# 0.21325f
C261 LELO_GR01_0.x7.x10.P a_19032_18564# 0.21365f
C262 LELO_GR01_0.x7.x10.P a_19680_16644# 0.05858f
C263 LELO_GR01_0.x7.x10.P a_20970_18564# 0.02289f
C264 LELO_GR01_0.x7.x10.P a_21402_18564# 0.02289f
C265 LELO_GR01_0.x7.x10.P a_21834_18564# 0.02289f
C266 LELO_GR01_0.x7.x10.P a_22266_18564# 0.02316f
C267 LELO_GR01_0.x7.x10.P a_22698_18564# 0.02376f
C268 LELO_GR01_0.x7.x10.P a_23130_18564# 0.02514f
C269 LELO_GR01_0.x7.x10.P a_23562_18564# 0.25167f
C270 LELO_GR01_0.x7.x10.P a_24210_16644# 0.01276f
C271 LELO_GR01_0.x7.x10.P uio_out<0> 0.03283f
C272 LELO_GR01_0.x7.x10.P uio_out<1> 0.04896f
C273 LELO_GR01_0.x7.x10.P uio_out<2> 0.05807f
C274 LELO_GR01_0.x7.x10.P uio_out<3> 0.01459f
C275 LELO_GR01_0.x7.x10.P uo_out<1> 0.05722f
C276 LELO_GR01_0.x7.x11.P LELO_GR01_0.x7.x11.N 0.16262f
C277 LELO_GR01_0.x7.x11.N LELO_GR01_0.x7.x26.P 0.04394f
C278 LELO_GR01_0.x8.VREF_BG LELO_GR01_0.x7.x11.N 0.06908f
C279 LELO_GR01_0.x7.x11.N VGND 5.29656f
C280 a_25078_16644# LELO_GR01_0.x7.x11.N 0.21168f
C281 LELO_GR01_0.x7.x11.N a_25510_18564# 0.25817f
C282 LELO_GR01_0.x7.x11.N a_28750_16644# 0.10442f
C283 LELO_GR01_0.x7.x11.N a_28934_15064# 0.2307f
C284 LELO_GR01_0.x7.x11.N a_29582_13144# 0.01976f
C285 LELO_GR01_0.x7.x11.N clk 0.29314f
C286 LELO_GR01_0.x7.x11.N ui_in<0> 0.09754f
C287 LELO_GR01_0.x7.x11.N uo_out<0> 0.13231f
C288 LELO_GR01_0.x8.IBP_BG LELO_GR01_0.x7.x11.P 0.16839f
C289 LELO_GR01_0.x8.PWRUP_N_1V8 LELO_GR01_0.x7.x11.P 0.1707f
C290 LELO_GR01_0.x8.VREF_BG LELO_GR01_0.x7.x11.P 0.63504f
C291 LELO_GR01_0.x7.x11.P VGND 7.72728f
C292 a_20538_16644# LELO_GR01_0.x7.x11.P 0.06522f
C293 LELO_GR01_0.x7.x11.P a_20970_18564# 0.42758f
C294 LELO_GR01_0.x7.x11.P a_21402_18564# 0.19339f
C295 LELO_GR01_0.x7.x11.P a_21834_18564# 0.19131f
C296 LELO_GR01_0.x7.x11.P a_22266_18564# 0.19042f
C297 LELO_GR01_0.x7.x11.P a_22698_18564# 0.19013f
C298 LELO_GR01_0.x7.x11.P a_23130_18564# 0.19038f
C299 LELO_GR01_0.x7.x11.P a_23562_18564# 0.19088f
C300 LELO_GR01_0.x7.x11.P a_24210_16644# 0.06053f
C301 LELO_GR01_0.x7.x11.P a_25510_18564# 0.01931f
C302 LELO_GR01_0.x7.x11.P a_25942_18564# 0.01931f
C303 LELO_GR01_0.x7.x11.P a_26374_18564# 0.01931f
C304 LELO_GR01_0.x7.x11.P a_26806_18564# 0.01958f
C305 LELO_GR01_0.x7.x11.P a_27238_18564# 0.02018f
C306 LELO_GR01_0.x7.x11.P a_27670_18564# 0.02157f
C307 LELO_GR01_0.x7.x11.P a_28102_18564# 0.24854f
C308 LELO_GR01_0.x7.x11.P a_28750_16644# 0.01898f
C309 LELO_GR01_0.x7.x11.P clk 0.07246f
C310 LELO_GR01_0.x7.x11.P rst_n 0.28408f
C311 LELO_GR01_0.x7.x11.P ui_in<0> 0.07149f
C312 LELO_GR01_0.x7.x11.P ui_in<1> 0.38289f
C313 LELO_GR01_0.x7.x11.P uo_out<0> 0.09473f
C314 LELO_GR01_0.x7.x15.I2 LELO_GR01_0.x7.x15.I1 2.57769f
C315 LELO_GR01_0.x7.x15.I1 LELO_GR01_0.x7.x28.e 0.05627f
C316 LELO_GR01_0.x7.x15.I1 LELO_GR01_0.x7.x3.P 0.03541f
C317 LELO_GR01_0.x7.x15.I1 LELO_GR01_0.x7.x31.N 0.01216f
C318 LELO_GR01_0.x7.x7.G LELO_GR01_0.x7.x15.I1 0.69304f
C319 LELO_GR01_0.x7.xd1<4>.A LELO_GR01_0.x7.x15.I1 0.33806f
C320 LELO_GR01_0.x7.x15.I1 VDPWR 0.55462f
C321 LELO_GR01_0.x7.x15.I1 VGND 25.3133f
C322 LELO_GR01_0.x7.x15.I1 a_10298_11234# 0.02053f
C323 LELO_GR01_0.x7.x15.I1 a_10412_8824# 0.01101f
C324 LELO_GR01_0.x7.x15.I1 a_10730_11234# 0.02053f
C325 LELO_GR01_0.x7.x15.I1 a_11060_6904# 0.01069f
C326 a_7148_11234# LELO_GR01_0.x7.x15.I1 0.09854f
C327 LELO_GR01_0.x7.x15.I1 a_7364_11234# 0.06462f
C328 LELO_GR01_0.x7.x15.I1 a_7580_13154# 0.27216f
C329 LELO_GR01_0.x7.x15.I1 a_7796_11234# 0.04112f
C330 LELO_GR01_0.x7.x15.I1 a_7820_8824# 0.01064f
C331 LELO_GR01_0.x7.x15.I1 a_8228_11234# 0.02669f
C332 LELO_GR01_0.x7.x15.I1 a_8252_8824# 0.01064f
C333 LELO_GR01_0.x7.x15.I1 a_8684_8824# 0.01064f
C334 LELO_GR01_0.x7.x15.I1 a_9116_8824# 0.01064f
C335 LELO_GR01_0.x7.x15.I1 a_9434_11234# 0.02053f
C336 LELO_GR01_0.x7.x15.I1 a_9548_8824# 0.01064f
C337 LELO_GR01_0.x7.x15.I1 a_9980_8824# 0.01064f
C338 LELO_GR01_0.x7.x15.I1 uio_out<1> 0.01164f
C339 LELO_GR01_0.x7.x15.I1 uio_out<2> 1.06698f
C340 LELO_GR01_0.x7.x15.I1 uio_out<3> 0.57917f
C341 LELO_GR01_0.x7.x15.I1 uio_out<4> 0.3883f
C342 LELO_GR01_0.x7.x15.I1 uio_out<5> 0.39276f
C343 LELO_GR01_0.x7.x15.I1 uio_out<6> 0.53673f
C344 LELO_GR01_0.x7.x15.I1 uio_out<7> 0.42103f
C345 LELO_GR01_0.x7.x15.I2 LELO_GR01_0.x7.x28.e 0.21636f
C346 LELO_GR01_0.x7.x15.I2 LELO_GR01_0.x7.x7.G 0.02302f
C347 LELO_GR01_0.x7.xd1<4>.A LELO_GR01_0.x7.x15.I2 4.47485f
C348 LELO_GR01_0.x8.PWRUP_N_1V8 LELO_GR01_0.x7.x15.I2 0.3419f
C349 LELO_GR01_0.x7.x15.I2 VDPWR 9.65015f
C350 LELO_GR01_0.x7.x15.I2 VGND 6.76826f
C351 LELO_GR01_0.x7.x15.I2 a_12688_15928# 0.09916f
C352 LELO_GR01_0.x7.x15.I2 a_12688_16728# 0.07212f
C353 LELO_GR01_0.x7.x15.I2 a_14358_11800# 0.05314f
C354 LELO_GR01_0.x7.x15.I2 a_14358_12600# 0.03227f
C355 LELO_GR01_0.x7.x15.I2 a_14358_12740# 0.03225f
C356 LELO_GR01_0.x7.x15.I2 a_14358_13540# 0.03213f
C357 LELO_GR01_0.x7.x15.I2 a_14358_13680# 0.03213f
C358 LELO_GR01_0.x7.x15.I2 a_14358_14480# 0.03247f
C359 LELO_GR01_0.x7.x15.I2 a_14358_14620# 0.03223f
C360 LELO_GR01_0.x7.x15.I2 a_14358_15420# 0.04814f
C361 LELO_GR01_0.x7.x15.I2 a_14358_15930# 0.04821f
C362 LELO_GR01_0.x7.x15.I2 a_14358_16730# 0.03295f
C363 LELO_GR01_0.x7.x15.I2 a_14358_16870# 0.03279f
C364 LELO_GR01_0.x7.x15.I2 a_14358_17670# 0.03213f
C365 LELO_GR01_0.x7.x15.I2 a_14358_17810# 0.03213f
C366 LELO_GR01_0.x7.x15.I2 a_14358_18610# 0.03213f
C367 LELO_GR01_0.x7.x15.I2 a_14358_18750# 0.03211f
C368 a_14358_19550# LELO_GR01_0.x7.x15.I2 0.01611f
C369 LELO_GR01_0.x7.x15.I2 uio_out<3> 0.17552f
C370 LELO_GR01_0.x7.x19.D LELO_GR01_0.x7.x18.D 0.52197f
C371 LELO_GR01_0.x7.x6<3>.G LELO_GR01_0.x7.x18.D 3.48833f
C372 LELO_GR01_0.x7.x18.D LELO_GR01_0.x7.x7.G 0.51952f
C373 LELO_GR01_0.x7.x18.D LELO_GR01_0.x7.x7.S 0.42102f
C374 LELO_GR01_0.x7.x18.D LELO_GR01_0.x7.xd1<4>.A 2.45274f
C375 LELO_GR01_0.x8.PWRUP_N_1V8 LELO_GR01_0.x7.x18.D 0.42659f
C376 LELO_GR01_0.x7.x18.D VDPWR 2.55647f
C377 LELO_GR01_0.x7.x18.D VGND 13.0258f
C378 LELO_GR01_0.x7.x18.D a_2478_19610# 0.01495f
C379 a_2478_20410# LELO_GR01_0.x7.x18.D 0.03962f
C380 LELO_GR01_0.x7.x18.D a_4578_11400# 0.05066f
C381 LELO_GR01_0.x7.x18.D a_4578_12200# 0.02079f
C382 LELO_GR01_0.x7.x18.D a_4578_17320# 0.07939f
C383 LELO_GR01_0.x7.x18.D a_4578_18120# 0.07864f
C384 LELO_GR01_0.x7.x18.D a_4578_18260# 0.07875f
C385 LELO_GR01_0.x7.x18.D a_4578_19060# 0.07857f
C386 LELO_GR01_0.x7.x18.D a_4578_19200# 0.0785f
C387 LELO_GR01_0.x7.x18.D a_4578_20000# 0.0784f
C388 LELO_GR01_0.x7.x18.D a_4578_20140# 0.07839f
C389 a_4578_20940# LELO_GR01_0.x7.x18.D 0.07043f
C390 LELO_GR01_0.x7.x19.D LELO_GR01_0.x7.x20.D 0.56721f
C391 LELO_GR01_0.x7.x19.D LELO_GR01_0.x7.xd1<4>.A 0.09695f
C392 LELO_GR01_0.x7.x19.D LELO_GR01_0.x8.PWRUP_N_1V8 1.01963f
C393 LELO_GR01_0.x7.x19.D VDPWR 0.4791f
C394 LELO_GR01_0.x7.x19.D VGND 0.17422f
C395 LELO_GR01_0.x7.x19.D a_2478_18300# 0.01255f
C396 LELO_GR01_0.x7.x19.D a_2478_19100# 0.04966f
C397 LELO_GR01_0.x7.x19.D a_2478_19610# 0.07959f
C398 a_2478_20410# LELO_GR01_0.x7.x19.D 0.0428f
C399 LELO_GR01_0.x7.x20.D LELO_GR01_0.x7.x21.D 0.57307f
C400 LELO_GR01_0.x7.xd1<4>.A LELO_GR01_0.x7.x20.D 0.09617f
C401 LELO_GR01_0.x8.PWRUP_N_1V8 LELO_GR01_0.x7.x20.D 1.01793f
C402 LELO_GR01_0.x7.x20.D VDPWR 0.43324f
C403 LELO_GR01_0.x7.x20.D VGND 0.1527f
C404 LELO_GR01_0.x7.x20.D a_2478_16990# 0.01256f
C405 LELO_GR01_0.x7.x20.D a_2478_17790# 0.0493f
C406 LELO_GR01_0.x7.x20.D a_2478_18300# 0.07916f
C407 a_2478_19100# LELO_GR01_0.x7.x20.D 0.04279f
C408 LELO_GR01_0.x7.x21.D LELO_GR01_0.x7.x22.D 0.56561f
C409 LELO_GR01_0.x7.xd1<4>.A LELO_GR01_0.x7.x21.D 0.0959f
C410 LELO_GR01_0.x8.PWRUP_N_1V8 LELO_GR01_0.x7.x21.D 1.01745f
C411 LELO_GR01_0.x7.x21.D VDPWR 0.43311f
C412 LELO_GR01_0.x7.x21.D VGND 0.15545f
C413 LELO_GR01_0.x7.x21.D a_2478_15680# 0.01254f
C414 LELO_GR01_0.x7.x21.D a_2478_16480# 0.04927f
C415 LELO_GR01_0.x7.x21.D a_2478_16990# 0.07916f
C416 a_2478_17790# LELO_GR01_0.x7.x21.D 0.04278f
C417 LELO_GR01_0.x7.x22.D LELO_GR01_0.x7.x23.D 0.57781f
C418 LELO_GR01_0.x7.xd1<4>.A LELO_GR01_0.x7.x22.D 0.09541f
C419 LELO_GR01_0.x8.PWRUP_N_1V8 LELO_GR01_0.x7.x22.D 1.03144f
C420 LELO_GR01_0.x7.x22.D VDPWR 0.43684f
C421 LELO_GR01_0.x7.x22.D VGND 0.15244f
C422 LELO_GR01_0.x7.x22.D a_2478_14370# 0.01255f
C423 LELO_GR01_0.x7.x22.D a_2478_15170# 0.05206f
C424 LELO_GR01_0.x7.x22.D a_2478_15680# 0.0773f
C425 a_2478_16480# LELO_GR01_0.x7.x22.D 0.04278f
C426 LELO_GR01_0.x7.x23.D LELO_GR01_0.x7.x24.D 0.57215f
C427 LELO_GR01_0.x7.xd1<4>.A LELO_GR01_0.x7.x23.D 0.0959f
C428 LELO_GR01_0.x8.PWRUP_N_1V8 LELO_GR01_0.x7.x23.D 1.01794f
C429 LELO_GR01_0.x7.x23.D VDPWR 0.43248f
C430 LELO_GR01_0.x7.x23.D VGND 0.15069f
C431 LELO_GR01_0.x7.x23.D a_2478_13060# 0.01256f
C432 LELO_GR01_0.x7.x23.D a_2478_13860# 0.04931f
C433 LELO_GR01_0.x7.x23.D a_2478_14370# 0.07916f
C434 a_2478_15170# LELO_GR01_0.x7.x23.D 0.04279f
C435 LELO_GR01_0.x7.x24.D LELO_GR01_0.x7.x25.D 0.56743f
C436 LELO_GR01_0.x7.xd1<4>.A LELO_GR01_0.x7.x24.D 0.09098f
C437 LELO_GR01_0.x8.PWRUP_N_1V8 LELO_GR01_0.x7.x24.D 1.02091f
C438 LELO_GR01_0.x7.x24.D VDPWR 0.43683f
C439 LELO_GR01_0.x7.x24.D VGND 0.16253f
C440 LELO_GR01_0.x7.x24.D a_2478_11750# 0.01255f
C441 LELO_GR01_0.x7.x24.D a_2478_12550# 0.05011f
C442 LELO_GR01_0.x7.x24.D a_2478_13060# 0.0791f
C443 a_2478_13860# LELO_GR01_0.x7.x24.D 0.04279f
C444 LELO_GR01_0.x7.x25.D LELO_GR01_0.x7.x30.N 0.54315f
C445 LELO_GR01_0.x8.PWRUP_N_1V8 LELO_GR01_0.x7.x25.D 1.02027f
C446 LELO_GR01_0.x7.x25.D VDPWR 0.43471f
C447 LELO_GR01_0.x7.x25.D VGND 0.39447f
C448 LELO_GR01_0.x7.x25.D a_2478_10440# 0.01257f
C449 LELO_GR01_0.x7.x25.D a_2478_11240# 0.04975f
C450 LELO_GR01_0.x7.x25.D a_2478_11750# 0.07869f
C451 a_2478_12550# LELO_GR01_0.x7.x25.D 0.04279f
C452 LELO_GR01_0.x7.x26.P VGND 2.10449f
C453 a_26134_15064# LELO_GR01_0.x7.x26.P 0.22964f
C454 LELO_GR01_0.x7.x26.P a_26782_13144# 0.0187f
C455 LELO_GR01_0.x7.x26.P a_27638_13144# 0.0187f
C456 LELO_GR01_0.x7.x26.P a_28070_15064# 0.22899f
C457 LELO_GR01_0.x7.x26.P ui_in<0> 0.06911f
C458 LELO_GR01_0.x7.x26.P uo_out<0> 0.03053f
C459 LELO_GR01_0.x7.x28.e LELO_GR01_0.x7.x29.N 0.91898f
C460 LELO_GR01_0.x8.PWRUP_N_1V8 LELO_GR01_0.x7.x28.e 0.12865f
C461 LELO_GR01_0.x7.x28.e VDPWR 0.35007f
C462 LELO_GR01_0.x7.x28.e VGND 10.3784f
C463 a_15998_13144# LELO_GR01_0.x7.x28.e 0.30444f
C464 LELO_GR01_0.x7.x28.e a_16214_13144# 0.20525f
C465 LELO_GR01_0.x7.x28.e a_16646_13144# 0.07609f
C466 LELO_GR01_0.x7.x28.e a_17508_13144# 0.04363f
C467 LELO_GR01_0.x7.x28.e uio_out<0> 0.3811f
C468 LELO_GR01_0.x7.x28.e uio_out<1> 0.23521f
C469 LELO_GR01_0.x7.x28.e uio_out<2> 0.35348f
C470 LELO_GR01_0.x7.x28.e uio_out<3> 0.12044f
C471 LELO_GR01_0.x7.x28.e uo_out<1> 0.54298f
C472 LELO_GR01_0.x7.x29.N LELO_GR01_0.x7.x29.P 1.20691f
C473 LELO_GR01_0.x8.IBP_BG LELO_GR01_0.x7.x29.N 0.06106f
C474 LELO_GR01_0.x8.PWRUP_N_1V8 LELO_GR01_0.x7.x29.N 0.14909f
C475 LELO_GR01_0.x7.x29.N VDPWR 0.22571f
C476 LELO_GR01_0.x7.x29.N VGND 8.08216f
C477 LELO_GR01_0.x7.x29.N a_16646_13144# 0.01236f
C478 a_16656_16644# LELO_GR01_0.x7.x29.N 0.01466f
C479 a_17088_16644# LELO_GR01_0.x7.x29.N 0.01466f
C480 a_17520_16644# LELO_GR01_0.x7.x29.N 0.01466f
C481 a_17952_16644# LELO_GR01_0.x7.x29.N 0.01208f
C482 LELO_GR01_0.x7.x29.N a_18156_13144# 0.01879f
C483 LELO_GR01_0.x7.x29.N a_19018_13144# 0.03827f
C484 LELO_GR01_0.x7.x29.N a_19666_13144# 0.02984f
C485 LELO_GR01_0.x7.x29.N a_20528_13144# 0.04127f
C486 LELO_GR01_0.x7.x29.N a_21176_13144# 0.02984f
C487 LELO_GR01_0.x7.x29.N a_22038_13144# 0.04014f
C488 LELO_GR01_0.x7.x29.N a_22470_15064# 0.24016f
C489 LELO_GR01_0.x7.x29.N uio_out<0> 0.05587f
C490 LELO_GR01_0.x7.x29.N uio_out<1> 0.02337f
C491 LELO_GR01_0.x7.x29.N uo_out<1> 0.06767f
C492 LELO_GR01_0.x8.IBP_BG LELO_GR01_0.x7.x29.P 0.1622f
C493 LELO_GR01_0.x8.PWRUP_N_1V8 LELO_GR01_0.x7.x29.P 0.23048f
C494 LELO_GR01_0.x8.VREF_BG LELO_GR01_0.x7.x29.P 0.14936f
C495 LELO_GR01_0.x7.x29.P VGND 8.73417f
C496 LELO_GR01_0.x7.x29.P a_19666_13144# 0.01241f
C497 a_20754_16644# LELO_GR01_0.x7.x29.P 0.01898f
C498 LELO_GR01_0.x7.x29.P a_21176_13144# 0.01231f
C499 a_21186_16644# LELO_GR01_0.x7.x29.P 0.0199f
C500 a_21618_16644# LELO_GR01_0.x7.x29.P 0.0199f
C501 a_22050_16644# LELO_GR01_0.x7.x29.P 0.0199f
C502 LELO_GR01_0.x7.x29.P a_22470_15064# 0.01622f
C503 a_22482_16644# LELO_GR01_0.x7.x29.P 0.0199f
C504 LELO_GR01_0.x7.x29.P a_22902_15064# 0.04653f
C505 a_22914_16644# LELO_GR01_0.x7.x29.P 0.0199f
C506 LELO_GR01_0.x7.x29.P a_23334_15064# 0.51417f
C507 a_23346_16644# LELO_GR01_0.x7.x29.P 0.01299f
C508 LELO_GR01_0.x7.x29.P a_23982_13144# 0.0187f
C509 LELO_GR01_0.x7.x29.P a_24838_13144# 0.0187f
C510 LELO_GR01_0.x7.x29.P a_25270_15064# 0.22899f
C511 LELO_GR01_0.x7.x7.G LELO_GR01_0.x7.x3.P 0.20121f
C512 LELO_GR01_0.x7.x3.P VGND 2.43021f
C513 a_7580_13154# LELO_GR01_0.x7.x3.P 0.22899f
C514 LELO_GR01_0.x7.x3.P a_8228_11234# 0.0187f
C515 LELO_GR01_0.x7.x3.P a_9218_11234# 0.01873f
C516 LELO_GR01_0.x7.x3.P a_9650_13154# 0.22903f
C517 LELO_GR01_0.x7.x3.P uio_out<7> 0.01622f
C518 LELO_GR01_0.x8.PWRUP_N_1V8 LELO_GR01_0.x7.x30.N 0.53533f
C519 LELO_GR01_0.x7.x30.N VDPWR 0.23821f
C520 LELO_GR01_0.x7.x30.N VGND 1.67117f
C521 LELO_GR01_0.x7.x30.N a_2478_10440# 0.07269f
C522 a_2478_11240# LELO_GR01_0.x7.x30.N 0.04279f
C523 LELO_GR01_0.x7.x30.N a_2858_6904# 0.01888f
C524 LELO_GR01_0.x7.x30.N a_3290_8824# 0.22921f
C525 LELO_GR01_0.x7.x31.N VDPWR 0.02499f
C526 LELO_GR01_0.x7.x31.N VGND 2.27863f
C527 a_5882_8824# LELO_GR01_0.x7.x31.N 0.22923f
C528 LELO_GR01_0.x7.x31.N a_6530_6904# 0.0187f
C529 LELO_GR01_0.x7.x31.N a_7388_6904# 0.0187f
C530 LELO_GR01_0.x7.x31.N a_7820_8824# 0.22899f
C531 LELO_GR01_0.x7.x6<3>.G LELO_GR01_0.x7.x7.G 0.18658f
C532 LELO_GR01_0.x7.x6<3>.G LELO_GR01_0.x7.x7.S 4.34539f
C533 LELO_GR01_0.x7.x6<3>.G LELO_GR01_0.x7.xd1<4>.A 2.42153f
C534 LELO_GR01_0.x7.x6<3>.G LELO_GR01_0.x8.PWRUP_N_1V8 0.15085f
C535 LELO_GR01_0.x7.x6<3>.G VDPWR 0.49558f
C536 LELO_GR01_0.x7.x6<3>.G VGND 10.1995f
C537 LELO_GR01_0.x7.x6<3>.G a_4578_13670# 0.0833f
C538 LELO_GR01_0.x7.x6<3>.G a_4578_14470# 0.17387f
C539 LELO_GR01_0.x7.x6<3>.G a_4578_15270# 0.1739f
C540 LELO_GR01_0.x7.x6<3>.G a_4578_16070# 0.17405f
C541 LELO_GR01_0.x7.x6<3>.G a_4578_17320# 0.08841f
C542 LELO_GR01_0.x7.x6<3>.G a_4578_18120# 0.06124f
C543 LELO_GR01_0.x7.x6<3>.G a_4578_18260# 0.06119f
C544 LELO_GR01_0.x7.x6<3>.G a_4578_19060# 0.06102f
C545 LELO_GR01_0.x7.x6<3>.G a_4578_19200# 0.06102f
C546 LELO_GR01_0.x7.x6<3>.G a_4578_20000# 0.06102f
C547 LELO_GR01_0.x7.x6<3>.G a_4578_20140# 0.061f
C548 a_4578_20940# LELO_GR01_0.x7.x6<3>.G 0.04269f
C549 LELO_GR01_0.x7.x6<3>.G a_4580_16870# 0.13443f
C550 LELO_GR01_0.x7.x7.S LELO_GR01_0.x7.x7.G 1.15979f
C551 LELO_GR01_0.x7.xd1<4>.A LELO_GR01_0.x7.x7.G 1.12158f
C552 LELO_GR01_0.x8.PWRUP_N_1V8 LELO_GR01_0.x7.x7.G 0.02474f
C553 LELO_GR01_0.x7.x7.G VDPWR 3.02386f
C554 LELO_GR01_0.x7.x7.G VGND 11.3367f
C555 LELO_GR01_0.x7.x7.G a_10082_13154# 0.05129f
C556 LELO_GR01_0.x7.x7.G a_10514_13154# 0.33397f
C557 LELO_GR01_0.x7.x7.G a_11162_11234# 0.08158f
C558 LELO_GR01_0.x7.x7.G a_11318_15928# 0.08481f
C559 a_11318_16728# LELO_GR01_0.x7.x7.G 0.07043f
C560 LELO_GR01_0.x7.x7.G a_11988_14620# 0.05469f
C561 LELO_GR01_0.x7.x7.G a_11988_15420# 0.01283f
C562 LELO_GR01_0.x7.x7.G a_4578_12610# 0.07253f
C563 LELO_GR01_0.x7.x7.G a_4578_13410# 0.10005f
C564 LELO_GR01_0.x7.x7.G a_4578_13670# 0.0231f
C565 LELO_GR01_0.x7.x7.G a_7148_11234# 0.05006f
C566 LELO_GR01_0.x7.x7.G a_7580_13154# 0.09893f
C567 LELO_GR01_0.x7.x7.G a_8228_11234# 0.04878f
C568 LELO_GR01_0.x7.x7.G a_9218_11234# 0.04833f
C569 LELO_GR01_0.x7.x7.G a_9650_13154# 0.0567f
C570 LELO_GR01_0.x7.x7.G uio_out<4> 0.16199f
C571 LELO_GR01_0.x7.x7.G uio_out<5> 0.09837f
C572 LELO_GR01_0.x7.x7.G uio_out<6> 0.21147f
C573 LELO_GR01_0.x7.x7.G uio_out<7> 0.1275f
C574 LELO_GR01_0.x7.x7.S VDPWR 0.2479f
C575 LELO_GR01_0.x7.x7.S VGND 1.26725f
C576 LELO_GR01_0.x7.x7.S a_4578_12610# 0.04269f
C577 LELO_GR01_0.x7.x7.S a_4578_13410# 0.06641f
C578 LELO_GR01_0.x7.x7.S a_4578_13670# 0.06807f
C579 LELO_GR01_0.x7.x7.S a_4578_14470# 0.0891f
C580 LELO_GR01_0.x7.x7.S a_4578_15270# 0.0891f
C581 LELO_GR01_0.x7.x7.S a_4578_16070# 0.08918f
C582 a_4580_16870# LELO_GR01_0.x7.x7.S 0.04272f
C583 LELO_GR01_0.x7.xd1<4>.A LELO_GR01_0.x8.IBP_BG 0.45185f
C584 LELO_GR01_0.x8.PWRUP_N_1V8 LELO_GR01_0.x7.xd1<4>.A 1.91875f
C585 LELO_GR01_0.x7.xd1<4>.A LELO_GR01_0.x8.VREF_BG 0.4353f
C586 LELO_GR01_0.x7.xd1<4>.A VDPWR 58.054f
C587 LELO_GR01_0.x7.xd1<4>.A VGND 25.2676f
C588 LELO_GR01_0.x7.xd1<4>.A a_10730_11234# 0.011f
C589 LELO_GR01_0.x7.xd1<4>.A a_11162_11234# 0.06208f
C590 LELO_GR01_0.x7.xd1<4>.A a_11988_14620# 0.08893f
C591 LELO_GR01_0.x7.xd1<4>.A a_11988_15420# 0.09528f
C592 LELO_GR01_0.x7.xd1<4>.A a_12688_15928# 0.05702f
C593 LELO_GR01_0.x7.xd1<4>.A a_12688_16728# 0.03598f
C594 LELO_GR01_0.x7.xd1<4>.A a_12688_16988# 0.03591f
C595 LELO_GR01_0.x7.xd1<4>.A a_12688_17788# 0.0373f
C596 LELO_GR01_0.x7.xd1<4>.A a_12688_20180# 0.04612f
C597 LELO_GR01_0.x7.xd1<4>.A a_12688_20980# 0.05114f
C598 LELO_GR01_0.x7.xd1<4>.A a_14358_11800# 0.07393f
C599 LELO_GR01_0.x7.xd1<4>.A a_14358_12600# 0.07768f
C600 LELO_GR01_0.x7.xd1<4>.A a_14358_12740# 0.07768f
C601 LELO_GR01_0.x7.xd1<4>.A a_14358_13540# 0.07768f
C602 LELO_GR01_0.x7.xd1<4>.A a_14358_13680# 0.07768f
C603 LELO_GR01_0.x7.xd1<4>.A a_14358_14480# 0.07695f
C604 LELO_GR01_0.x7.xd1<4>.A a_14358_14620# 0.07579f
C605 LELO_GR01_0.x7.xd1<4>.A a_14358_15420# 0.07873f
C606 LELO_GR01_0.x7.xd1<4>.A a_14358_15930# 0.07778f
C607 LELO_GR01_0.x7.xd1<4>.A a_14358_16730# 0.07579f
C608 LELO_GR01_0.x7.xd1<4>.A a_14358_16870# 0.07585f
C609 LELO_GR01_0.x7.xd1<4>.A a_14358_17670# 0.07584f
C610 LELO_GR01_0.x7.xd1<4>.A a_14358_17810# 0.07582f
C611 LELO_GR01_0.x7.xd1<4>.A a_14358_18610# 0.07599f
C612 LELO_GR01_0.x7.xd1<4>.A a_14358_18750# 0.07602f
C613 LELO_GR01_0.x7.xd1<4>.A a_14358_19550# 0.08223f
C614 LELO_GR01_0.x7.xd1<4>.A a_15998_13144# 0.01383f
C615 LELO_GR01_0.x7.xd1<4>.A a_16018_19950# 0.07055f
C616 LELO_GR01_0.x7.xd1<4>.A a_16018_20750# 0.08612f
C617 LELO_GR01_0.x7.xd1<4>.A a_17668_19950# 0.07043f
C618 LELO_GR01_0.x7.xd1<4>.A a_17668_20750# 0.07801f
C619 LELO_GR01_0.x7.xd1<4>.A a_4578_11400# 0.07043f
C620 LELO_GR01_0.x7.xd1<4>.A a_4578_12200# 0.07078f
C621 LELO_GR01_0.x7.xd1<4>.A a_4578_17320# 0.01267f
C622 LELO_GR01_0.x7.xd1<4>.A a_4578_18120# 0.02712f
C623 LELO_GR01_0.x7.xd1<4>.A a_4578_18260# 0.02715f
C624 LELO_GR01_0.x7.xd1<4>.A a_4578_19060# 0.02715f
C625 LELO_GR01_0.x7.xd1<4>.A a_4578_19200# 0.02715f
C626 LELO_GR01_0.x7.xd1<4>.A a_4578_20000# 0.02741f
C627 LELO_GR01_0.x7.xd1<4>.A a_4578_20140# 0.02747f
C628 a_4578_20940# LELO_GR01_0.x7.xd1<4>.A 0.05431f
C629 LELO_GR01_0.x7.xd1<4>.A a_8552_20648# 0.03101f
C630 LELO_GR01_0.x7.xd1<4>.A uio_out<0> 0.21254f
C631 LELO_GR01_0.x7.xd1<4>.A uio_out<1> 0.06506f
C632 LELO_GR01_0.x7.xd1<4>.A uio_out<2> 0.27174f
C633 LELO_GR01_0.x7.xd1<4>.A uio_out<3> 0.36401f
C634 LELO_GR01_0.x7.xd1<4>.A uio_out<4> 0.08673f
C635 LELO_GR01_0.x7.xd1<4>.A uio_out<5> 0.20486f
C636 LELO_GR01_0.x7.xd1<4>.A uio_out<6> 0.09982f
C637 LELO_GR01_0.x7.xd1<4>.A uio_out<7> 0.07756f
C638 LELO_GR01_0.x7.xd1<4>.A uo_out<1> 0.11426f
C639 LELO_GR01_0.x8.PWRUP_N_1V8 LELO_GR01_0.x8.IBP_BG 1.4098f
C640 LELO_GR01_0.x8.VREF_BG LELO_GR01_0.x8.IBP_BG 1.82271f
C641 LELO_GR01_0.x8.IBP_BG LELO_GR01_0.x8.x1.x5.IBN 1.10788f
C642 LELO_GR01_0.x8.IBP_BG LELO_GR01_0.x8.x1.x5.x9<2>.G 0.07847f
C643 LELO_GR01_0.x8.IBP_BG LELO_GR01_0.x8.x1.x7.D 0.377f
C644 LELO_GR01_0.x8.IBP_BG LELO_GR01_0.x8.x5.CK 0.46839f
C645 LELO_GR01_0.x8.IBP_BG LELO_GR01_0.x8.x7.D 0.03708f
C646 LELO_GR01_0.x8.IBP_BG VDPWR 2.13452f
C647 LELO_GR01_0.x8.IBP_BG VGND 37.8418f
C648 LELO_GR01_0.x8.IBP_BG a_17668_19950# 0.0283f
C649 a_17668_20750# LELO_GR01_0.x8.IBP_BG 0.03792f
C650 LELO_GR01_0.x8.IBP_BG a_17850_4665# 0.01485f
C651 LELO_GR01_0.x8.IBP_BG a_17850_5465# 0.03728f
C652 LELO_GR01_0.x8.IBP_BG a_20372_11267# 0.01653f
C653 LELO_GR01_0.x8.IBP_BG a_20372_12347# 0.02366f
C654 LELO_GR01_0.x8.IBP_BG a_20970_18564# 0.01309f
C655 LELO_GR01_0.x8.IBP_BG a_21402_18564# 0.0178f
C656 LELO_GR01_0.x8.IBP_BG a_21618_16644# 0.01094f
C657 LELO_GR01_0.x8.IBP_BG a_21834_18564# 0.02548f
C658 LELO_GR01_0.x8.IBP_BG a_22038_13144# 0.03219f
C659 LELO_GR01_0.x8.IBP_BG a_22050_16644# 0.02573f
C660 LELO_GR01_0.x8.IBP_BG a_22254_13144# 0.03642f
C661 LELO_GR01_0.x8.IBP_BG a_22266_18564# 0.0466f
C662 LELO_GR01_0.x8.IBP_BG a_22292_11483# 0.05119f
C663 LELO_GR01_0.x8.IBP_BG a_22292_11915# 0.03977f
C664 LELO_GR01_0.x8.IBP_BG a_22470_15064# 0.08629f
C665 LELO_GR01_0.x8.IBP_BG a_22482_16644# 0.06888f
C666 LELO_GR01_0.x8.IBP_BG a_22686_13144# 0.03845f
C667 LELO_GR01_0.x8.IBP_BG a_22698_18564# 0.0399f
C668 LELO_GR01_0.x8.IBP_BG a_23138_7627# 0.08779f
C669 LELO_GR01_0.x8.IBP_BG a_23138_8427# 0.07321f
C670 LELO_GR01_0.x8.IBP_BG a_26146_4651# 0.01392f
C671 LELO_GR01_0.x8.IBP_BG a_26146_5451# 0.03731f
C672 LELO_GR01_0.x8.IBP_BG ui_in<0> 0.01825f
C673 LELO_GR01_0.x8.IBP_BG uo_out<0> 0.27142f
C674 LELO_GR01_0.x8.IBP_BG uo_out<1> 0.04639f
C675 LELO_GR01_0.x8.PWRUP_N_1V8 LELO_GR01_0.x8.VREF_BG 0.13591f
C676 LELO_GR01_0.x8.PWRUP_N_1V8 LELO_GR01_0.x8.x1.x5.IBN 0.16671f
C677 LELO_GR01_0.x8.PWRUP_N_1V8 LELO_GR01_0.x8.x1.x5.x8.G 0.10125f
C678 LELO_GR01_0.x8.x1.x5.x8.S LELO_GR01_0.x8.PWRUP_N_1V8 0.87651f
C679 LELO_GR01_0.x8.PWRUP_N_1V8 LELO_GR01_0.x8.x1.x5.x9<2>.G 0.46786f
C680 LELO_GR01_0.x8.PWRUP_N_1V8 LELO_GR01_0.x8.x7.D 0.35908f
C681 LELO_GR01_0.x8.x8.D LELO_GR01_0.x8.PWRUP_N_1V8 0.33775f
C682 LELO_GR01_0.x8.PWRUP_N_1V8 VDPWR 27.4238f
C683 LELO_GR01_0.x8.PWRUP_N_1V8 VGND 38.2023f
C684 LELO_GR01_0.x8.PWRUP_N_1V8 a_16008_16644# 0.034f
C685 LELO_GR01_0.x8.PWRUP_N_1V8 a_16224_16644# 0.02887f
C686 LELO_GR01_0.x8.PWRUP_N_1V8 a_16656_16644# 0.02887f
C687 LELO_GR01_0.x8.PWRUP_N_1V8 a_17088_16644# 0.02887f
C688 LELO_GR01_0.x8.PWRUP_N_1V8 a_17520_16644# 0.02887f
C689 LELO_GR01_0.x8.PWRUP_N_1V8 a_17850_4665# 0.07043f
C690 LELO_GR01_0.x8.PWRUP_N_1V8 a_17850_5465# 0.07736f
C691 LELO_GR01_0.x8.PWRUP_N_1V8 a_17952_16644# 0.02887f
C692 LELO_GR01_0.x8.PWRUP_N_1V8 a_18384_16644# 0.02887f
C693 LELO_GR01_0.x8.PWRUP_N_1V8 a_18456_11509# 0.08225f
C694 LELO_GR01_0.x8.PWRUP_N_1V8 a_18456_12309# 0.07206f
C695 LELO_GR01_0.x8.PWRUP_N_1V8 a_18816_16644# 0.02887f
C696 LELO_GR01_0.x8.PWRUP_N_1V8 a_19248_16644# 0.02887f
C697 LELO_GR01_0.x8.PWRUP_N_1V8 a_19356_6659# 0.07971f
C698 LELO_GR01_0.x8.PWRUP_N_1V8 a_19356_7459# 0.07091f
C699 LELO_GR01_0.x8.PWRUP_N_1V8 a_19680_16644# 0.03243f
C700 LELO_GR01_0.x8.PWRUP_N_1V8 a_20372_11699# 0.01391f
C701 LELO_GR01_0.x8.PWRUP_N_1V8 a_20372_12347# 0.07092f
C702 LELO_GR01_0.x8.PWRUP_N_1V8 a_20412_20378# 0.01046f
C703 LELO_GR01_0.x8.PWRUP_N_1V8 a_20412_20698# 0.01772f
C704 LELO_GR01_0.x8.PWRUP_N_1V8 a_20528_13144# 0.0267f
C705 LELO_GR01_0.x8.PWRUP_N_1V8 a_20538_16644# 0.05456f
C706 LELO_GR01_0.x8.PWRUP_N_1V8 a_20744_13144# 0.03895f
C707 LELO_GR01_0.x8.PWRUP_N_1V8 a_20754_16644# 0.0649f
C708 LELO_GR01_0.x8.PWRUP_N_1V8 a_20970_18564# 0.04424f
C709 LELO_GR01_0.x8.PWRUP_N_1V8 a_21176_13144# 0.04497f
C710 LELO_GR01_0.x8.PWRUP_N_1V8 a_21186_16644# 0.03733f
C711 LELO_GR01_0.x8.PWRUP_N_1V8 a_21252_20378# 0.0124f
C712 LELO_GR01_0.x8.PWRUP_N_1V8 a_21252_20698# 0.01772f
C713 LELO_GR01_0.x8.PWRUP_N_1V8 a_21402_18564# 0.02214f
C714 LELO_GR01_0.x8.PWRUP_N_1V8 a_21618_16644# 0.01686f
C715 LELO_GR01_0.x8.PWRUP_N_1V8 a_22038_13144# 0.01311f
C716 LELO_GR01_0.x8.PWRUP_N_1V8 a_22292_11483# 0.02242f
C717 LELO_GR01_0.x8.PWRUP_N_1V8 a_22292_11915# 0.09379f
C718 LELO_GR01_0.x8.PWRUP_N_1V8 a_23824_11183# 0.07045f
C719 LELO_GR01_0.x8.PWRUP_N_1V8 a_23824_11983# 0.0783f
C720 LELO_GR01_0.x8.PWRUP_N_1V8 a_24510_6435# 0.07045f
C721 LELO_GR01_0.x8.PWRUP_N_1V8 a_24510_7235# 0.07874f
C722 LELO_GR01_0.x8.PWRUP_N_1V8 a_2478_10440# 0.07043f
C723 LELO_GR01_0.x8.PWRUP_N_1V8 a_2478_11240# 0.08228f
C724 LELO_GR01_0.x8.PWRUP_N_1V8 a_2478_11750# 0.07785f
C725 LELO_GR01_0.x8.PWRUP_N_1V8 a_2478_12550# 0.08238f
C726 LELO_GR01_0.x8.PWRUP_N_1V8 a_2478_13060# 0.07785f
C727 LELO_GR01_0.x8.PWRUP_N_1V8 a_2478_13860# 0.08228f
C728 LELO_GR01_0.x8.PWRUP_N_1V8 a_2478_14370# 0.07785f
C729 LELO_GR01_0.x8.PWRUP_N_1V8 a_2478_15170# 0.08238f
C730 LELO_GR01_0.x8.PWRUP_N_1V8 a_2478_15680# 0.07785f
C731 LELO_GR01_0.x8.PWRUP_N_1V8 a_2478_16480# 0.08228f
C732 LELO_GR01_0.x8.PWRUP_N_1V8 a_2478_16990# 0.07785f
C733 LELO_GR01_0.x8.PWRUP_N_1V8 a_2478_17790# 0.08228f
C734 LELO_GR01_0.x8.PWRUP_N_1V8 a_2478_18300# 0.07785f
C735 LELO_GR01_0.x8.PWRUP_N_1V8 a_2478_19100# 0.08243f
C736 LELO_GR01_0.x8.PWRUP_N_1V8 a_2478_19610# 0.07797f
C737 a_2478_20410# LELO_GR01_0.x8.PWRUP_N_1V8 0.08598f
C738 LELO_GR01_0.x8.PWRUP_N_1V8 a_6636_19810# 0.08178f
C739 LELO_GR01_0.x8.PWRUP_N_1V8 a_6636_20610# 0.07596f
C740 LELO_GR01_0.x8.PWRUP_N_1V8 a_7536_14960# 0.0713f
C741 LELO_GR01_0.x8.PWRUP_N_1V8 a_7536_15760# 0.06872f
C742 LELO_GR01_0.x8.PWRUP_N_1V8 uio_out<0> 0.02731f
C743 LELO_GR01_0.x8.PWRUP_N_1V8 uio_out<1> 0.02629f
C744 LELO_GR01_0.x8.PWRUP_N_1V8 uio_out<2> 0.02454f
C745 LELO_GR01_0.x8.PWRUP_N_1V8 uio_out<3> 0.03782f
C746 LELO_GR01_0.x8.PWRUP_N_1V8 uio_out<4> 0.03085f
C747 LELO_GR01_0.x8.PWRUP_N_1V8 uio_out<5> 0.0321f
C748 LELO_GR01_0.x8.PWRUP_N_1V8 uio_out<6> 0.03873f
C749 LELO_GR01_0.x8.PWRUP_N_1V8 uio_out<7> 0.04187f
C750 LELO_GR01_0.x8.PWRUP_N_1V8 uo_out<0> 0.01287f
C751 LELO_GR01_0.x8.PWRUP_N_1V8 uo_out<1> 0.08617f
C752 LELO_GR01_0.x8.VREF_BG LELO_GR01_0.x8.x1.x5.IBN 0.70178f
C753 LELO_GR01_0.x8.VREF_BG LELO_GR01_0.x8.x1.x7.D 0.28036f
C754 LELO_GR01_0.x8.VREF_BG LELO_GR01_0.x8.x7.D 0.39898f
C755 LELO_GR01_0.x8.x8.D LELO_GR01_0.x8.VREF_BG 0.24928f
C756 LELO_GR01_0.x8.VREF_BG VDPWR 2.41605f
C757 LELO_GR01_0.x8.VREF_BG VGND 10.0575f
C758 LELO_GR01_0.x8.VREF_BG a_16018_19950# 0.03062f
C759 a_16018_20750# LELO_GR01_0.x8.VREF_BG 0.01293f
C760 LELO_GR01_0.x8.VREF_BG a_16440_18564# 0.12517f
C761 LELO_GR01_0.x8.VREF_BG a_16872_18564# 0.31305f
C762 LELO_GR01_0.x8.VREF_BG a_17304_18564# 0.31305f
C763 LELO_GR01_0.x8.VREF_BG a_17668_19950# 0.0186f
C764 LELO_GR01_0.x8.VREF_BG a_17736_18564# 0.31305f
C765 LELO_GR01_0.x8.VREF_BG a_18168_18564# 0.31368f
C766 LELO_GR01_0.x8.VREF_BG a_18600_18564# 0.32824f
C767 LELO_GR01_0.x8.VREF_BG a_19032_18564# 0.54196f
C768 LELO_GR01_0.x8.VREF_BG a_19680_16644# 0.01441f
C769 LELO_GR01_0.x8.VREF_BG a_20970_18564# 0.06457f
C770 LELO_GR01_0.x8.VREF_BG a_21402_18564# 0.06457f
C771 LELO_GR01_0.x8.VREF_BG a_21834_18564# 0.06457f
C772 LELO_GR01_0.x8.VREF_BG a_22266_18564# 0.06457f
C773 LELO_GR01_0.x8.VREF_BG a_22698_18564# 0.06458f
C774 LELO_GR01_0.x8.VREF_BG a_23130_18564# 0.06791f
C775 LELO_GR01_0.x8.VREF_BG a_23550_13144# 0.01123f
C776 LELO_GR01_0.x8.VREF_BG a_23562_18564# 0.07133f
C777 LELO_GR01_0.x8.VREF_BG a_23778_16644# 0.01749f
C778 LELO_GR01_0.x8.VREF_BG a_23982_13144# 0.02375f
C779 LELO_GR01_0.x8.VREF_BG a_24210_16644# 0.03359f
C780 LELO_GR01_0.x8.VREF_BG a_24508_7627# 0.08035f
C781 LELO_GR01_0.x8.VREF_BG a_24508_8427# 0.08053f
C782 LELO_GR01_0.x8.VREF_BG a_24838_13144# 0.03116f
C783 LELO_GR01_0.x8.VREF_BG a_25054_13144# 0.01616f
C784 LELO_GR01_0.x8.VREF_BG a_25270_15064# 0.01345f
C785 LELO_GR01_0.x8.VREF_BG a_25294_16644# 0.01024f
C786 LELO_GR01_0.x8.VREF_BG uio_out<0> 0.06622f
C787 LELO_GR01_0.x8.VREF_BG uio_out<1> 0.02962f
C788 LELO_GR01_0.x8.VREF_BG uo_out<1> 0.09992f
C789 LELO_GR01_0.x8.x1.x5.x9<2>.G LELO_GR01_0.x8.x1.x5.IBN 0.96053f
C790 LELO_GR01_0.x8.x1.x5.IBN LELO_GR01_0.x8.x1.x7.D 0.773f
C791 LELO_GR01_0.x8.x1.x5.IBN LELO_GR01_0.x8.x7.D 0.50701f
C792 LELO_GR01_0.x8.x1.x5.IBN VDPWR 0.20497f
C793 LELO_GR01_0.x8.x1.x5.IBN VGND 4.42608f
C794 a_21554_10625# LELO_GR01_0.x8.x1.x5.IBN 0.01243f
C795 LELO_GR01_0.x8.x1.x5.IBN a_21554_8773# 0.03188f
C796 LELO_GR01_0.x8.x1.x5.IBN a_21554_9573# 0.03042f
C797 LELO_GR01_0.x8.x1.x5.IBN a_21554_9825# 0.03033f
C798 LELO_GR01_0.x8.x1.x5.IBN a_21558_7709# 0.01549f
C799 LELO_GR01_0.x8.x1.x5.IBN a_21558_8509# 0.0318f
C800 LELO_GR01_0.x8.x1.x5.IBN a_23138_7627# 0.04924f
C801 LELO_GR01_0.x8.x1.x5.IBN a_23138_8427# 0.04626f
C802 LELO_GR01_0.x8.x1.x5.IBN a_24508_7627# 0.04366f
C803 LELO_GR01_0.x8.x1.x5.IBN a_24508_8427# 0.04312f
C804 LELO_GR01_0.x8.x1.x5.x6.N LELO_GR01_0.x8.x1.x5.x8.G 2.32381f
C805 LELO_GR01_0.x8.x1.x5.x8.S LELO_GR01_0.x8.x1.x5.x6.N 0.15326f
C806 LELO_GR01_0.x8.x1.x5.x6.N LELO_GR01_0.x8.x1.x5.x9<2>.G 0.836f
C807 LELO_GR01_0.x8.x1.x5.x6.N VDPWR 0.06476f
C808 LELO_GR01_0.x8.x1.x5.x6.N VGND 6.17676f
C809 LELO_GR01_0.x8.x1.x5.x6.N a_19706_9559# 0.03679f
C810 LELO_GR01_0.x8.x1.x5.x6.N a_20156_10709# 0.43217f
C811 LELO_GR01_0.x8.x1.x5.x6.N a_20156_9909# 0.39909f
C812 LELO_GR01_0.x8.x1.x5.x6.N a_20372_11267# 0.03752f
C813 LELO_GR01_0.x8.x1.x5.x6.N a_20372_11699# 0.22481f
C814 LELO_GR01_0.x8.x1.x5.x8.S LELO_GR01_0.x8.x1.x5.x8.G 3.06086f
C815 LELO_GR01_0.x8.x1.x5.x8.G LELO_GR01_0.x8.x1.x5.x9<2>.G 2.14916f
C816 LELO_GR01_0.x8.x1.x5.x8.G VGND 5.04997f
C817 a_18456_10709# LELO_GR01_0.x8.x1.x5.x8.G 0.08382f
C818 LELO_GR01_0.x8.x1.x5.x8.G a_18456_9909# 0.13066f
C819 LELO_GR01_0.x8.x1.x5.x8.G a_18756_7709# 0.01247f
C820 LELO_GR01_0.x8.x1.x5.x8.G a_18756_8509# 0.0438f
C821 LELO_GR01_0.x8.x1.x5.x8.G a_19706_8759# 0.08395f
C822 LELO_GR01_0.x8.x1.x5.x8.G a_19706_9559# 0.11889f
C823 LELO_GR01_0.x8.x1.x5.x8.G a_20156_10709# 0.07053f
C824 LELO_GR01_0.x8.x1.x5.x8.G a_20156_9909# 0.0824f
C825 LELO_GR01_0.x8.x1.x5.x8.S VDPWR 1.35071f
C826 LELO_GR01_0.x8.x1.x5.x8.S VGND 6.16315f
C827 LELO_GR01_0.x8.x1.x5.x8.S a_18456_10709# 0.45344f
C828 LELO_GR01_0.x8.x1.x5.x8.S a_18456_11509# 0.04689f
C829 LELO_GR01_0.x8.x1.x5.x8.S a_18456_12309# 0.03292f
C830 LELO_GR01_0.x8.x1.x5.x8.S a_18456_9909# 0.3991f
C831 LELO_GR01_0.x8.x1.x5.x8.S a_20372_11699# 0.22449f
C832 LELO_GR01_0.x8.x1.x5.x8.S a_20372_12347# 0.01766f
C833 LELO_GR01_0.x8.x1.x5.x8.S uo_out<1> 0.01378f
C834 LELO_GR01_0.x8.x1.x5.x9<2>.G VDPWR 0.02304f
C835 LELO_GR01_0.x8.x1.x5.x9<2>.G VGND 17.5153f
C836 LELO_GR01_0.x8.x1.x5.x9<2>.G a_18756_7709# 0.07336f
C837 LELO_GR01_0.x8.x1.x5.x9<2>.G a_18756_8509# 0.0876f
C838 LELO_GR01_0.x8.x1.x5.x9<2>.G a_19356_6659# 0.0124f
C839 LELO_GR01_0.x8.x1.x5.x9<2>.G a_19356_7459# 0.03436f
C840 LELO_GR01_0.x8.x1.x5.x9<2>.G a_19706_8759# 0.09093f
C841 LELO_GR01_0.x8.x1.x5.x9<2>.G a_19706_9559# 0.0452f
C842 a_20156_10709# LELO_GR01_0.x8.x1.x5.x9<2>.G 0.01325f
C843 LELO_GR01_0.x8.x1.x5.x9<2>.G a_20156_7709# 0.08521f
C844 LELO_GR01_0.x8.x1.x5.x9<2>.G a_20156_8509# 0.12529f
C845 LELO_GR01_0.x8.x1.x5.x9<2>.G a_20156_9909# 0.04123f
C846 LELO_GR01_0.x8.x1.x5.x9<2>.G a_21554_10625# 0.07164f
C847 LELO_GR01_0.x8.x1.x5.x9<2>.G a_21554_8773# 0.07821f
C848 LELO_GR01_0.x8.x1.x5.x9<2>.G a_21554_9573# 0.07745f
C849 LELO_GR01_0.x8.x1.x5.x9<2>.G a_21554_9825# 0.07795f
C850 LELO_GR01_0.x8.x1.x5.x9<2>.G a_21558_7709# 0.07064f
C851 LELO_GR01_0.x8.x1.x5.x9<2>.G a_21558_8509# 0.07542f
C852 LELO_GR01_0.x8.x1.x7.D LELO_GR01_0.x8.x7.D 0.31296f
C853 LELO_GR01_0.x8.x8.D LELO_GR01_0.x8.x1.x7.D 0.01324f
C854 LELO_GR01_0.x8.x1.x7.D VDPWR 7.25163f
C855 LELO_GR01_0.x8.x1.x7.D VGND 1.24868f
C856 LELO_GR01_0.x8.x1.x7.D a_23138_7627# 0.01243f
C857 LELO_GR01_0.x8.x1.x7.D a_23138_8427# 0.03742f
C858 LELO_GR01_0.x8.x1.x7.D a_23138_8685# 0.10753f
C859 LELO_GR01_0.x8.x1.x7.D a_23138_9485# 0.098f
C860 a_23816_10541# LELO_GR01_0.x8.x1.x7.D 0.01242f
C861 LELO_GR01_0.x8.x1.x7.D a_23816_9741# 0.04055f
C862 LELO_GR01_0.x8.x1.x7.D a_24508_8687# 0.07119f
C863 LELO_GR01_0.x8.x1.x7.D a_24508_9487# 0.07449f
C864 LELO_GR01_0.x8.x5.CK LELO_GR01_0.x8.x3.A 0.22809f
C865 LELO_GR01_0.x8.x7.D LELO_GR01_0.x8.x3.A 0.06152f
C866 LELO_GR01_0.x8.x8.D LELO_GR01_0.x8.x3.A 0.01039f
C867 LELO_GR01_0.x8.x3.A VDPWR 0.62871f
C868 LELO_GR01_0.x8.x3.A VGND 1.11864f
C869 LELO_GR01_0.x8.x3.A a_26086_6851# 0.02945f
C870 LELO_GR01_0.x8.x3.A a_26088_7351# 0.09328f
C871 a_26088_7671# LELO_GR01_0.x8.x3.A 0.06171f
C872 LELO_GR01_0.x8.x3.A a_26926_6851# 0.02226f
C873 LELO_GR01_0.x8.x3.A a_26928_7351# 0.06185f
C874 a_26928_7671# LELO_GR01_0.x8.x3.A 0.05912f
C875 LELO_GR01_0.x8.x3.A uo_out<0> 0.01798f
C876 LELO_GR01_0.x8.x5.XA7.C LELO_GR01_0.x8.x5.CK 0.09614f
C877 LELO_GR01_0.x8.x7.D LELO_GR01_0.x8.x5.CK 0.19224f
C878 LELO_GR01_0.x8.x8.D LELO_GR01_0.x8.x5.CK 0.39672f
C879 LELO_GR01_0.x8.x5.CK VDPWR 0.89011f
C880 LELO_GR01_0.x8.x5.CK VGND 5.30256f
C881 LELO_GR01_0.x8.x5.CK a_26086_6531# 0.01504f
C882 LELO_GR01_0.x8.x5.CK a_26086_6851# 0.01343f
C883 LELO_GR01_0.x8.x5.CK a_26088_7351# 0.01111f
C884 LELO_GR01_0.x8.x5.CK a_26088_7671# 0.04129f
C885 LELO_GR01_0.x8.x5.CK a_26090_8213# 0.04105f
C886 LELO_GR01_0.x8.x5.CK a_26090_8533# 0.07991f
C887 LELO_GR01_0.x8.x5.CK a_26146_4651# 0.07043f
C888 LELO_GR01_0.x8.x5.CK a_26146_5451# 0.07681f
C889 LELO_GR01_0.x8.x5.CK a_26928_7671# 0.02203f
C890 LELO_GR01_0.x8.x5.CK a_26930_8533# 0.06181f
C891 LELO_GR01_0.x8.x5.CK ui_in<0> 0.01544f
C892 LELO_GR01_0.x8.x5.CK uo_out<0> 0.09295f
C893 LELO_GR01_0.x8.x5.Q LELO_GR01_0.x8.x5.XA6.A 0.01049f
C894 LELO_GR01_0.x8.x5.Q LELO_GR01_0.x8.x5.XA7.C 0.15827f
C895 LELO_GR01_0.x8.x5.Q LELO_GR01_0.x8.x5.XA7.CN 0.2542f
C896 LELO_GR01_0.x8.x5.Q LELO_GR01_0.x8.x5.XA7.MP1.S 0.08106f
C897 LELO_GR01_0.x8.x8.D LELO_GR01_0.x8.x5.Q 0.83185f
C898 LELO_GR01_0.x8.x5.Q VDPWR 0.26125f
C899 LELO_GR01_0.x8.x5.Q VGND 0.66974f
C900 a_26090_12053# LELO_GR01_0.x8.x5.Q 0.01772f
C901 LELO_GR01_0.x8.x5.Q a_26930_11733# 0.01857f
C902 a_26930_12053# LELO_GR01_0.x8.x5.Q 0.02725f
C903 LELO_GR01_0.x8.x5.Q ui_in<0> 0.01422f
C904 LELO_GR01_0.x8.x5.Q uo_out<0> 0.23496f
C905 LELO_GR01_0.x8.x5.XA7.C LELO_GR01_0.x8.x5.XA1.MN1.S 0.07714f
C906 LELO_GR01_0.x8.x5.XA1.MN1.S VGND 0.09685f
C907 LELO_GR01_0.x8.x5.XA5.A LELO_GR01_0.x8.x5.XA3.MN1.S 0.04373f
C908 LELO_GR01_0.x8.x5.XA7.C LELO_GR01_0.x8.x5.XA3.MN1.S 0.01857f
C909 LELO_GR01_0.x8.x5.XA7.CN LELO_GR01_0.x8.x5.XA3.MN1.S 0.0238f
C910 LELO_GR01_0.x8.x5.XA3.MN1.S VGND 0.09448f
C911 LELO_GR01_0.x8.x5.XA3.MN1.S uo_out<0> 0.0152f
C912 LELO_GR01_0.x8.x5.XA5.A LELO_GR01_0.x8.x5.XA3.MP1.S 0.04373f
C913 LELO_GR01_0.x8.x5.XA7.CN LELO_GR01_0.x8.x5.XA3.MP1.S 0.03112f
C914 LELO_GR01_0.x8.x8.D LELO_GR01_0.x8.x5.XA3.MP1.S 0.07376f
C915 LELO_GR01_0.x8.x5.XA3.MP1.S uo_out<0> 0.05614f
C916 LELO_GR01_0.x8.x5.XA5.A LELO_GR01_0.x8.x5.XA4.MN1.S 0.07879f
C917 LELO_GR01_0.x8.x5.XA7.CN LELO_GR01_0.x8.x5.XA4.MN1.S 0.03049f
C918 LELO_GR01_0.x8.x5.XA4.MN1.S VGND 0.08682f
C919 LELO_GR01_0.x8.x5.XA4.MN1.S uo_out<0> 0.0116f
C920 LELO_GR01_0.x8.x5.XA5.A LELO_GR01_0.x8.x5.XA4.MP1.S 0.05173f
C921 LELO_GR01_0.x8.x5.XA6.A LELO_GR01_0.x8.x5.XA4.MP1.S 0.01889f
C922 LELO_GR01_0.x8.x5.XA7.CN LELO_GR01_0.x8.x5.XA4.MP1.S 0.02318f
C923 LELO_GR01_0.x8.x8.D LELO_GR01_0.x8.x5.XA4.MP1.S 0.09448f
C924 LELO_GR01_0.x8.x5.XA6.A LELO_GR01_0.x8.x5.XA5.A 0.21316f
C925 LELO_GR01_0.x8.x5.XA7.C LELO_GR01_0.x8.x5.XA5.A 0.09018f
C926 LELO_GR01_0.x8.x5.XA7.CN LELO_GR01_0.x8.x5.XA5.A 0.38708f
C927 LELO_GR01_0.x8.x8.D LELO_GR01_0.x8.x5.XA5.A 0.65561f
C928 LELO_GR01_0.x8.x5.XA5.A VDPWR 0.07548f
C929 LELO_GR01_0.x8.x5.XA5.A VGND 0.98063f
C930 LELO_GR01_0.x8.x5.XA5.A a_26090_10293# 0.09561f
C931 a_26090_10613# LELO_GR01_0.x8.x5.XA5.A 0.06582f
C932 LELO_GR01_0.x8.x5.XA5.A a_26090_9813# 0.02736f
C933 LELO_GR01_0.x8.x5.XA5.A a_26930_10293# 0.07901f
C934 a_26930_10613# LELO_GR01_0.x8.x5.XA5.A 0.05912f
C935 LELO_GR01_0.x8.x5.XA5.A a_26930_9813# 0.02049f
C936 LELO_GR01_0.x8.x5.XA5.A uo_out<0> 0.30418f
C937 LELO_GR01_0.x8.x5.XA7.C LELO_GR01_0.x8.x5.XA6.A 0.58167f
C938 LELO_GR01_0.x8.x5.XA7.CN LELO_GR01_0.x8.x5.XA6.A 0.65975f
C939 LELO_GR01_0.x8.x8.D LELO_GR01_0.x8.x5.XA6.A 1.28877f
C940 LELO_GR01_0.x8.x5.XA6.A VDPWR 0.04131f
C941 LELO_GR01_0.x8.x5.XA6.A VGND 0.95452f
C942 LELO_GR01_0.x8.x5.XA6.A a_26090_10613# 0.07684f
C943 LELO_GR01_0.x8.x5.XA6.A a_26090_9813# 0.05912f
C944 LELO_GR01_0.x8.x5.XA6.A a_26930_10293# 0.01281f
C945 LELO_GR01_0.x8.x5.XA6.A a_26930_10613# 0.09795f
C946 LELO_GR01_0.x8.x5.XA6.A a_26930_9813# 0.06533f
C947 LELO_GR01_0.x8.x5.XA6.A ui_in<0> 0.01827f
C948 LELO_GR01_0.x8.x5.XA6.A uo_out<0> 0.24977f
C949 LELO_GR01_0.x8.x5.XA7.C LELO_GR01_0.x8.x5.XA6.MN1.S 0.01224f
C950 LELO_GR01_0.x8.x5.XA7.CN LELO_GR01_0.x8.x5.XA6.MN1.S 0.03056f
C951 LELO_GR01_0.x8.x5.XA6.MN1.S VGND 0.08222f
C952 LELO_GR01_0.x8.x5.XA6.MN1.S uo_out<0> 0.0697f
C953 LELO_GR01_0.x8.x5.XA7.C LELO_GR01_0.x8.x5.XA6.MP1.S 0.02158f
C954 LELO_GR01_0.x8.x5.XA7.CN LELO_GR01_0.x8.x5.XA6.MP1.S 0.02377f
C955 LELO_GR01_0.x8.x8.D LELO_GR01_0.x8.x5.XA6.MP1.S 0.08476f
C956 LELO_GR01_0.x8.x5.XA6.MP1.S uo_out<0> 0.04841f
C957 LELO_GR01_0.x8.x5.XA7.C LELO_GR01_0.x8.x5.XA7.CN 0.48001f
C958 LELO_GR01_0.x8.x5.XA7.C LELO_GR01_0.x8.x5.XA7.MP1.S 0.04215f
C959 LELO_GR01_0.x8.x8.D LELO_GR01_0.x8.x5.XA7.C 2.76753f
C960 LELO_GR01_0.x8.x5.XA7.C VDPWR 0.48819f
C961 LELO_GR01_0.x8.x5.XA7.C VGND 2.58683f
C962 LELO_GR01_0.x8.x5.XA7.C a_26090_11093# 0.01225f
C963 a_26090_11733# LELO_GR01_0.x8.x5.XA7.C 0.06698f
C964 LELO_GR01_0.x8.x5.XA7.C a_26090_9013# 0.09819f
C965 LELO_GR01_0.x8.x5.XA7.C a_26090_9333# 0.07292f
C966 LELO_GR01_0.x8.x5.XA7.C a_26090_9813# 0.06535f
C967 LELO_GR01_0.x8.x5.XA7.C a_26930_10293# 0.067f
C968 LELO_GR01_0.x8.x5.XA7.C a_26930_11093# 0.06949f
C969 LELO_GR01_0.x8.x5.XA7.C a_26930_9013# 0.1046f
C970 LELO_GR01_0.x8.x5.XA7.C a_26930_9333# 0.06658f
C971 LELO_GR01_0.x8.x5.XA7.C ui_in<0> 0.06899f
C972 LELO_GR01_0.x8.x5.XA7.C uo_out<0> 0.68391f
C973 LELO_GR01_0.x8.x5.XA7.CN LELO_GR01_0.x8.x5.XA7.MP1.S 0.07161f
C974 LELO_GR01_0.x8.x8.D LELO_GR01_0.x8.x5.XA7.CN 1.51068f
C975 LELO_GR01_0.x8.x5.XA7.CN VDPWR 0.11174f
C976 LELO_GR01_0.x8.x5.XA7.CN VGND 1.44475f
C977 LELO_GR01_0.x8.x5.XA7.CN a_26090_10293# 0.08881f
C978 LELO_GR01_0.x8.x5.XA7.CN a_26090_10613# 0.02661f
C979 LELO_GR01_0.x8.x5.XA7.CN a_26090_11093# 0.06325f
C980 LELO_GR01_0.x8.x5.XA7.CN a_26090_9333# 0.04737f
C981 LELO_GR01_0.x8.x5.XA7.CN a_26090_9813# 0.02602f
C982 LELO_GR01_0.x8.x5.XA7.CN a_26930_10293# 0.02605f
C983 LELO_GR01_0.x8.x5.XA7.CN a_26930_10613# 0.026f
C984 LELO_GR01_0.x8.x5.XA7.CN a_26930_11093# 0.02572f
C985 a_26930_11733# LELO_GR01_0.x8.x5.XA7.CN 0.06207f
C986 LELO_GR01_0.x8.x5.XA7.CN a_26930_9333# 0.04767f
C987 LELO_GR01_0.x8.x5.XA7.CN a_26930_9813# 0.08626f
C988 LELO_GR01_0.x8.x5.XA7.CN ui_in<0> 0.022f
C989 LELO_GR01_0.x8.x5.XA7.CN uo_out<0> 0.4552f
C990 LELO_GR01_0.x8.x5.XA7.MP1.S LELO_GR01_0.x8.x5.XA7.MN0.S 0.05173f
C991 LELO_GR01_0.x8.x5.XA7.MN0.S VGND 0.0979f
C992 LELO_GR01_0.x8.x5.XA7.MN0.S uo_out<0> 0.01897f
C993 LELO_GR01_0.x8.x8.D LELO_GR01_0.x8.x5.XA7.MP1.S 0.28786f
C994 LELO_GR01_0.x8.x5.XA7.MP1.S VDPWR 0.04378f
C995 LELO_GR01_0.x8.x5.XA7.MP1.S VGND 0.12129f
C996 LELO_GR01_0.x8.x5.XA7.MP1.S a_26930_11093# 0.0183f
C997 LELO_GR01_0.x8.x5.XA7.MP1.S uo_out<0> 0.33803f
C998 LELO_GR01_0.x8.x7.D VDPWR 1.28065f
C999 LELO_GR01_0.x8.x7.D VGND 2.14417f
C1000 LELO_GR01_0.x8.x7.D a_24508_7627# 0.03796f
C1001 LELO_GR01_0.x8.x7.D a_24508_8427# 0.03513f
C1002 LELO_GR01_0.x8.x7.D a_24508_8687# 0.0355f
C1003 a_24508_9487# LELO_GR01_0.x8.x7.D 0.01243f
C1004 LELO_GR01_0.x8.x7.D a_24510_6435# 0.01356f
C1005 LELO_GR01_0.x8.x7.D a_24510_7235# 0.03877f
C1006 LELO_GR01_0.x8.x7.D a_26086_6531# 0.05922f
C1007 LELO_GR01_0.x8.x7.D a_26086_6851# 0.0629f
C1008 LELO_GR01_0.x8.x7.D a_26926_6531# 0.06129f
C1009 LELO_GR01_0.x8.x7.D a_26926_6851# 0.05912f
C1010 LELO_GR01_0.x8.x7.D uo_out<0> 0.04656f
C1011 LELO_GR01_0.x8.x8.D VDPWR 1.63375f
C1012 LELO_GR01_0.x8.x8.D VGND 16.8495f
C1013 LELO_GR01_0.x8.x8.D a_23824_11183# 0.01319f
C1014 LELO_GR01_0.x8.x8.D a_23824_11983# 0.0403f
C1015 LELO_GR01_0.x8.x8.D a_26090_12053# 0.01564f
C1016 LELO_GR01_0.x8.x8.D a_26930_10293# 0.31059f
C1017 LELO_GR01_0.x8.x8.D a_26930_10613# 0.31063f
C1018 LELO_GR01_0.x8.x8.D a_26930_11093# 0.30152f
C1019 LELO_GR01_0.x8.x8.D a_26930_11733# 0.31369f
C1020 LELO_GR01_0.x8.x8.D a_26930_12053# 0.27617f
C1021 LELO_GR01_0.x8.x8.D a_26930_8213# 0.35757f
C1022 LELO_GR01_0.x8.x8.D a_26930_8533# 0.40085f
C1023 LELO_GR01_0.x8.x8.D a_26930_9013# 0.32808f
C1024 LELO_GR01_0.x8.x8.D a_26930_9333# 0.31293f
C1025 LELO_GR01_0.x8.x8.D a_26930_9813# 0.31342f
C1026 LELO_GR01_0.x8.x8.D ui_in<0> 0.42589f
C1027 LELO_GR01_0.x8.x8.D uo_out<0> 1.7882f
C1028 VDPWR VGND 0.40874p
C1029 a_10137_4838# VDPWR 0.45623f
C1030 a_10140_2778# VDPWR 0.08228f
C1031 a_10412_8824# VDPWR 0.2945f
C1032 a_10420_1298# VDPWR 0.217f
C1033 a_10420_1842# VDPWR 0.21541f
C1034 a_10472_19784# VDPWR 0.04403f
C1035 a_10472_20216# VDPWR 0.0182f
C1036 a_10546_1482# VDPWR 0.22792f
C1037 a_10546_2106# VDPWR 0.22691f
C1038 a_10657_4562# VDPWR 0.42402f
C1039 a_10786_1298# VDPWR 0.33128f
C1040 a_10786_1842# VDPWR 0.3265f
C1041 a_10841_2386# VDPWR 0.38779f
C1042 a_10861_3474# VDPWR 0.42827f
C1043 a_10944_4840# VDPWR 0.2857f
C1044 a_11060_6904# VDPWR 0.09092f
C1045 a_11128_2664# VDPWR 0.27595f
C1046 a_11149_1874# VDPWR 0.48002f
C1047 a_11149_2956# VDPWR 0.38727f
C1048 a_11209_4018# VDPWR 0.41153f
C1049 a_11222_4856# VDPWR 0.24635f
C1050 a_11234_3276# VDPWR 0.21819f
C1051 a_11257_5926# VDPWR 0.37235f
C1052 a_11261_4730# VDPWR 0.45439f
C1053 a_11315_1874# VDPWR 0.58333f
C1054 a_11318_15928# VDPWR 0.02717f
C1055 a_11318_16728# VDPWR 0.04219f
C1056 a_11318_16986# VDPWR 0.40021f
C1057 a_11318_17786# VDPWR 0.49163f
C1058 a_11348_4954# VDPWR 0.20382f
C1059 a_11406_2680# VDPWR 0.26036f
C1060 a_11416_3500# VDPWR 1.28058f
C1061 a_11417_4825# VDPWR 0.19433f
C1062 a_11433_5132# VDPWR 0.43345f
C1063 a_11445_2554# VDPWR 0.40893f
C1064 a_11467_1651# VDPWR 0.20871f
C1065 a_11496_4176# VDPWR 0.29532f
C1066 a_11532_2778# VDPWR 0.20146f
C1067 a_11562_4954# VDPWR 0.13232f
C1068 a_11570_2234# VDPWR 0.08228f
C1069 a_11592_2956# VDPWR 0.47539f
C1070 a_11601_2649# VDPWR 0.19272f
C1071 a_11665_2246# VDPWR 0.20209f
C1072 a_11721_1651# VDPWR 0.08888f
C1073 a_11746_2778# VDPWR 0.13232f
C1074 a_11773_1868# VDPWR 0.1421f
C1075 a_11774_4160# VDPWR 0.52166f
C1076 a_11793_5926# VDPWR 0.3936f
C1077 a_11813_4286# VDPWR 0.48836f
C1078 a_11883_1842# VDPWR 0.20734f
C1079 a_11900_4044# VDPWR 0.20815f
C1080 a_11969_4018# VDPWR 0.20052f
C1081 a_11980_4954# VDPWR 0.07761f
C1082 a_11988_14620# VDPWR 0.39903f
C1083 a_11988_15420# VDPWR 0.43667f
C1084 a_11996_18042# VDPWR 0.51334f
C1085 a_11996_18842# VDPWR 0.47143f
C1086 a_12069_5132# VDPWR 0.34656f
C1087 a_12114_4044# VDPWR 0.1421f
C1088 a_12154_5452# VDPWR 0.20377f
C1089 a_12164_2778# VDPWR 0.07761f
C1090 a_12230_2246# VDPWR 0.29839f
C1091 a_12323_1476# VDPWR 0.18262f
C1092 a_12367_2956# VDPWR 0.27148f
C1093 a_12405_2172# VDPWR 0.43107f
C1094 a_12419_1298# VDPWR 0.283f
C1095 a_12512_5132# VDPWR 0.50191f
C1096 a_12532_4044# VDPWR 0.08451f
C1097 a_12603_2956# VDPWR 0.29891f
C1098 a_12677_1298# VDPWR 0.33039f
C1099 a_12688_15928# VDPWR 0.03231f
C1100 a_12688_16728# VDPWR 0.04865f
C1101 a_12688_16988# VDPWR 0.40785f
C1102 a_12688_17788# VDPWR 0.48955f
C1103 a_12688_20180# VDPWR 0.42653f
C1104 a_12688_20980# VDPWR 0.39884f
C1105 a_12709_2956# VDPWR 0.20776f
C1106 a_12847_4915# VDPWR 0.23811f
C1107 a_12919_2412# VDPWR 0.34653f
C1108 a_13042_1476# VDPWR 0.2532f
C1109 a_13101_4915# VDPWR 0.11162f
C1110 a_13132_4276# VDPWR 0.29874f
C1111 a_13141_2930# VDPWR 0.41886f
C1112 a_13155_2412# VDPWR 0.31496f
C1113 a_13189_3750# VDPWR 0.4498f
C1114 a_13261_2412# VDPWR 0.1941f
C1115 a_13348_1574# VDPWR 0.22024f
C1116 a_13428_3088# VDPWR 0.28058f
C1117 a_13541_1874# VDPWR 0.45473f
C1118 a_13693_4018# VDPWR 0.40009f
C1119 a_13706_3072# VDPWR 0.25971f
C1120 a_13707_1874# VDPWR 0.57918f
C1121 a_13725_1324# VDPWR 0.32557f
C1122 a_13725_2412# VDPWR 0.58144f
C1123 a_13725_4588# VDPWR 0.46812f
C1124 a_13745_3198# VDPWR 0.45004f
C1125 a_13795_5828# VDPWR 0.18692f
C1126 a_13832_2956# VDPWR 0.20443f
C1127 a_13891_2412# VDPWR 0.2806f
C1128 a_13891_4588# VDPWR 0.57564f
C1129 a_13891_5650# VDPWR 0.29153f
C1130 a_13901_2930# VDPWR 0.19823f
C1131 a_13942_1324# VDPWR 0.2188f
C1132 a_13951_3827# VDPWR 0.18799f
C1133 a_13962_2234# VDPWR 0.08367f
C1134 a_13969_5106# VDPWR 0.41391f
C1135 a_13980_4176# VDPWR 0.27771f
C1136 a_14046_2956# VDPWR 0.13297f
C1137 a_14053_1324# VDPWR 0.20741f
C1138 a_14057_2246# VDPWR 0.20598f
C1139 a_14079_2412# VDPWR 0.10126f
C1140 a_14146_4588# VDPWR 0.08358f
C1141 a_14149_5650# VDPWR 0.27785f
C1142 a_14165_1868# VDPWR 0.14291f
C1143 a_14174_2412# VDPWR 0.26757f
C1144 a_14205_3827# VDPWR 0.10796f
C1145 a_14241_4588# VDPWR 0.20402f
C1146 a_14256_5264# VDPWR 0.29919f
C1147 a_14258_4160# VDPWR 0.25476f
C1148 a_14275_1842# VDPWR 0.20676f
C1149 a_14297_4286# VDPWR 0.42532f
C1150 a_14349_4954# VDPWR 0.14275f
C1151 a_14350_2386# VDPWR 0.24636f
C1152 a_14358_11800# VDPWR 0.40066f
C1153 a_14358_12600# VDPWR 0.41173f
C1154 a_14358_12740# VDPWR 0.41176f
C1155 a_14358_13540# VDPWR 0.41176f
C1156 a_14358_13680# VDPWR 0.41176f
C1157 a_14358_14480# VDPWR 0.41154f
C1158 a_14358_14620# VDPWR 0.4112f
C1159 a_14358_15420# VDPWR 0.43103f
C1160 a_14358_15930# VDPWR 0.43333f
C1161 a_14358_16730# VDPWR 0.41173f
C1162 a_14358_16870# VDPWR 0.41237f
C1163 a_14358_17670# VDPWR 0.4124f
C1164 a_14358_17810# VDPWR 0.4122f
C1165 a_14358_18610# VDPWR 0.4118f
C1166 a_14358_18750# VDPWR 0.41178f
C1167 a_14358_19550# VDPWR 0.41661f
C1168 a_14384_4044# VDPWR 0.20526f
C1169 a_14453_4018# VDPWR 0.19496f
C1170 a_14459_4830# VDPWR 0.20536f
C1171 a_14464_2956# VDPWR 0.07825f
C1172 a_14531_1476# VDPWR 0.18878f
C1173 a_14534_5248# VDPWR 0.58234f
C1174 a_14553_5676# VDPWR 0.25542f
C1175 a_14573_5374# VDPWR 0.45672f
C1176 a_14598_4044# VDPWR 0.13253f
C1177 a_14622_2246# VDPWR 0.29105f
C1178 a_14627_1298# VDPWR 0.29259f
C1179 a_14660_5132# VDPWR 0.20609f
C1180 a_14726_2778# VDPWR 0.40529f
C1181 a_14729_5106# VDPWR 0.20325f
C1182 a_14759_3500# VDPWR 0.27054f
C1183 a_14770_5676# VDPWR 0.22681f
C1184 a_14797_2172# VDPWR 0.40313f
C1185 a_14806_4588# VDPWR 0.29385f
C1186 a_14874_5132# VDPWR 0.1421f
C1187 a_14876_2626# VDPWR 0.24189f
C1188 a_14881_5676# VDPWR 0.21564f
C1189 a_14885_1298# VDPWR 0.28366f
C1190 a_14981_4562# VDPWR 0.40876f
C1191 a_14995_3500# VDPWR 0.2819f
C1192 a_15016_4044# VDPWR 0.07761f
C1193 a_15101_3500# VDPWR 0.18045f
C1194 a_15289_1324# VDPWR 0.26991f
C1195 a_15289_2956# VDPWR 0.32262f
C1196 a_15289_5676# VDPWR 0.2492f
C1197 a_15292_5132# VDPWR 0.08228f
C1198 a_15300_2412# VDPWR 0.26364f
C1199 a_15506_1324# VDPWR 0.24122f
C1200 a_15506_2956# VDPWR 0.23552f
C1201 a_15506_5676# VDPWR 0.23073f
C1202 a_15507_3528# VDPWR 0.26774f
C1203 a_15617_1324# VDPWR 0.23185f
C1204 a_15617_2956# VDPWR 0.227f
C1205 a_15617_5676# VDPWR 0.23336f
C1206 a_15998_13144# VDPWR 0.04827f
C1207 a_16008_16644# VDPWR 0.06123f
C1208 a_16018_19950# VDPWR 0.40582f
C1209 a_16018_20750# VDPWR 0.43757f
C1210 a_16214_13144# VDPWR 0.01021f
C1211 a_16224_16644# VDPWR 0.01295f
C1212 a_16440_18564# VDPWR 0.01613f
C1213 a_16646_13144# VDPWR 0.027f
C1214 a_16656_16644# VDPWR 0.03049f
C1215 a_16872_18564# VDPWR 0.02444f
C1216 a_17088_16644# VDPWR 0.07122f
C1217 a_17304_18564# VDPWR 0.01882f
C1218 a_17508_13144# VDPWR 0.03814f
C1219 a_17520_16644# VDPWR 0.02723f
C1220 a_17668_19950# VDPWR 0.40365f
C1221 a_17668_20750# VDPWR 0.4254f
C1222 a_17724_13144# VDPWR 0.02531f
C1223 a_17952_16644# VDPWR 0.01154f
C1224 a_18156_13144# VDPWR 0.01799f
C1225 a_18456_11509# VDPWR 0.40138f
C1226 a_18456_12309# VDPWR 0.42759f
C1227 a_20372_11267# VDPWR 0.17609f
C1228 a_20372_11699# VDPWR 0.1669f
C1229 a_20372_12347# VDPWR 0.01519f
C1230 a_20412_20698# VDPWR 0.01383f
C1231 a_21252_20378# VDPWR 0.28542f
C1232 a_21252_20698# VDPWR 0.28596f
C1233 a_21554_10625# VDPWR 0.01321f
C1234 a_22292_11483# VDPWR 0.02191f
C1235 a_23138_8427# VDPWR 0.042f
C1236 a_23138_8685# VDPWR 0.40004f
C1237 a_23138_9485# VDPWR 0.49026f
C1238 a_23816_10541# VDPWR 0.46055f
C1239 a_23816_9741# VDPWR 0.51143f
C1240 a_23824_11183# VDPWR 0.43853f
C1241 a_23824_11983# VDPWR 0.41304f
C1242 a_24508_8427# VDPWR 0.04298f
C1243 a_24508_8687# VDPWR 0.40196f
C1244 a_24508_9487# VDPWR 0.49095f
C1245 a_2478_10440# VDPWR 0.35724f
C1246 a_2478_11240# VDPWR 0.36405f
C1247 a_2478_11750# VDPWR 0.36417f
C1248 a_2478_12550# VDPWR 0.36428f
C1249 a_2478_13060# VDPWR 0.36439f
C1250 a_2478_13860# VDPWR 0.36405f
C1251 a_2478_14370# VDPWR 0.36417f
C1252 a_2478_15170# VDPWR 0.36405f
C1253 a_2478_15680# VDPWR 0.36417f
C1254 a_2478_16480# VDPWR 0.36405f
C1255 a_2478_16990# VDPWR 0.36417f
C1256 a_2478_17790# VDPWR 0.36405f
C1257 a_2478_18300# VDPWR 0.36417f
C1258 a_2478_19100# VDPWR 0.36405f
C1259 a_2478_19610# VDPWR 0.36455f
C1260 a_2478_20410# VDPWR 0.3754f
C1261 a_26088_7671# VDPWR 0.01369f
C1262 a_26090_11093# VDPWR 0.06709f
C1263 a_26090_8213# VDPWR 0.01106f
C1264 a_26090_9013# VDPWR 0.06915f
C1265 a_26926_6531# VDPWR 0.2841f
C1266 a_26926_6851# VDPWR 0.29521f
C1267 a_26928_7351# VDPWR 0.30455f
C1268 a_26928_7671# VDPWR 0.27923f
C1269 a_26930_11093# VDPWR 0.06129f
C1270 a_26930_8213# VDPWR 0.01174f
C1271 a_26930_9013# VDPWR 0.05926f
C1272 a_29432_20186# VDPWR 0.29178f
C1273 a_29432_20666# VDPWR 0.31208f
C1274 a_29432_20986# VDPWR 0.31082f
C1275 a_29432_21305# VDPWR 0.38497f
C1276 a_29432_21624# VDPWR 0.40182f
C1277 a_29432_21944# VDPWR 0.267f
C1278 a_3290_8824# VDPWR 0.01927f
C1279 a_3336_4018# VDPWR 0.23952f
C1280 a_3389_2930# VDPWR 0.42086f
C1281 a_3437_1574# VDPWR 0.38628f
C1282 a_3437_1868# VDPWR 0.42922f
C1283 a_3443_2412# VDPWR 0.32215f
C1284 a_3462_4282# VDPWR 0.23965f
C1285 a_3513_3500# VDPWR 0.29749f
C1286 a_3676_3088# VDPWR 0.29593f
C1287 a_3679_2412# VDPWR 0.28046f
C1288 a_3702_4018# VDPWR 0.33935f
C1289 a_3722_8824# VDPWR 0.10318f
C1290 a_3730_3500# VDPWR 0.23792f
C1291 a_3785_2412# VDPWR 0.16983f
C1292 a_3841_3500# VDPWR 0.22546f
C1293 a_3903_1324# VDPWR 0.27651f
C1294 a_3941_1842# VDPWR 0.41248f
C1295 a_3954_3072# VDPWR 0.58389f
C1296 a_3993_3198# VDPWR 0.43679f
C1297 a_4033_5106# VDPWR 0.42604f
C1298 a_4080_2956# VDPWR 0.20964f
C1299 a_4139_1324# VDPWR 0.2813f
C1300 a_4149_2930# VDPWR 0.20643f
C1301 a_4154_8824# VDPWR 0.12007f
C1302 a_4157_2412# VDPWR 0.23301f
C1303 a_4228_2000# VDPWR 0.29787f
C1304 a_4245_1324# VDPWR 0.17823f
C1305 a_4294_2956# VDPWR 0.14211f
C1306 a_4320_5264# VDPWR 0.28596f
C1307 a_4341_4052# VDPWR 0.30356f
C1308 a_4374_2412# VDPWR 0.2188f
C1309 a_4383_3827# VDPWR 0.15118f
C1310 a_4455_5676# VDPWR 0.30936f
C1311 a_4485_2412# VDPWR 0.21647f
C1312 a_4506_1984# VDPWR 0.34252f
C1313 a_4545_2110# VDPWR 0.43113f
C1314 a_4578_12200# VDPWR 0.01413f
C1315 a_4578_12610# VDPWR 0.3588f
C1316 a_4578_13410# VDPWR 0.35714f
C1317 a_4578_13670# VDPWR 0.03731f
C1318 a_4578_20940# VDPWR 0.02654f
C1319 a_4586_8824# VDPWR 0.03764f
C1320 a_4598_5248# VDPWR 0.25953f
C1321 a_4632_1868# VDPWR 0.20793f
C1322 a_4637_3827# VDPWR 0.0946f
C1323 a_4637_5374# VDPWR 0.46017f
C1324 a_4691_5676# VDPWR 0.27694f
C1325 a_4701_1842# VDPWR 0.19918f
C1326 a_4712_2956# VDPWR 0.08228f
C1327 a_4724_5132# VDPWR 0.19913f
C1328 a_4793_5106# VDPWR 0.18853f
C1329 a_4797_5676# VDPWR 0.17734f
C1330 a_4846_1868# VDPWR 0.13243f
C1331 a_4935_1651# VDPWR 0.21324f
C1332 a_4938_5132# VDPWR 0.13238f
C1333 a_5018_8824# VDPWR 0.0249f
C1334 a_5169_5676# VDPWR 0.24846f
C1335 a_5189_1651# VDPWR 0.10416f
C1336 a_5264_1868# VDPWR 0.07761f
C1337 a_5321_2386# VDPWR 0.4013f
C1338 a_5321_3474# VDPWR 0.41168f
C1339 a_5356_5132# VDPWR 0.07761f
C1340 a_5386_5676# VDPWR 0.23391f
C1341 a_5450_8824# VDPWR 0.02146f
C1342 a_5461_2956# VDPWR 0.42586f
C1343 a_5497_5676# VDPWR 0.22323f
C1344 a_5608_2664# VDPWR 0.27598f
C1345 a_5608_3752# VDPWR 0.29625f
C1346 a_5873_4562# VDPWR 0.42159f
C1347 a_5882_8824# VDPWR 0.01812f
C1348 a_5886_2680# VDPWR 0.25662f
C1349 a_5886_3768# VDPWR 0.31161f
C1350 a_5925_2554# VDPWR 0.44148f
C1351 a_5925_3642# VDPWR 0.39729f
C1352 a_5997_4044# VDPWR 0.417f
C1353 a_6012_2778# VDPWR 0.20321f
C1354 a_6012_3866# VDPWR 0.20948f
C1355 a_6046_5364# VDPWR 0.09181f
C1356 a_6075_1842# VDPWR 0.23899f
C1357 a_6081_2649# VDPWR 0.18806f
C1358 a_6081_3737# VDPWR 0.20214f
C1359 a_6160_4840# VDPWR 0.29509f
C1360 a_6226_2778# VDPWR 0.13232f
C1361 a_6226_3866# VDPWR 0.13232f
C1362 a_6280_5650# VDPWR 0.22119f
C1363 a_6343_2930# VDPWR 1.27833f
C1364 a_6372_1298# VDPWR 0.21266f
C1365 a_6406_5834# VDPWR 0.22877f
C1366 a_6438_4856# VDPWR 0.5764f
C1367 a_6457_4044# VDPWR 0.3842f
C1368 a_6475_5430# VDPWR 0.1733f
C1369 a_6477_4730# VDPWR 0.44161f
C1370 a_6498_1482# VDPWR 0.22031f
C1371 a_6530_6904# VDPWR 0.0484f
C1372 a_6564_4954# VDPWR 0.2112f
C1373 a_6575_1868# VDPWR 0.46737f
C1374 a_6631_1842# VDPWR 0.20711f
C1375 a_6633_4825# VDPWR 0.20115f
C1376 a_6636_19810# VDPWR 0.40448f
C1377 a_6636_20610# VDPWR 0.4456f
C1378 a_6644_2778# VDPWR 0.07761f
C1379 a_6644_3866# VDPWR 0.07761f
C1380 a_6646_5650# VDPWR 0.24663f
C1381 a_6738_1298# VDPWR 0.23642f
C1382 a_6778_4954# VDPWR 0.1421f
C1383 a_6939_5676# VDPWR 0.26218f
C1384 a_6968_4276# VDPWR 0.28867f
C1385 a_7009_1324# VDPWR 0.23442f
C1386 a_7025_5132# VDPWR 0.41107f
C1387 a_7175_5676# VDPWR 0.27111f
C1388 a_7196_4954# VDPWR 0.08228f
C1389 a_7226_1324# VDPWR 0.21806f
C1390 a_7253_2386# VDPWR 0.37178f
C1391 a_7281_5676# VDPWR 0.17906f
C1392 a_7302_1868# VDPWR 0.37311f
C1393 a_7337_1324# VDPWR 0.20997f
C1394 a_7385_3750# VDPWR 0.38737f
C1395 a_7388_6904# VDPWR 0.04816f
C1396 a_7529_5106# VDPWR 0.40317f
C1397 a_7547_4018# VDPWR 0.24311f
C1398 a_7695_6003# VDPWR 0.15332f
C1399 a_7745_2412# VDPWR 0.44736f
C1400 a_7767_1324# VDPWR 0.26066f
C1401 a_7816_5264# VDPWR 0.29658f
C1402 a_7820_8824# VDPWR 0.01812f
C1403 a_7871_4616# VDPWR 0.24291f
C1404 a_7949_6003# VDPWR 0.10339f
C1405 a_8003_1324# VDPWR 0.26761f
C1406 a_8081_1842# VDPWR 0.40273f
C1407 a_8081_4018# VDPWR 0.40883f
C1408 a_8094_5248# VDPWR 0.57669f
C1409 a_8109_1324# VDPWR 0.16801f
C1410 a_8133_5374# VDPWR 0.50185f
C1411 a_8220_5132# VDPWR 0.21232f
C1412 a_8252_8824# VDPWR 0.01812f
C1413 a_8289_5106# VDPWR 0.20685f
C1414 a_8368_2000# VDPWR 0.29483f
C1415 a_8368_4176# VDPWR 0.29118f
C1416 a_8389_2956# VDPWR 0.2998f
C1417 a_8389_3276# VDPWR 0.27515f
C1418 a_8434_5132# VDPWR 0.1421f
C1419 a_8552_19568# VDPWR 0.22552f
C1420 a_8552_20000# VDPWR 0.19563f
C1421 a_8552_20648# VDPWR 0.05463f
C1422 a_8615_1651# VDPWR 0.22031f
C1423 a_8646_1984# VDPWR 0.57626f
C1424 a_8646_4160# VDPWR 0.57633f
C1425 a_8684_8824# VDPWR 0.01812f
C1426 a_8685_2110# VDPWR 0.45014f
C1427 a_8685_4286# VDPWR 0.46517f
C1428 a_8735_3474# VDPWR 1.24988f
C1429 a_8739_4910# VDPWR 0.32107f
C1430 a_8772_1868# VDPWR 0.20834f
C1431 a_8772_4044# VDPWR 0.21059f
C1432 a_8793_4562# VDPWR 0.13077f
C1433 a_8817_2386# VDPWR 0.40697f
C1434 a_8841_1842# VDPWR 0.20009f
C1435 a_8841_4018# VDPWR 0.20225f
C1436 a_8852_5132# VDPWR 0.08323f
C1437 a_8869_1651# VDPWR 0.11267f
C1438 a_8986_1868# VDPWR 0.1421f
C1439 a_8986_4044# VDPWR 0.1421f
C1440 a_9104_2664# VDPWR 0.29383f
C1441 a_9116_8824# VDPWR 0.01994f
C1442 a_9217_2956# VDPWR 0.33032f
C1443 a_9382_2680# VDPWR 0.56588f
C1444 a_9404_1868# VDPWR 0.08243f
C1445 a_9404_4044# VDPWR 0.0823f
C1446 a_9417_4838# VDPWR 0.46465f
C1447 a_9421_2554# VDPWR 0.45089f
C1448 a_9434_2956# VDPWR 0.23902f
C1449 a_9508_2778# VDPWR 0.209f
C1450 a_9545_2956# VDPWR 0.22079f
C1451 a_9548_8824# VDPWR 0.02394f
C1452 a_9577_2649# VDPWR 0.20346f
C1453 a_9677_1690# VDPWR 0.23393f
C1454 a_9722_2778# VDPWR 0.1421f
C1455 a_9734_18926# VDPWR 0.04466f
C1456 a_9862_1690# VDPWR 0.20143f
C1457 a_9969_2956# VDPWR 0.37714f
C1458 a_9980_8824# VDPWR 0.0324f
C1459 VDPWR clk 2.0805f
C1460 digital_0._057_.D VDPWR 0.29803f
C1461 digital_0._060_.A_N VDPWR 1.0819f
C1462 digital_0._060_.B VDPWR 0.88779f
C1463 digital_0._063_.A VDPWR 0.85199f
C1464 digital_0._063_.B VDPWR 0.10474f
C1465 digital_0._065_.A2_N VDPWR 0.93791f
C1466 digital_0._067_.A VDPWR 0.99397f
C1467 digital_0._067_.B VDPWR 0.2714f
C1468 digital_0._069_.A VDPWR 3.674f
C1469 digital_0._069_.B VDPWR 0.12246f
C1470 digital_0._080_.A2 VDPWR 1.31468f
C1471 digital_0._100_.D VDPWR 0.47094f
C1472 digital_0._100_.RESET_B VDPWR 0.64478f
C1473 digital_0._101_.D VDPWR 0.50529f
C1474 digital_0._101_.RESET_B VDPWR 0.49048f
C1475 digital_0._102_.D VDPWR 0.43282f
C1476 digital_0._102_.RESET_B VDPWR 0.80471f
C1477 digital_0._103_.D VDPWR 0.46656f
C1478 digital_0._103_.RESET_B VDPWR 0.4443f
C1479 digital_0._104_.D VDPWR 0.4181f
C1480 digital_0._104_.RESET_B VDPWR 0.62134f
C1481 digital_0._105_.D VDPWR 0.63065f
C1482 digital_0._105_.RESET_B VDPWR 0.52182f
C1483 digital_0._106_.D VDPWR 0.81806f
C1484 digital_0._106_.RESET_B VDPWR 0.37845f
C1485 digital_0._107_.D VDPWR 0.90224f
C1486 digital_0._107_.RESET_B VDPWR 0.44087f
C1487 digital_0._108_.D VDPWR 0.47311f
C1488 digital_0._108_.Q VDPWR 0.76234f
C1489 digital_0._108_.RESET_B VDPWR 0.26929f
C1490 digital_0._109_.D VDPWR 0.36865f
C1491 digital_0._109_.Q VDPWR 2.65482f
C1492 digital_0._109_.RESET_B VDPWR 0.32599f
C1493 digital_0._110_.D VDPWR 0.48437f
C1494 digital_0._110_.Q VDPWR 0.82981f
C1495 digital_0._110_.RESET_B VDPWR 0.23254f
C1496 digital_0._111_.D VDPWR 0.38072f
C1497 digital_0._111_.Q VDPWR 0.91076f
C1498 digital_0._111_.RESET_B VDPWR 0.2235f
C1499 digital_0._112_.D VDPWR 0.36959f
C1500 digital_0._112_.Q VDPWR 3.14689f
C1501 digital_0._112_.RESET_B VDPWR 0.49414f
C1502 digital_0._113_.D VDPWR 0.33636f
C1503 digital_0._113_.Q VDPWR 1.05493f
C1504 digital_0._113_.RESET_B VDPWR 0.50294f
C1505 digital_0._114_.D VDPWR 0.54663f
C1506 digital_0._114_.Q VDPWR 0.66562f
C1507 digital_0._114_.RESET_B VDPWR 0.28338f
C1508 digital_0._115_.D VDPWR 0.34016f
C1509 digital_0._115_.Q VDPWR 0.65202f
C1510 digital_0._115_.RESET_B VDPWR 0.37733f
C1511 digital_0._116_.D VDPWR 0.95721f
C1512 digital_0._116_.Q VDPWR 5.39891f
C1513 digital_0._116_.SET_B VDPWR 0.42783f
C1514 digital_0._117_.RESET_B VDPWR 0.51814f
C1515 digital_0._118_.D VDPWR 0.46566f
C1516 digital_0._118_.RESET_B VDPWR 0.75793f
C1517 digital_0._119_.RESET_B VDPWR 0.41285f
C1518 digital_0.clkbuf_1_0__f_clk.X VDPWR 3.19481f
C1519 digital_0.clkbuf_1_1__f_clk.A VDPWR 2.93599f
C1520 digital_0.clkload0.A VDPWR 4.06327f
C1521 digital_0.clkload0.X VDPWR 0.30516f
C1522 digital_0.hold18.X VDPWR 0.21734f
C1523 digital_0.hold19.X VDPWR 0.60317f
C1524 digital_0.hold20.X VDPWR 0.20866f
C1525 digital_0.hold21.X VDPWR 0.29451f
C1526 digital_0.hold22.X VDPWR 0.85473f
C1527 digital_0.hold23.X VDPWR 0.69489f
C1528 digital_0.hold24.X VDPWR 0.33078f
C1529 digital_0.hold25.X VDPWR 0.47456f
C1530 digital_0.hold26.X VDPWR 0.20799f
C1531 digital_0.hold27.X VDPWR 0.27305f
C1532 digital_0.hold28.A VDPWR 9.32204f
C1533 digital_0.hold28.X VDPWR 0.72291f
C1534 digital_0.input1.X VDPWR 4.54738f
C1535 digital_0.input2.X VDPWR 1.18969f
C1536 digital_0.input3.X VDPWR 0.70909f
C1537 digital_0.load_slew15.A VDPWR 1.31639f
C1538 digital_0.load_slew15.X VDPWR 2.7677f
C1539 digital_0.load_slew17.A VDPWR 3.44586f
C1540 digital_0.load_slew17.X VDPWR 3.46656f
C1541 digital_0.output10.A VDPWR 0.66256f
C1542 digital_0.output11.A VDPWR 0.69481f
C1543 digital_0.output12.A VDPWR 0.83015f
C1544 digital_0.output13.A VDPWR 1.50147f
C1545 digital_0.output4.A VDPWR 0.7581f
C1546 digital_0.output5.A VDPWR 0.85557f
C1547 digital_0.output6.A VDPWR 2.27964f
C1548 digital_0.output7.A VDPWR 0.6558f
C1549 digital_0.output8.A VDPWR 0.35426f
C1550 digital_0.output9.A VDPWR 0.7509f
C1551 VDPWR rst_n 0.91884f
C1552 VDPWR ui_in<0> 1.07467f
C1553 VDPWR ui_in<1> 0.84938f
C1554 VDPWR uio_out<0> 0.45351f
C1555 VDPWR uio_out<1> 0.7432f
C1556 VDPWR uio_out<2> 0.64141f
C1557 VDPWR uio_out<3> 2.19359f
C1558 VDPWR uio_out<4> 1.04071f
C1559 VDPWR uio_out<5> 0.6966f
C1560 VDPWR uio_out<6> 3.17853f
C1561 VDPWR uio_out<7> 1.13197f
C1562 VDPWR uo_out<0> 0.94974f
C1563 VDPWR uo_out<1> 1.28188f
C1564 a_10082_13154# VGND 1.09286f
C1565 a_10137_4838# VGND 0.01208f
C1566 a_10140_2778# VGND 0.07837f
C1567 a_10196_6904# VGND 0.43654f
C1568 a_10298_11234# VGND 0.50078f
C1569 a_10412_8824# VGND 0.65537f
C1570 a_10420_1298# VGND 0.2751f
C1571 a_10420_1842# VGND 0.27518f
C1572 a_10472_19784# VGND 0.52984f
C1573 a_10472_20216# VGND 0.52984f
C1574 a_10514_13154# VGND 0.65952f
C1575 a_10546_1482# VGND 0.27533f
C1576 a_10546_2106# VGND 0.27253f
C1577 a_10628_6904# VGND 0.53048f
C1578 a_10657_4562# VGND 0.61486f
C1579 a_10730_11234# VGND 0.53953f
C1580 a_10786_1298# VGND 0.3293f
C1581 a_10786_1842# VGND 0.32575f
C1582 a_10841_2386# VGND 0.60238f
C1583 a_10861_3474# VGND 0.5468f
C1584 a_10944_4840# VGND 0.28106f
C1585 a_11060_6904# VGND 1.90218f $ **FLOATING
C1586 a_11128_2664# VGND 0.26239f
C1587 a_11149_1874# VGND 0.60006f
C1588 a_11162_11234# VGND 1.90869f $ **FLOATING
C1589 a_11209_4018# VGND 0.5852f
C1590 a_11222_4856# VGND 0.32986f
C1591 a_11234_3276# VGND 0.52354f
C1592 a_11257_5926# VGND 0.01351f
C1593 a_11261_4730# VGND 0.63121f
C1594 a_11315_1874# VGND 0.33718f
C1595 a_11318_15928# VGND 0.48361f $ **FLOATING
C1596 a_11318_16728# VGND 0.36615f $ **FLOATING
C1597 a_11318_16986# VGND 0.04601f $ **FLOATING
C1598 a_11318_17786# VGND 0.04997f $ **FLOATING
C1599 a_11348_4954# VGND 0.18784f
C1600 a_11406_2680# VGND 0.32456f
C1601 a_11416_3500# VGND 1.97752f
C1602 a_11417_4825# VGND 0.2643f
C1603 a_11433_5132# VGND 0.01333f
C1604 a_11445_2554# VGND 0.69744f
C1605 a_11467_1651# VGND 0.36451f
C1606 a_11496_4176# VGND 0.26269f
C1607 a_11532_2778# VGND 0.17973f
C1608 a_11570_2234# VGND 0.08081f
C1609 a_11592_2956# VGND 0.01146f
C1610 a_11592_3276# VGND 0.32549f
C1611 a_11601_2649# VGND 0.26714f
C1612 a_11665_2246# VGND 0.27362f
C1613 a_11721_1651# VGND 0.278f
C1614 a_11774_4160# VGND 0.3195f
C1615 a_11793_5926# VGND 0.01459f
C1616 a_11813_4286# VGND 0.61578f
C1617 a_11883_1842# VGND 0.19661f
C1618 a_11900_4044# VGND 0.19382f
C1619 a_11969_4018# VGND 0.28815f
C1620 a_11980_4954# VGND 0.07459f
C1621 a_11988_14620# VGND 0.11547f $ **FLOATING
C1622 a_11988_15420# VGND 0.10723f $ **FLOATING
C1623 a_11996_18042# VGND 0.0144f $ **FLOATING
C1624 a_11996_18842# VGND 0.09281f $ **FLOATING
C1625 a_12069_5132# VGND 0.01511f
C1626 a_12114_4044# VGND 0.01231f
C1627 a_12154_5452# VGND 0.52229f
C1628 a_12164_2778# VGND 0.0958f
C1629 a_12230_2246# VGND 0.31552f
C1630 a_12279_4410# VGND 0.01372f
C1631 a_12323_1476# VGND 0.27569f
C1632 a_12367_2956# VGND 0.39811f
C1633 a_12405_2172# VGND 0.61874f
C1634 a_12419_1298# VGND 0.40272f
C1635 a_12512_5452# VGND 0.32231f
C1636 a_12532_4044# VGND 0.0749f
C1637 a_12603_2956# VGND 0.3832f
C1638 a_12677_1298# VGND 0.3806f
C1639 a_12688_15928# VGND 0.43748f $ **FLOATING
C1640 a_12688_16728# VGND 0.36061f $ **FLOATING
C1641 a_12688_16988# VGND 0.04043f $ **FLOATING
C1642 a_12688_17788# VGND 0.05055f $ **FLOATING
C1643 a_12688_20180# VGND 0.09276f $ **FLOATING
C1644 a_12688_20980# VGND 0.09416f $ **FLOATING
C1645 a_12709_2956# VGND 0.23339f
C1646 a_12847_4915# VGND 0.34646f
C1647 a_12919_2412# VGND 0.38951f
C1648 a_13042_1476# VGND 0.31743f
C1649 a_13101_4915# VGND 0.26613f
C1650 a_13132_4276# VGND 0.34218f
C1651 a_13141_2930# VGND 0.58045f
C1652 a_13155_2412# VGND 0.37878f
C1653 a_13261_2412# VGND 0.23815f
C1654 a_13428_3088# VGND 0.25799f
C1655 a_13541_1874# VGND 0.54416f
C1656 a_13693_4018# VGND 0.57983f
C1657 a_13706_3072# VGND 0.29447f
C1658 a_13707_1874# VGND 0.29367f
C1659 a_13725_1324# VGND 0.33484f
C1660 a_13725_2412# VGND 0.54949f
C1661 a_13725_4588# VGND 0.63146f
C1662 a_13745_3198# VGND 0.54087f
C1663 a_13795_5828# VGND 0.23052f
C1664 a_13832_2956# VGND 0.17482f
C1665 a_13891_2412# VGND 0.4994f
C1666 a_13891_4588# VGND 0.29637f
C1667 a_13891_5650# VGND 0.39037f
C1668 a_13901_2930# VGND 0.2593f
C1669 a_13942_1324# VGND 0.28702f
C1670 a_13951_3827# VGND 0.2988f
C1671 a_13962_2234# VGND 0.07386f
C1672 a_13969_5106# VGND 0.58778f
C1673 a_13980_4176# VGND 0.26861f
C1674 a_14053_1324# VGND 0.28434f
C1675 a_14057_2246# VGND 0.25806f
C1676 a_14079_2412# VGND 0.09909f
C1677 a_14146_4588# VGND 0.08f
C1678 a_14149_5650# VGND 0.38799f
C1679 a_14174_2412# VGND 0.43315f
C1680 a_14205_3827# VGND 0.26361f
C1681 a_14241_4588# VGND 0.26133f
C1682 a_14256_5264# VGND 0.27285f
C1683 a_14258_4160# VGND 0.30397f
C1684 a_14275_1842# VGND 0.18395f
C1685 a_14297_4286# VGND 0.67208f
C1686 a_14350_2386# VGND 0.18046f
C1687 a_14358_11800# VGND 0.09812f $ **FLOATING
C1688 a_14358_14620# VGND 0.0127f $ **FLOATING
C1689 a_14358_15420# VGND 0.0629f $ **FLOATING
C1690 a_14358_15930# VGND 0.06286f $ **FLOATING
C1691 a_14358_19550# VGND 0.09424f $ **FLOATING
C1692 a_14384_4044# VGND 0.18626f
C1693 a_14453_4018# VGND 0.26189f
C1694 a_14459_4830# VGND 0.18475f
C1695 a_14464_2956# VGND 0.07386f
C1696 a_14531_1476# VGND 0.23821f
C1697 a_14534_5248# VGND 0.30761f
C1698 a_14553_5676# VGND 0.29717f
C1699 a_14573_5374# VGND 0.68413f
C1700 a_14622_2246# VGND 0.26826f
C1701 a_14627_1298# VGND 0.39158f
C1702 a_14660_5132# VGND 0.1872f
C1703 a_14726_2778# VGND 0.40756f
C1704 a_14729_5106# VGND 0.26621f
C1705 a_14759_3500# VGND 0.35882f
C1706 a_14770_5676# VGND 0.2876f
C1707 a_14797_2172# VGND 0.58184f
C1708 a_14806_4588# VGND 0.27275f
C1709 a_14876_2626# VGND 0.17883f
C1710 a_14881_5676# VGND 0.28408f
C1711 a_14885_1298# VGND 0.3876f
C1712 a_14981_4562# VGND 0.59692f
C1713 a_14995_3500# VGND 0.36806f
C1714 a_15016_4044# VGND 0.08f
C1715 a_15101_3500# VGND 0.22038f
C1716 a_15289_1324# VGND 0.29946f
C1717 a_15289_2956# VGND 0.31529f
C1718 a_15289_5676# VGND 0.27838f
C1719 a_15292_5132# VGND 0.08f
C1720 a_15300_2412# VGND 0.31913f
C1721 a_15506_1324# VGND 0.29501f
C1722 a_15506_2956# VGND 0.27795f
C1723 a_15506_5676# VGND 0.27698f
C1724 a_15507_3528# VGND 0.33905f
C1725 a_15617_1324# VGND 0.30662f
C1726 a_15617_2956# VGND 0.2902f
C1727 a_15617_5676# VGND 0.29012f
C1728 a_15998_13144# VGND 1.79633f $ **FLOATING
C1729 a_16008_16644# VGND 1.85086f $ **FLOATING
C1730 a_16018_19950# VGND 0.11578f $ **FLOATING
C1731 a_16018_20750# VGND 0.09304f $ **FLOATING
C1732 a_16214_13144# VGND 0.63633f
C1733 a_16224_16644# VGND 0.52984f
C1734 a_16440_18564# VGND 0.63171f
C1735 a_16646_13144# VGND 1.81369f $ **FLOATING
C1736 a_16656_16644# VGND 0.43595f
C1737 a_16872_18564# VGND 0.63171f
C1738 a_17088_16644# VGND 0.43595f
C1739 a_17304_18564# VGND 0.63171f
C1740 a_17508_13144# VGND 1.79886f $ **FLOATING
C1741 a_17520_16644# VGND 0.43595f
C1742 a_17668_19950# VGND 0.11691f $ **FLOATING
C1743 a_17668_20750# VGND 0.09304f $ **FLOATING
C1744 a_17724_13144# VGND 0.62372f
C1745 a_17736_18564# VGND 0.63171f
C1746 a_17850_4665# VGND 0.49625f $ **FLOATING
C1747 a_17850_5465# VGND 0.53307f $ **FLOATING
C1748 a_17952_16644# VGND 0.43595f
C1749 a_18156_13144# VGND 1.7963f $ **FLOATING
C1750 a_18168_18564# VGND 0.63171f
C1751 a_18384_16644# VGND 0.43595f
C1752 a_18456_10709# VGND 0.07526f $ **FLOATING
C1753 a_18456_11509# VGND 0.07658f $ **FLOATING
C1754 a_18456_12309# VGND 0.09896f $ **FLOATING
C1755 a_18456_9909# VGND 0.09536f $ **FLOATING
C1756 a_18600_18564# VGND 0.63171f
C1757 a_18756_7709# VGND 0.53146f $ **FLOATING
C1758 a_18756_8509# VGND 0.51605f $ **FLOATING
C1759 a_18816_16644# VGND 0.43595f
C1760 a_19018_13144# VGND 1.7965f $ **FLOATING
C1761 a_19032_18564# VGND 0.63171f
C1762 a_19234_13144# VGND 0.62372f
C1763 a_19248_16644# VGND 0.52981f
C1764 a_19356_6659# VGND 0.53678f $ **FLOATING
C1765 a_19356_7459# VGND 0.52649f $ **FLOATING
C1766 a_19666_13144# VGND 1.79761f $ **FLOATING
C1767 a_19680_16644# VGND 1.86518f $ **FLOATING
C1768 a_19706_8759# VGND 0.45452f $ **FLOATING
C1769 a_19706_9559# VGND 0.40866f $ **FLOATING
C1770 a_20156_10709# VGND 0.10069f $ **FLOATING
C1771 a_20156_7709# VGND 0.54389f $ **FLOATING
C1772 a_20156_8509# VGND 0.51027f $ **FLOATING
C1773 a_20156_9909# VGND 0.08029f $ **FLOATING
C1774 a_20372_11267# VGND 1.81325f $ **FLOATING
C1775 a_20372_11699# VGND 0.63171f
C1776 a_20372_12347# VGND 1.86823f $ **FLOATING
C1777 a_20412_20378# VGND 0.37895f $ **FLOATING
C1778 a_20412_20698# VGND 0.34895f $ **FLOATING
C1779 a_20528_13144# VGND 1.79601f $ **FLOATING
C1780 a_20538_16644# VGND 1.8634f $ **FLOATING
C1781 a_20744_13144# VGND 0.62372f
C1782 a_20754_16644# VGND 0.52983f
C1783 a_20970_18564# VGND 0.63192f
C1784 a_21176_13144# VGND 1.796f $ **FLOATING
C1785 a_21186_16644# VGND 0.43595f
C1786 a_21252_20378# VGND 0.09677f $ **FLOATING
C1787 a_21252_20698# VGND 0.08287f $ **FLOATING
C1788 a_21402_18564# VGND 0.63171f
C1789 a_21554_10625# VGND 0.4857f $ **FLOATING
C1790 a_21554_8773# VGND 0.4626f $ **FLOATING
C1791 a_21554_9573# VGND 0.45893f $ **FLOATING
C1792 a_21554_9825# VGND 0.45845f $ **FLOATING
C1793 a_21558_7709# VGND 0.52382f $ **FLOATING
C1794 a_21558_8509# VGND 0.48005f $ **FLOATING
C1795 a_21618_16644# VGND 0.43595f
C1796 a_21834_18564# VGND 0.63171f
C1797 a_22038_13144# VGND 1.87049f $ **FLOATING
C1798 a_22050_16644# VGND 0.43595f
C1799 a_22254_13144# VGND 0.5385f
C1800 a_22266_18564# VGND 0.63171f
C1801 a_22292_11483# VGND 0.53632f
C1802 a_22292_11915# VGND 0.53632f
C1803 a_22470_15064# VGND 0.63355f
C1804 a_22482_16644# VGND 0.43595f
C1805 a_22686_13144# VGND 0.60167f
C1806 a_22698_18564# VGND 0.67519f
C1807 a_22902_15064# VGND 0.71634f
C1808 a_22914_16644# VGND 0.49811f
C1809 a_23118_13144# VGND 0.51211f
C1810 a_23130_18564# VGND 0.6641f
C1811 a_23138_7627# VGND 0.49653f $ **FLOATING
C1812 a_23138_8427# VGND 0.36615f $ **FLOATING
C1813 a_23138_8685# VGND 0.04601f $ **FLOATING
C1814 a_23138_9485# VGND 0.0513f $ **FLOATING
C1815 a_23334_15064# VGND 0.65049f
C1816 a_23346_16644# VGND 0.45989f
C1817 a_23550_13144# VGND 0.55059f
C1818 a_23562_18564# VGND 0.64482f
C1819 a_23778_16644# VGND 0.54007f
C1820 a_23816_10541# VGND 0.07131f $ **FLOATING
C1821 a_23816_9741# VGND 0.01454f $ **FLOATING
C1822 a_23824_11183# VGND 0.0717f $ **FLOATING
C1823 a_23824_11983# VGND 0.09686f $ **FLOATING
C1824 a_23982_13144# VGND 1.88203f $ **FLOATING
C1825 a_24210_16644# VGND 1.87767f $ **FLOATING
C1826 a_24508_7627# VGND 0.42047f $ **FLOATING
C1827 a_24508_8427# VGND 0.36248f $ **FLOATING
C1828 a_24508_8687# VGND 0.04081f $ **FLOATING
C1829 a_24508_9487# VGND 0.05146f $ **FLOATING
C1830 a_24510_6435# VGND 0.53896f $ **FLOATING
C1831 a_24510_7235# VGND 0.47456f $ **FLOATING
C1832 a_2478_10440# VGND 0.11928f $ **FLOATING
C1833 a_2478_11240# VGND 0.06519f $ **FLOATING
C1834 a_2478_11750# VGND 0.06306f $ **FLOATING
C1835 a_2478_12550# VGND 0.0622f $ **FLOATING
C1836 a_2478_13060# VGND 0.06174f $ **FLOATING
C1837 a_2478_13860# VGND 0.06196f $ **FLOATING
C1838 a_2478_14370# VGND 0.06248f $ **FLOATING
C1839 a_2478_15170# VGND 0.06248f $ **FLOATING
C1840 a_2478_15680# VGND 0.06196f $ **FLOATING
C1841 a_2478_16480# VGND 0.06196f $ **FLOATING
C1842 a_2478_16990# VGND 0.06248f $ **FLOATING
C1843 a_2478_17790# VGND 0.06196f $ **FLOATING
C1844 a_2478_18300# VGND 0.06248f $ **FLOATING
C1845 a_2478_19100# VGND 0.06248f $ **FLOATING
C1846 a_2478_19610# VGND 0.06196f $ **FLOATING
C1847 a_2478_20410# VGND 0.09367f $ **FLOATING
C1848 a_24838_13144# VGND 1.86402f $ **FLOATING
C1849 a_25054_13144# VGND 0.52983f
C1850 a_25078_16644# VGND 1.86526f $ **FLOATING
C1851 a_25270_15064# VGND 0.63194f
C1852 a_25294_16644# VGND 0.52984f
C1853 a_25486_13144# VGND 0.43595f
C1854 a_25510_18564# VGND 0.63171f
C1855 a_25702_15064# VGND 0.63194f
C1856 a_25726_16644# VGND 0.43595f
C1857 a_25918_13144# VGND 0.43595f
C1858 a_25942_18564# VGND 0.63171f
C1859 a_26086_6531# VGND 0.37817f $ **FLOATING
C1860 a_26086_6851# VGND 0.33527f $ **FLOATING
C1861 a_26088_7351# VGND 0.34646f $ **FLOATING
C1862 a_26088_7671# VGND 0.33398f $ **FLOATING
C1863 a_26090_10293# VGND 0.31036f $ **FLOATING
C1864 a_26090_10613# VGND 0.31386f $ **FLOATING
C1865 a_26090_11093# VGND 0.31602f $ **FLOATING
C1866 a_26090_11733# VGND 0.3119f $ **FLOATING
C1867 a_26090_12053# VGND 0.34862f $ **FLOATING
C1868 a_26090_8213# VGND 0.41859f $ **FLOATING
C1869 a_26090_8533# VGND 0.40042f $ **FLOATING
C1870 a_26090_9013# VGND 0.31073f $ **FLOATING
C1871 a_26090_9333# VGND 0.31349f $ **FLOATING
C1872 a_26090_9813# VGND 0.31584f $ **FLOATING
C1873 a_26134_15064# VGND 0.63194f
C1874 a_26146_4651# VGND 0.4961f $ **FLOATING
C1875 a_26146_5451# VGND 0.52065f $ **FLOATING
C1876 a_26158_16644# VGND 0.43595f
C1877 a_26350_13144# VGND 0.53322f
C1878 a_26374_18564# VGND 0.63171f
C1879 a_26590_16644# VGND 0.43595f
C1880 a_26782_13144# VGND 1.8706f $ **FLOATING
C1881 a_26806_18564# VGND 0.63171f
C1882 a_26926_6531# VGND 0.08273f $ **FLOATING
C1883 a_26926_6851# VGND 0.05419f $ **FLOATING
C1884 a_26928_7351# VGND 0.05422f $ **FLOATING
C1885 a_26928_7671# VGND 0.05685f $ **FLOATING
C1886 a_26930_12053# VGND 0.08336f $ **FLOATING
C1887 a_26930_8213# VGND 0.05804f $ **FLOATING
C1888 a_27022_16644# VGND 0.43595f
C1889 a_27238_18564# VGND 0.63171f
C1890 a_27454_16644# VGND 0.43595f
C1891 a_27638_13144# VGND 1.8955f $ **FLOATING
C1892 a_27670_18564# VGND 0.63171f
C1893 a_27854_13144# VGND 0.55891f
C1894 a_27886_16644# VGND 0.43595f
C1895 a_28070_15064# VGND 0.70074f
C1896 a_28102_18564# VGND 0.63171f
C1897 a_28286_13144# VGND 0.51428f
C1898 a_28318_16644# VGND 0.60277f
C1899 a_28502_15064# VGND 0.77053f
C1900 a_2858_6904# VGND 1.89354f $ **FLOATING
C1901 a_28718_13144# VGND 0.51196f
C1902 a_28750_16644# VGND 1.89389f $ **FLOATING
C1903 a_28934_15064# VGND 0.66729f
C1904 a_29150_13144# VGND 0.58882f
C1905 a_29432_20186# VGND 0.08093f $ **FLOATING
C1906 a_29432_21944# VGND 0.08088f $ **FLOATING
C1907 a_29582_13144# VGND 1.93307f $ **FLOATING
C1908 a_30272_20186# VGND 0.36716f $ **FLOATING
C1909 a_30272_20666# VGND 0.33097f $ **FLOATING
C1910 a_30272_20986# VGND 0.31423f $ **FLOATING
C1911 a_30272_21305# VGND 0.39141f $ **FLOATING
C1912 a_30272_21624# VGND 0.40472f $ **FLOATING
C1913 a_30272_21944# VGND 0.35438f $ **FLOATING
C1914 a_3074_6904# VGND 0.53009f
C1915 a_3290_8824# VGND 0.64498f
C1916 a_3336_4018# VGND 0.29257f
C1917 a_3389_2930# VGND 0.60407f
C1918 a_3437_1574# VGND 0.01204f
C1919 a_3437_1868# VGND 0.01142f
C1920 a_3443_2412# VGND 0.40086f
C1921 a_3462_4282# VGND 0.28215f
C1922 a_3506_6904# VGND 0.43652f
C1923 a_3513_3500# VGND 0.30025f
C1924 a_3676_3088# VGND 0.27003f
C1925 a_3679_2412# VGND 0.37199f
C1926 a_3702_4018# VGND 0.31595f
C1927 a_3722_8824# VGND 0.6433f
C1928 a_3730_3500# VGND 0.26926f
C1929 a_3785_2412# VGND 0.21632f
C1930 a_3841_3500# VGND 0.27598f
C1931 a_3903_1324# VGND 0.42268f
C1932 a_3938_6904# VGND 0.43659f
C1933 a_3941_1842# VGND 0.60564f
C1934 a_3954_3072# VGND 0.3019f
C1935 a_3993_3198# VGND 0.68261f
C1936 a_4033_5106# VGND 0.64147f
C1937 a_4080_2956# VGND 0.18283f
C1938 a_4139_1324# VGND 0.39134f
C1939 a_4149_2930# VGND 0.26568f
C1940 a_4154_8824# VGND 0.64358f
C1941 a_4157_2412# VGND 0.27022f
C1942 a_4228_2000# VGND 0.27529f
C1943 a_4245_1324# VGND 0.23649f
C1944 a_4320_5264# VGND 0.28102f
C1945 a_4341_4052# VGND 0.32527f
C1946 a_4370_6904# VGND 0.43595f
C1947 a_4374_2412# VGND 0.27166f
C1948 a_4383_3827# VGND 0.28053f
C1949 a_4455_5676# VGND 0.42205f
C1950 a_4485_2412# VGND 0.27946f
C1951 a_4506_1984# VGND 0.31384f
C1952 a_4545_2110# VGND 0.60689f
C1953 a_4578_11400# VGND 0.51407f $ **FLOATING
C1954 a_4578_12200# VGND 0.4881f $ **FLOATING
C1955 a_4578_12610# VGND 0.11513f $ **FLOATING
C1956 a_4578_13410# VGND 0.05679f $ **FLOATING
C1957 a_4578_13670# VGND 0.3651f $ **FLOATING
C1958 a_4578_14470# VGND 0.38763f $ **FLOATING
C1959 a_4578_15270# VGND 0.3874f $ **FLOATING
C1960 a_4578_16070# VGND 0.38915f $ **FLOATING
C1961 a_4578_17320# VGND 0.42975f $ **FLOATING
C1962 a_4578_18120# VGND 0.35453f $ **FLOATING
C1963 a_4578_18260# VGND 0.35417f $ **FLOATING
C1964 a_4578_19060# VGND 0.35369f $ **FLOATING
C1965 a_4578_19200# VGND 0.35396f $ **FLOATING
C1966 a_4578_20000# VGND 0.35276f $ **FLOATING
C1967 a_4578_20140# VGND 0.35276f $ **FLOATING
C1968 a_4578_20940# VGND 0.4503f $ **FLOATING
C1969 a_4580_16870# VGND 0.42944f $ **FLOATING
C1970 a_4586_8824# VGND 0.68272f
C1971 a_4598_5248# VGND 0.30655f
C1972 a_4632_1868# VGND 0.18923f
C1973 a_4637_3827# VGND 0.25891f
C1974 a_4637_5374# VGND 0.63867f
C1975 a_4691_5676# VGND 0.38729f
C1976 a_4701_1842# VGND 0.2656f
C1977 a_4712_2956# VGND 0.08f
C1978 a_4724_5132# VGND 0.20082f
C1979 a_4793_5106# VGND 0.27406f
C1980 a_4797_5676# VGND 0.2285f
C1981 a_4802_6904# VGND 0.43595f
C1982 a_4935_1651# VGND 0.3147f
C1983 a_5018_8824# VGND 0.71483f
C1984 a_5169_5676# VGND 0.27109f
C1985 a_5189_1651# VGND 0.27032f
C1986 a_5234_6904# VGND 0.43595f
C1987 a_5264_1868# VGND 0.07881f
C1988 a_5321_2386# VGND 0.59282f
C1989 a_5321_3474# VGND 0.59513f
C1990 a_5356_5132# VGND 0.08f
C1991 a_5386_5676# VGND 0.27823f
C1992 a_5450_8824# VGND 0.71483f
C1993 a_5497_5676# VGND 0.27997f
C1994 a_5608_2664# VGND 0.26074f
C1995 a_5608_3752# VGND 0.2588f
C1996 a_5666_6904# VGND 0.43595f
C1997 a_5873_4562# VGND 0.59574f
C1998 a_5882_8824# VGND 0.71483f
C1999 a_5886_2680# VGND 0.30061f
C2000 a_5886_3768# VGND 0.28801f
C2001 a_5925_2554# VGND 0.57364f
C2002 a_5925_3642# VGND 0.52413f
C2003 a_5997_4044# VGND 0.01014f
C2004 a_6012_2778# VGND 0.17859f
C2005 a_6012_3866# VGND 0.17772f
C2006 a_6046_5364# VGND 0.27398f
C2007 a_6075_1842# VGND 0.33203f
C2008 a_6081_2649# VGND 0.27053f
C2009 a_6081_3737# VGND 0.25706f
C2010 a_6098_6904# VGND 0.52984f
C2011 a_6160_4840# VGND 0.26438f
C2012 a_6280_5650# VGND 0.28273f
C2013 a_6343_2930# VGND 2.01117f
C2014 a_6372_1298# VGND 0.28608f
C2015 a_6406_5834# VGND 0.28339f
C2016 a_6438_4856# VGND 0.2973f
C2017 a_6475_5430# VGND 0.30644f
C2018 a_6477_4730# VGND 0.53679f
C2019 a_6498_1482# VGND 0.27917f
C2020 a_6530_6904# VGND 1.85252f $ **FLOATING
C2021 a_6564_4954# VGND 0.18886f
C2022 a_6631_1842# VGND 0.47541f
C2023 a_6633_4825# VGND 0.26435f
C2024 a_6636_18210# VGND 0.09526f $ **FLOATING
C2025 a_6636_19010# VGND 0.07525f $ **FLOATING
C2026 a_6636_19810# VGND 0.07597f $ **FLOATING
C2027 a_6636_20610# VGND 0.09372f $ **FLOATING
C2028 a_6644_2778# VGND 0.07397f
C2029 a_6644_3866# VGND 0.07386f
C2030 a_6646_5650# VGND 0.28298f
C2031 a_6738_1298# VGND 0.2787f
C2032 a_6851_2188# VGND 0.30385f
C2033 a_6936_16010# VGND 0.53615f $ **FLOATING
C2034 a_6936_16810# VGND 0.51609f $ **FLOATING
C2035 a_6939_5676# VGND 0.37503f
C2036 a_6968_4276# VGND 0.34224f
C2037 a_7009_1324# VGND 0.29021f
C2038 a_7148_11234# VGND 1.8889f $ **FLOATING
C2039 a_7175_5676# VGND 0.3893f
C2040 a_7196_4954# VGND 0.07859f
C2041 a_7226_1324# VGND 0.29295f
C2042 a_7253_2386# VGND 0.52256f
C2043 a_7281_5676# VGND 0.23691f
C2044 a_7337_1324# VGND 0.2875f
C2045 a_7364_11234# VGND 0.53688f
C2046 a_7385_3750# VGND 0.01068f
C2047 a_7388_6904# VGND 1.85075f $ **FLOATING
C2048 a_7529_5106# VGND 0.5919f
C2049 a_7536_14960# VGND 0.53503f $ **FLOATING
C2050 a_7536_15760# VGND 0.52719f $ **FLOATING
C2051 a_7547_4018# VGND 0.33064f
C2052 a_7580_13154# VGND 0.64099f
C2053 a_7604_6904# VGND 0.52984f
C2054 a_7695_6003# VGND 0.27795f
C2055 a_7745_2412# VGND 0.36434f
C2056 a_7767_1324# VGND 0.36858f
C2057 a_7796_11234# VGND 0.53518f
C2058 a_7816_5264# VGND 0.2736f
C2059 a_7820_8824# VGND 0.65537f
C2060 a_7871_4616# VGND 0.31222f
C2061 a_7886_17060# VGND 0.45452f $ **FLOATING
C2062 a_7886_17860# VGND 0.40866f $ **FLOATING
C2063 a_7949_6003# VGND 0.27579f
C2064 a_8003_1324# VGND 0.36828f
C2065 a_8036_6904# VGND 0.43595f
C2066 a_8081_1842# VGND 0.59026f
C2067 a_8081_4018# VGND 0.60082f
C2068 a_8094_5248# VGND 0.29702f
C2069 a_8109_1324# VGND 0.22171f
C2070 a_8133_5374# VGND 0.60161f
C2071 a_8220_5132# VGND 0.18656f
C2072 a_8228_11234# VGND 1.82172f $ **FLOATING
C2073 a_8252_8824# VGND 0.65537f
C2074 a_8289_5106# VGND 0.2603f
C2075 a_8336_16010# VGND 0.54416f $ **FLOATING
C2076 a_8336_16810# VGND 0.51027f $ **FLOATING
C2077 a_8336_18210# VGND 0.08029f $ **FLOATING
C2078 a_8336_19010# VGND 0.10069f $ **FLOATING
C2079 a_8368_2000# VGND 0.27724f
C2080 a_8368_4176# VGND 0.27304f
C2081 a_8389_2956# VGND 0.01346f
C2082 a_8389_3276# VGND 0.59813f
C2083 a_8468_6904# VGND 0.43595f
C2084 a_8552_19568# VGND 1.81111f $ **FLOATING
C2085 a_8552_20000# VGND 0.63171f
C2086 a_8552_20648# VGND 1.85378f $ **FLOATING
C2087 a_8573_4588# VGND 0.17588f
C2088 a_8615_1651# VGND 0.31404f
C2089 a_8646_1984# VGND 0.30626f
C2090 a_8646_4160# VGND 0.30274f
C2091 a_8684_8824# VGND 0.65537f
C2092 a_8685_2110# VGND 0.68855f
C2093 a_8685_4286# VGND 0.68534f
C2094 a_8735_3474# VGND 1.9916f
C2095 a_8739_4910# VGND 0.25352f
C2096 a_8772_1868# VGND 0.18516f
C2097 a_8772_4044# VGND 0.18654f
C2098 a_8793_4562# VGND 0.18095f
C2099 a_8817_2386# VGND 0.57268f
C2100 a_8841_1842# VGND 0.26437f
C2101 a_8841_4018# VGND 0.26368f
C2102 a_8852_5132# VGND 0.07386f
C2103 a_8869_1651# VGND 0.28231f
C2104 a_8900_6904# VGND 0.43659f
C2105 a_9104_2664# VGND 0.25807f
C2106 a_9116_8824# VGND 0.65537f
C2107 a_9217_2956# VGND 0.32958f
C2108 a_9218_11234# VGND 1.8856f $ **FLOATING
C2109 a_9332_6904# VGND 0.43654f
C2110 a_9382_2680# VGND 0.30005f
C2111 a_9404_1868# VGND 0.08173f
C2112 a_9404_4044# VGND 0.08003f
C2113 a_9417_4838# VGND 0.01244f
C2114 a_9421_2554# VGND 0.61408f
C2115 a_9434_11234# VGND 0.5658f
C2116 a_9434_2956# VGND 0.27908f
C2117 a_9508_2778# VGND 0.17911f
C2118 a_9545_2956# VGND 0.27435f
C2119 a_9548_8824# VGND 0.65537f
C2120 a_9577_2649# VGND 0.25789f
C2121 a_9650_13154# VGND 0.97771f
C2122 a_9677_1690# VGND 0.24798f
C2123 a_9734_17074# VGND 0.4626f $ **FLOATING
C2124 a_9734_17874# VGND 0.45893f $ **FLOATING
C2125 a_9734_18126# VGND 0.45845f $ **FLOATING
C2126 a_9734_18926# VGND 0.4856f $ **FLOATING
C2127 a_9738_16010# VGND 0.52514f $ **FLOATING
C2128 a_9738_16810# VGND 0.48005f $ **FLOATING
C2129 a_9764_6904# VGND 0.43659f
C2130 a_9862_1690# VGND 0.33481f
C2131 a_9866_11234# VGND 0.87141f
C2132 a_9980_8824# VGND 0.65537f
C2133 clk VGND 13.5676f
C2134 digital_0._057_.D VGND 1.69216f
C2135 digital_0._060_.A_N VGND 1.84069f
C2136 digital_0._060_.B VGND 0.34689f
C2137 digital_0._063_.A VGND 1.28369f
C2138 digital_0._063_.B VGND 1.69785f
C2139 digital_0._065_.A2_N VGND 2.49776f
C2140 digital_0._067_.A VGND 0.60536f
C2141 digital_0._067_.B VGND 0.69729f
C2142 digital_0._069_.A VGND 3.36055f
C2143 digital_0._069_.B VGND 0.75972f
C2144 digital_0._080_.A2 VGND 0.49663f
C2145 digital_0._100_.D VGND 0.61918f
C2146 digital_0._100_.RESET_B VGND 1.13015f
C2147 digital_0._101_.D VGND 0.29588f
C2148 digital_0._101_.RESET_B VGND 0.84734f
C2149 digital_0._102_.D VGND 0.62129f
C2150 digital_0._102_.RESET_B VGND 0.81736f
C2151 digital_0._103_.D VGND 0.84614f
C2152 digital_0._103_.RESET_B VGND 0.828f
C2153 digital_0._104_.D VGND 0.52653f
C2154 digital_0._104_.RESET_B VGND 0.80961f
C2155 digital_0._105_.D VGND 0.32866f
C2156 digital_0._105_.RESET_B VGND 0.69531f
C2157 digital_0._106_.D VGND 0.36049f
C2158 digital_0._106_.RESET_B VGND 0.78914f
C2159 digital_0._107_.D VGND 0.3f
C2160 digital_0._107_.RESET_B VGND 1.28318f
C2161 digital_0._108_.D VGND 0.4422f
C2162 digital_0._108_.Q VGND 2.77523f
C2163 digital_0._108_.RESET_B VGND 1.42762f
C2164 digital_0._109_.D VGND 0.7085f
C2165 digital_0._109_.Q VGND 0.92056f
C2166 digital_0._109_.RESET_B VGND 1.05223f
C2167 digital_0._110_.D VGND 0.50536f
C2168 digital_0._110_.Q VGND 1.39468f
C2169 digital_0._110_.RESET_B VGND 0.9097f
C2170 digital_0._111_.D VGND 0.70089f
C2171 digital_0._111_.Q VGND 0.81127f
C2172 digital_0._111_.RESET_B VGND 1.02704f
C2173 digital_0._112_.D VGND 1.26581f
C2174 digital_0._112_.Q VGND 1.20045f
C2175 digital_0._112_.RESET_B VGND 1.51769f
C2176 digital_0._113_.D VGND 0.50822f
C2177 digital_0._113_.Q VGND 1.8909f
C2178 digital_0._113_.RESET_B VGND 1.76605f
C2179 digital_0._114_.D VGND 0.44923f
C2180 digital_0._114_.Q VGND 1.58128f
C2181 digital_0._114_.RESET_B VGND 0.61458f
C2182 digital_0._115_.D VGND 0.46648f
C2183 digital_0._115_.Q VGND 1.38476f
C2184 digital_0._115_.RESET_B VGND 1.73343f
C2185 digital_0._116_.D VGND 0.31398f
C2186 digital_0._116_.Q VGND 6.88578f
C2187 digital_0._116_.SET_B VGND 1.48311f
C2188 digital_0._117_.RESET_B VGND 1.26589f
C2189 digital_0._118_.D VGND 0.71167f
C2190 digital_0._118_.RESET_B VGND 0.63632f
C2191 digital_0._119_.RESET_B VGND 0.76526f
C2192 digital_0.clkbuf_1_0__f_clk.X VGND 3.28097f
C2193 digital_0.clkbuf_1_1__f_clk.A VGND 2.6869f
C2194 digital_0.clkload0.A VGND 3.13782f
C2195 digital_0.clkload0.X VGND 0.23313f
C2196 digital_0.hold18.X VGND 0.33263f
C2197 digital_0.hold19.X VGND 0.39869f
C2198 digital_0.hold20.X VGND 0.41779f
C2199 digital_0.hold21.X VGND 0.47232f
C2200 digital_0.hold22.X VGND 0.45354f
C2201 digital_0.hold23.X VGND 0.35644f
C2202 digital_0.hold24.X VGND 1.16125f
C2203 digital_0.hold25.X VGND 0.67374f
C2204 digital_0.hold26.X VGND 0.46166f
C2205 digital_0.hold27.X VGND 0.59107f
C2206 digital_0.hold28.A VGND 3.96301f
C2207 digital_0.hold28.X VGND 0.4511f
C2208 digital_0.input1.X VGND 2.69477f
C2209 digital_0.input2.X VGND 1.35326f
C2210 digital_0.input3.X VGND 0.71251f
C2211 digital_0.load_slew15.A VGND 2.06893f
C2212 digital_0.load_slew15.X VGND 4.40999f
C2213 digital_0.load_slew17.A VGND 3.04631f
C2214 digital_0.load_slew17.X VGND 2.5656f
C2215 digital_0.output10.A VGND 1.55065f
C2216 digital_0.output11.A VGND 0.56252f
C2217 digital_0.output12.A VGND 0.73978f
C2218 digital_0.output13.A VGND 2.93136f
C2219 digital_0.output4.A VGND 1.06204f
C2220 digital_0.output5.A VGND 0.54441f
C2221 digital_0.output6.A VGND 0.66567f
C2222 digital_0.output7.A VGND 1.06199f
C2223 digital_0.output8.A VGND 0.92699f
C2224 digital_0.output9.A VGND 0.69223f
C2225 ena VGND 0.064f
C2226 m1_7720_7850# VGND 0.12028f $ **FLOATING
C2227 m4_6134_22044# VGND 0.01451f $ **FLOATING
C2228 rst_n VGND 2.67111f
C2229 ui_in<0> VGND 8.22633f
C2230 ui_in<1> VGND 2.9017f
C2231 ui_in<2> VGND 0.04321f
C2232 ui_in<3> VGND 0.04234f
C2233 ui_in<4> VGND 0.04234f
C2234 ui_in<5> VGND 0.04226f
C2235 ui_in<6> VGND 0.04226f
C2236 ui_in<7> VGND 0.04226f
C2237 uio_in<0> VGND 0.03967f
C2238 uio_in<1> VGND 0.042f
C2239 uio_in<2> VGND 0.04051f
C2240 uio_in<3> VGND 0.0406f
C2241 uio_in<4> VGND 0.04118f
C2242 uio_in<5> VGND 0.0402f
C2243 uio_in<6> VGND 0.04116f
C2244 uio_in<7> VGND 0.04165f
C2245 uio_oe<0> VGND 0.03014f
C2246 uio_oe<1> VGND 0.03204f
C2247 uio_oe<2> VGND 0.03183f
C2248 uio_oe<3> VGND 0.03204f
C2249 uio_oe<4> VGND 0.03199f
C2250 uio_oe<5> VGND 0.03187f
C2251 uio_oe<6> VGND 0.03187f
C2252 uio_oe<7> VGND 0.05938f
C2253 uio_out<0> VGND 1.6092f
C2254 uio_out<1> VGND 2.43038f
C2255 uio_out<2> VGND 3.78671f
C2256 uio_out<3> VGND 5.0547f
C2257 uio_out<4> VGND 4.75193f
C2258 uio_out<5> VGND 3.50786f
C2259 uio_out<6> VGND 3.90776f
C2260 uio_out<7> VGND 6.16845f
C2261 uo_out<0> VGND 17.1597f
C2262 uo_out<1> VGND 4.95754f
C2263 uo_out<2> VGND 0.04053f
C2264 uo_out<3> VGND 0.03985f
C2265 uo_out<4> VGND 0.04018f
C2266 uo_out<5> VGND 0.03587f
C2267 uo_out<6> VGND 0.04051f
C2268 uo_out<7> VGND 0.03921f
C2269 a_10082_13154# a_10514_13154# 0.21349f
C2270 a_9650_13154# a_10082_13154# 0.21349f
C2271 digital_0._069_.A a_10137_4838# 0.01183f
C2272 a_10137_4838# digital_0._108_.RESET_B 0.15265f
C2273 digital_0._116_.Q a_10137_4838# 0.09992f
C2274 digital_0.load_slew15.A a_10137_4838# 0.11178f
C2275 a_9382_2680# a_10140_2778# 0.06418f
C2276 a_9421_2554# a_10140_2778# 0.08813f
C2277 a_9577_2649# a_10140_2778# 0.04983f
C2278 digital_0._060_.A_N a_10140_2778# 0.01017f
C2279 digital_0._114_.D a_10140_2778# 0.17109f
C2280 a_10196_6904# a_10628_6904# 0.14233f
C2281 a_9764_6904# a_10196_6904# 0.14233f
C2282 a_10196_6904# uio_out<2> 0.02936f
C2283 a_10196_6904# uio_out<4> 0.03877f
C2284 a_10196_6904# uio_out<5> 0.02173f
C2285 a_10196_6904# uio_out<7> 0.01544f
C2286 a_10298_11234# a_10730_11234# 0.14233f
C2287 a_9866_11234# a_10298_11234# 0.14233f
C2288 a_10298_11234# uio_out<5> 0.01961f
C2289 a_10298_11234# uio_out<7> 0.01879f
C2290 a_9980_8824# a_10412_8824# 0.21349f
C2291 a_10412_8824# uio_out<5> 0.03194f
C2292 a_10412_8824# uio_out<7> 0.01279f
C2293 a_10420_1842# a_10420_1298# 0.01212f
C2294 a_10420_1298# a_10546_1482# 0.34134f
C2295 a_9862_1690# a_10420_1298# 0.01329f
C2296 digital_0.hold28.A a_10420_1298# 0.05519f
C2297 a_10420_1298# uio_out<7> 0.12605f
C2298 a_10420_1842# a_10546_2106# 0.34134f
C2299 a_10420_1842# digital_0._107_.RESET_B 0.04501f
C2300 digital_0.clkload0.A a_10420_1842# 0.04768f
C2301 digital_0.input2.X a_10420_1842# 0.09274f
C2302 digital_0.load_slew15.X a_10420_1842# 0.03838f
C2303 a_10472_20216# a_10472_19784# 0.14233f
C2304 a_10472_19784# a_8552_19568# 0.01515f
C2305 a_10472_19784# uio_out<4> 0.01227f
C2306 a_10472_19784# uio_out<5> 0.0252f
C2307 a_8552_20648# a_10472_20216# 0.01515f
C2308 a_10472_20216# uio_out<4> 0.01227f
C2309 a_10472_20216# uio_out<5> 0.02761f
C2310 a_10514_13154# uio_out<5> 0.02225f
C2311 a_10546_2106# a_10546_1482# 0.02141f
C2312 a_10546_1482# a_10786_1298# 0.11296f
C2313 digital_0.hold28.A a_10546_1482# 0.05586f
C2314 a_10546_1482# uio_out<7> 0.04345f
C2315 a_10546_2106# a_10786_1842# 0.11296f
C2316 a_10546_2106# digital_0._107_.RESET_B 0.04795f
C2317 digital_0.clkload0.A a_10546_2106# 0.04945f
C2318 a_10628_6904# a_11060_6904# 0.01515f
C2319 a_10628_6904# uio_out<2> 0.0295f
C2320 a_10628_6904# uio_out<4> 0.05197f
C2321 a_10628_6904# uio_out<5> 0.01653f
C2322 a_10657_4562# a_10944_4840# 0.23366f
C2323 a_10657_4562# a_11222_4856# 0.04176f
C2324 a_10657_4562# a_11261_4730# 0.04359f
C2325 a_10657_4562# clk 0.02838f
C2326 digital_0._069_.A a_10657_4562# 0.07637f
C2327 digital_0._109_.Q a_10657_4562# 0.10309f
C2328 digital_0._109_.RESET_B a_10657_4562# 0.27859f
C2329 digital_0.load_slew15.A a_10657_4562# 0.01629f
C2330 digital_0.load_slew15.X a_10657_4562# 0.0302f
C2331 a_10730_11234# a_11162_11234# 0.01515f
C2332 a_10730_11234# uio_out<4> 0.02119f
C2333 a_10730_11234# uio_out<5> 0.01779f
C2334 a_10786_1842# a_10786_1298# 0.02031f
C2335 digital_0.hold28.A a_10786_1298# 0.07922f
C2336 digital_0.output12.A a_10786_1298# 0.18503f
C2337 a_10786_1298# uio_out<7> 0.0447f
C2338 a_10786_1842# digital_0._107_.RESET_B 0.05303f
C2339 digital_0.clkload0.A a_10786_1842# 0.0679f
C2340 a_10786_1842# ui_in<0> 0.20084f
C2341 a_10841_2386# a_11128_2664# 0.23366f
C2342 a_10841_2386# a_11406_2680# 0.04251f
C2343 a_10841_2386# a_11445_2554# 0.04359f
C2344 digital_0._115_.Q a_10841_2386# 0.16858f
C2345 digital_0._115_.RESET_B a_10841_2386# 0.2717f
C2346 digital_0.input1.X a_10841_2386# 0.05806f
C2347 a_10841_2386# ui_in<0> 0.0489f
C2348 a_10861_3474# a_11416_3500# 0.01896f
C2349 digital_0._116_.Q a_10861_3474# 0.02437f
C2350 a_10861_3474# digital_0.clkbuf_1_1__f_clk.A 0.081f
C2351 digital_0.load_slew15.A a_10861_3474# 0.23464f
C2352 digital_0.load_slew15.X a_10861_3474# 0.22875f
C2353 a_10944_4840# a_11222_4856# 0.11669f
C2354 a_10944_4840# a_11261_4730# 0.10236f
C2355 a_10944_4840# a_11348_4954# 0.05116f
C2356 a_10944_4840# clk 0.01477f
C2357 digital_0._069_.A a_10944_4840# 0.08736f
C2358 digital_0._109_.RESET_B a_10944_4840# 0.23165f
C2359 digital_0.load_slew15.X a_10944_4840# 0.01651f
C2360 a_11060_6904# uio_out<2> 0.02018f
C2361 a_11060_6904# uio_out<4> 0.0172f
C2362 a_11060_6904# uio_out<6> 0.01521f
C2363 a_11128_2664# a_11406_2680# 0.11876f
C2364 a_11128_2664# a_11445_2554# 0.10236f
C2365 a_11128_2664# a_11532_2778# 0.05116f
C2366 digital_0._115_.Q a_11128_2664# 0.04301f
C2367 digital_0._115_.RESET_B a_11128_2664# 0.2207f
C2368 digital_0.hold28.A a_11128_2664# 0.0176f
C2369 digital_0.input1.X a_11128_2664# 0.05798f
C2370 a_11128_2664# ui_in<0> 0.02017f
C2371 a_11149_1874# a_11315_1874# 0.87924f
C2372 a_11149_1874# a_11570_2234# 0.08638f
C2373 a_11149_1874# a_11665_2246# 0.10748f
C2374 a_11149_1874# a_11883_1842# 0.07009f
C2375 a_11149_1874# a_12230_2246# 0.10236f
C2376 a_11149_1874# a_12405_2172# 0.04359f
C2377 a_11149_1874# digital_0._107_.D 0.16641f
C2378 a_11149_1874# digital_0._107_.RESET_B 0.66441f
C2379 digital_0._115_.Q a_11149_1874# 0.03603f
C2380 digital_0.clkload0.A a_11149_1874# 0.2453f
C2381 digital_0.hold28.A a_11149_1874# 0.03327f
C2382 a_11149_1874# ui_in<0> 0.02292f
C2383 a_11149_1874# uio_out<7> 0.01497f
C2384 a_11234_3276# a_11149_2956# 0.15745f
C2385 a_11149_2956# a_11592_2956# 0.02665f
C2386 digital_0._060_.A_N a_11149_2956# 0.07193f
C2387 digital_0._115_.Q a_11149_2956# 0.03064f
C2388 digital_0.hold28.A a_11149_2956# 0.01254f
C2389 digital_0.input2.X a_11149_2956# 0.01419f
C2390 a_11162_11234# uio_out<4> 0.01987f
C2391 a_11162_11234# uio_out<6> 0.01981f
C2392 a_11261_4730# a_11209_4018# 0.0117f
C2393 a_11209_4018# a_11496_4176# 0.23366f
C2394 a_11209_4018# a_11774_4160# 0.04251f
C2395 a_11209_4018# a_11813_4286# 0.04359f
C2396 digital_0._108_.Q a_11209_4018# 0.14941f
C2397 digital_0._108_.RESET_B a_11209_4018# 0.31857f
C2398 digital_0.input1.X a_11209_4018# 0.06177f
C2399 a_11222_4856# a_11261_4730# 0.85951f
C2400 a_11222_4856# a_11348_4954# 0.18122f
C2401 a_11222_4856# a_11417_4825# 0.21686f
C2402 a_11222_4856# a_11562_4954# 0.02761f
C2403 a_11222_4856# a_11980_4954# 0.05562f
C2404 a_11222_4856# clk 0.05579f
C2405 digital_0._069_.A a_11222_4856# 0.57366f
C2406 digital_0._108_.Q a_11222_4856# 0.05336f
C2407 digital_0._109_.D a_11222_4856# 0.31112f
C2408 digital_0._109_.RESET_B a_11222_4856# 0.05867f
C2409 digital_0.output13.A a_11222_4856# 0.01416f
C2410 a_11416_3500# a_11234_3276# 0.01392f
C2411 a_11234_3276# a_11592_2956# 0.27101f
C2412 a_11234_3276# a_11592_3276# 0.01892f
C2413 digital_0._060_.A_N a_11234_3276# 0.25649f
C2414 a_11234_3276# digital_0._115_.D 0.19915f
C2415 digital_0._115_.Q a_11234_3276# 0.42751f
C2416 digital_0._115_.RESET_B a_11234_3276# 0.01615f
C2417 digital_0.hold28.A a_11234_3276# 0.07444f
C2418 digital_0.input2.X a_11234_3276# 0.02385f
C2419 digital_0.load_slew17.X a_11234_3276# 0.02391f
C2420 a_11257_5926# a_11793_5926# 0.03302f
C2421 a_11257_5926# digital_0._109_.RESET_B 0.15333f
C2422 digital_0._116_.Q a_11257_5926# 0.09861f
C2423 digital_0.load_slew15.A a_11257_5926# 0.05053f
C2424 a_11257_5926# uio_out<7> 0.01161f
C2425 a_11261_4730# a_11348_4954# 0.07009f
C2426 a_11261_4730# a_11417_4825# 0.1152f
C2427 a_11261_4730# a_11980_4954# 0.0858f
C2428 a_11261_4730# clk 0.04809f
C2429 digital_0._069_.A a_11261_4730# 0.06108f
C2430 digital_0._108_.Q a_11261_4730# 0.20914f
C2431 digital_0._109_.D a_11261_4730# 0.21624f
C2432 digital_0._109_.RESET_B a_11261_4730# 0.3316f
C2433 digital_0.input1.X a_11261_4730# 0.257f
C2434 digital_0.output13.A a_11261_4730# 0.03125f
C2435 a_11315_1874# a_11570_2234# 0.06418f
C2436 a_11315_1874# a_11665_2246# 0.2298f
C2437 a_11315_1874# a_11773_1868# 0.03462f
C2438 a_11315_1874# a_11883_1842# 0.18639f
C2439 a_11315_1874# a_12230_2246# 0.12532f
C2440 a_11315_1874# a_12405_2172# 0.04251f
C2441 digital_0._107_.D a_11315_1874# 0.27543f
C2442 a_11315_1874# digital_0._107_.RESET_B 0.05444f
C2443 digital_0._115_.Q a_11315_1874# 0.04244f
C2444 digital_0.hold28.A a_11315_1874# 0.02877f
C2445 a_11318_16986# a_11318_16728# 0.05264f
C2446 a_11417_4825# a_11348_4954# 0.20964f
C2447 a_11348_4954# a_11562_4954# 0.09774f
C2448 a_11348_4954# clk 0.01451f
C2449 digital_0._069_.A a_11348_4954# 0.02093f
C2450 digital_0._109_.RESET_B a_11348_4954# 0.18284f
C2451 a_11406_2680# a_11445_2554# 0.88744f
C2452 a_11406_2680# a_11532_2778# 0.18122f
C2453 a_11406_2680# a_11601_2649# 0.21686f
C2454 a_11406_2680# a_11746_2778# 0.02761f
C2455 a_11406_2680# a_12164_2778# 0.05936f
C2456 digital_0._115_.D a_11406_2680# 0.2732f
C2457 digital_0._115_.Q a_11406_2680# 0.03003f
C2458 digital_0._115_.RESET_B a_11406_2680# 0.05004f
C2459 digital_0.hold28.A a_11406_2680# 0.03561f
C2460 digital_0.input1.X a_11406_2680# 0.55733f
C2461 a_11406_2680# ui_in<0> 0.05784f
C2462 a_11774_4160# a_11416_3500# 0.02009f
C2463 a_11813_4286# a_11416_3500# 0.0213f
C2464 a_11969_4018# a_11416_3500# 0.01141f
C2465 a_11416_3500# a_12367_2956# 0.02203f
C2466 a_11416_3500# a_12603_2956# 0.02551f
C2467 a_11416_3500# a_12709_2956# 0.01183f
C2468 a_11416_3500# digital_0._060_.A_N 0.02403f
C2469 digital_0._108_.D a_11416_3500# 0.01566f
C2470 digital_0._108_.RESET_B a_11416_3500# 0.01182f
C2471 a_11416_3500# digital_0._115_.Q 0.01213f
C2472 a_11416_3500# digital_0._115_.RESET_B 0.1198f
C2473 digital_0._116_.Q a_11416_3500# 0.10023f
C2474 digital_0.clkbuf_1_0__f_clk.X a_11416_3500# 1.62377f
C2475 digital_0.clkbuf_1_1__f_clk.A a_11416_3500# 0.33032f
C2476 digital_0.hold28.A a_11416_3500# 0.07006f
C2477 digital_0.input1.X a_11416_3500# 0.05359f
C2478 digital_0.load_slew15.X a_11416_3500# 0.01128f
C2479 digital_0.load_slew17.X a_11416_3500# 0.02845f
C2480 digital_0.output6.A a_11416_3500# 0.02082f
C2481 a_11416_3500# uio_out<7> 0.01171f
C2482 a_11417_4825# a_11562_4954# 0.05722f
C2483 a_11417_4825# a_11727_4588# 0.01379f
C2484 a_11417_4825# a_11980_4954# 0.04983f
C2485 a_11417_4825# clk 0.0127f
C2486 digital_0._069_.A a_11417_4825# 0.03092f
C2487 digital_0._108_.Q a_11417_4825# 0.01667f
C2488 digital_0._109_.RESET_B a_11417_4825# 0.16304f
C2489 a_11433_5132# a_12069_5132# 0.03064f
C2490 a_12154_5452# a_11433_5132# 0.01166f
C2491 digital_0._069_.B a_11433_5132# 0.0939f
C2492 digital_0._108_.Q a_11433_5132# 0.19481f
C2493 digital_0._109_.Q a_11433_5132# 0.15831f
C2494 digital_0._109_.RESET_B a_11433_5132# 0.0171f
C2495 digital_0.output13.A a_11433_5132# 0.02555f
C2496 a_11445_2554# a_11532_2778# 0.07009f
C2497 a_11445_2554# a_11601_2649# 0.11535f
C2498 a_11445_2554# a_12164_2778# 0.09313f
C2499 a_12367_2956# a_11445_2554# 0.01002f
C2500 a_11445_2554# a_12919_2412# 0.02525f
C2501 digital_0._115_.D a_11445_2554# 0.17271f
C2502 digital_0._115_.Q a_11445_2554# 0.02557f
C2503 digital_0._115_.RESET_B a_11445_2554# 0.32383f
C2504 digital_0.hold28.A a_11445_2554# 0.02955f
C2505 digital_0.input1.X a_11445_2554# 0.32439f
C2506 a_11445_2554# ui_in<0> 0.05158f
C2507 digital_0._107_.D a_11467_1651# 0.02881f
C2508 digital_0._115_.Q a_11467_1651# 0.10048f
C2509 a_11467_1651# digital_0.hold26.X 0.04056f
C2510 digital_0.hold28.A a_11467_1651# 0.23801f
C2511 digital_0.output12.A a_11467_1651# 0.05081f
C2512 a_11467_1651# uio_out<7> 0.02399f
C2513 a_11496_4176# a_11774_4160# 0.12532f
C2514 a_11496_4176# a_11813_4286# 0.10236f
C2515 a_11496_4176# a_11900_4044# 0.05116f
C2516 digital_0._108_.Q a_11496_4176# 0.04376f
C2517 digital_0._108_.RESET_B a_11496_4176# 0.21671f
C2518 digital_0.input1.X a_11496_4176# 0.0583f
C2519 a_11601_2649# a_11532_2778# 0.20964f
C2520 a_11532_2778# a_11746_2778# 0.09774f
C2521 digital_0._115_.Q a_11532_2778# 0.03672f
C2522 digital_0._115_.RESET_B a_11532_2778# 0.16793f
C2523 digital_0.input1.X a_11532_2778# 0.01907f
C2524 a_11532_2778# ui_in<0> 0.01316f
C2525 digital_0._069_.A a_11562_4954# 0.02672f
C2526 digital_0._109_.RESET_B a_11562_4954# 0.0167f
C2527 a_11665_2246# a_11570_2234# 0.04983f
C2528 digital_0._107_.D a_11570_2234# 0.15794f
C2529 digital_0._107_.RESET_B a_11570_2234# 0.01778f
C2530 digital_0.hold28.A a_11570_2234# 0.01372f
C2531 a_12367_2956# a_11592_2956# 0.02816f
C2532 digital_0._060_.A_N a_11592_2956# 0.02998f
C2533 digital_0._115_.D a_11592_2956# 0.12848f
C2534 digital_0._115_.Q a_11592_2956# 0.03928f
C2535 digital_0._115_.RESET_B a_11592_2956# 0.0164f
C2536 digital_0.hold28.A a_11592_2956# 0.12518f
C2537 digital_0.input2.X a_11592_2956# 0.01707f
C2538 digital_0._060_.A_N a_11592_3276# 0.05172f
C2539 a_11592_3276# digital_0._115_.D 0.08512f
C2540 digital_0._115_.Q a_11592_3276# 0.10697f
C2541 digital_0._115_.RESET_B a_11592_3276# 0.01688f
C2542 a_11601_2649# a_11746_2778# 0.05722f
C2543 a_11601_2649# a_11911_2412# 0.01379f
C2544 a_11601_2649# a_12164_2778# 0.04983f
C2545 digital_0._115_.Q a_11601_2649# 0.01744f
C2546 digital_0._115_.RESET_B a_11601_2649# 0.16061f
C2547 digital_0.input1.X a_11601_2649# 0.03134f
C2548 a_11601_2649# ui_in<0> 0.0122f
C2549 a_11665_2246# a_11761_2246# 0.01379f
C2550 a_11665_2246# a_11773_1868# 0.05722f
C2551 a_11883_1842# a_11665_2246# 0.20964f
C2552 digital_0._107_.RESET_B a_11665_2246# 0.17382f
C2553 digital_0._115_.Q a_11665_2246# 0.02148f
C2554 a_11721_1651# a_12323_1476# 0.01569f
C2555 digital_0._107_.D a_11721_1651# 0.11551f
C2556 digital_0._115_.Q a_11721_1651# 0.19457f
C2557 a_11721_1651# digital_0.hold26.X 0.11101f
C2558 digital_0.hold28.A a_11721_1651# 0.31818f
C2559 digital_0.output12.A a_11721_1651# 0.03686f
C2560 digital_0._115_.RESET_B a_11746_2778# 0.01838f
C2561 digital_0.input1.X a_11746_2778# 0.02646f
C2562 a_11883_1842# a_11773_1868# 0.09774f
C2563 digital_0._107_.RESET_B a_11773_1868# 0.0122f
C2564 a_11813_4286# a_11774_4160# 0.57945f
C2565 a_11774_4160# a_11900_4044# 0.17589f
C2566 a_11774_4160# a_11969_4018# 0.21907f
C2567 a_11774_4160# a_12114_4044# 0.03462f
C2568 a_11774_4160# a_12532_4044# 0.06121f
C2569 digital_0._069_.A a_11774_4160# 0.01885f
C2570 digital_0._108_.D a_11774_4160# 0.20518f
C2571 digital_0._108_.RESET_B a_11774_4160# 0.02352f
C2572 digital_0.hold28.A a_11774_4160# 0.02569f
C2573 digital_0.input1.X a_11774_4160# 0.66507f
C2574 a_11774_4160# digital_0.output6.A 0.11064f
C2575 digital_0._069_.A a_11793_5926# 0.10637f
C2576 digital_0._069_.B a_11793_5926# 0.0498f
C2577 a_11793_5926# digital_0._109_.D 0.15276f
C2578 a_11813_4286# a_11900_4044# 0.05348f
C2579 a_11813_4286# a_11969_4018# 0.11025f
C2580 a_11813_4286# a_12532_4044# 0.08657f
C2581 a_11813_4286# clk 0.01012f
C2582 digital_0._069_.A a_11813_4286# 0.20455f
C2583 digital_0._108_.D a_11813_4286# 0.1615f
C2584 digital_0._108_.Q a_11813_4286# 0.01107f
C2585 digital_0._108_.RESET_B a_11813_4286# 0.29526f
C2586 digital_0.hold28.A a_11813_4286# 0.03836f
C2587 digital_0.input1.X a_11813_4286# 0.88302f
C2588 a_11813_4286# digital_0.output6.A 0.03742f
C2589 a_11883_1842# a_12230_2246# 0.05116f
C2590 a_11883_1842# digital_0._107_.RESET_B 0.16649f
C2591 a_11969_4018# a_11900_4044# 0.20964f
C2592 a_11900_4044# a_12114_4044# 0.09774f
C2593 digital_0._108_.Q a_11900_4044# 0.0176f
C2594 digital_0._108_.RESET_B a_11900_4044# 0.16185f
C2595 digital_0.input1.X a_11900_4044# 0.04904f
C2596 a_11969_4018# a_12114_4044# 0.05722f
C2597 a_11969_4018# a_12279_4410# 0.01379f
C2598 a_11969_4018# a_12532_4044# 0.04983f
C2599 digital_0._108_.RESET_B a_11969_4018# 0.15327f
C2600 digital_0._109_.D a_11969_4018# 0.01073f
C2601 digital_0.input1.X a_11969_4018# 0.0523f
C2602 digital_0._069_.A a_11980_4954# 0.01733f
C2603 digital_0._108_.Q a_11980_4954# 0.03535f
C2604 digital_0._109_.D a_11980_4954# 0.16937f
C2605 a_12154_5452# a_12069_5132# 0.142f
C2606 a_12069_5132# a_12512_5132# 0.02551f
C2607 digital_0._108_.Q a_12069_5132# 0.025f
C2608 digital_0._109_.D a_12069_5132# 0.02492f
C2609 digital_0._109_.Q a_12069_5132# 0.16825f
C2610 digital_0.output13.A a_12069_5132# 0.03096f
C2611 digital_0._108_.RESET_B a_12114_4044# 0.0122f
C2612 a_12154_5452# a_12512_5132# 0.27101f
C2613 a_12154_5452# a_12512_5452# 0.01892f
C2614 digital_0._069_.A a_12154_5452# 0.01502f
C2615 a_12154_5452# digital_0._108_.D 0.22729f
C2616 digital_0._108_.Q a_12154_5452# 0.27639f
C2617 digital_0._109_.D a_12154_5452# 0.01436f
C2618 digital_0._109_.Q a_12154_5452# 0.06913f
C2619 digital_0.load_slew15.X a_12154_5452# 0.11514f
C2620 digital_0.output13.A a_12154_5452# 0.42579f
C2621 digital_0._115_.D a_12164_2778# 0.16052f
C2622 digital_0.input1.X a_12164_2778# 0.01824f
C2623 a_12405_2172# a_12230_2246# 0.23366f
C2624 digital_0._107_.RESET_B a_12230_2246# 0.2366f
C2625 digital_0.input1.X a_12230_2246# 0.024f
C2626 a_12323_1476# a_12419_1298# 0.41909f
C2627 a_12323_1476# digital_0.hold26.X 0.13552f
C2628 digital_0.input1.X a_12323_1476# 0.01254f
C2629 digital_0.output12.A a_12323_1476# 0.06985f
C2630 a_12367_2956# a_12603_2956# 0.22264f
C2631 a_12367_2956# digital_0._115_.D 0.03034f
C2632 digital_0.hold28.A a_12367_2956# 0.35896f
C2633 digital_0.input1.X a_12367_2956# 0.03798f
C2634 a_12405_2172# a_12419_1298# 0.01412f
C2635 digital_0._107_.RESET_B a_12405_2172# 0.27892f
C2636 digital_0.input1.X a_12405_2172# 0.03252f
C2637 digital_0.load_slew15.X a_12405_2172# 0.01065f
C2638 a_12405_2172# digital_0.output12.A 0.12593f
C2639 a_12405_2172# ui_in<0> 0.01036f
C2640 a_12419_1298# a_12677_1298# 0.22264f
C2641 digital_0.input1.X a_12419_1298# 0.03886f
C2642 digital_0.output12.A a_12419_1298# 0.10114f
C2643 a_12419_1298# uo_out<0> 0.03656f
C2644 digital_0._069_.A a_12512_5132# 0.01076f
C2645 digital_0._108_.D a_12512_5132# 0.19159f
C2646 digital_0._108_.Q a_12512_5132# 0.03666f
C2647 digital_0._109_.Q a_12512_5132# 0.12604f
C2648 digital_0.output13.A a_12512_5132# 0.03156f
C2649 digital_0._069_.A a_12512_5452# 0.01228f
C2650 a_12512_5452# digital_0._108_.D 0.08622f
C2651 digital_0._108_.Q a_12512_5452# 0.02841f
C2652 digital_0.load_slew15.X a_12512_5452# 0.05464f
C2653 digital_0.output13.A a_12512_5452# 0.10609f
C2654 digital_0._069_.A a_12532_4044# 0.02907f
C2655 digital_0._108_.D a_12532_4044# 0.15797f
C2656 digital_0.hold28.A a_12532_4044# 0.01088f
C2657 digital_0.input1.X a_12532_4044# 0.01933f
C2658 a_12603_2956# a_12709_2956# 0.41909f
C2659 digital_0.hold28.A a_12603_2956# 0.06312f
C2660 digital_0.input1.X a_12603_2956# 0.02391f
C2661 digital_0.input2.X a_12603_2956# 0.01481f
C2662 digital_0.load_slew17.X a_12603_2956# 0.01529f
C2663 digital_0.output6.A a_12603_2956# 0.02703f
C2664 digital_0._116_.D a_12677_1298# 0.01657f
C2665 digital_0.input1.X a_12677_1298# 0.05261f
C2666 digital_0.output12.A a_12677_1298# 0.32309f
C2667 a_12677_1298# uo_out<0> 0.05226f
C2668 a_12688_16988# a_12688_16728# 0.05215f
C2669 a_12709_2956# a_13141_2930# 0.01491f
C2670 a_12709_2956# digital_0.hold28.X 0.13591f
C2671 digital_0.input2.X a_12709_2956# 0.01252f
C2672 digital_0.load_slew17.X a_12709_2956# 0.01406f
C2673 digital_0.output6.A a_12709_2956# 0.03182f
C2674 a_12847_4915# clk 0.01109f
C2675 digital_0._108_.D a_12847_4915# 0.01251f
C2676 digital_0._108_.Q a_12847_4915# 0.1333f
C2677 digital_0.hold25.X a_12847_4915# 0.03829f
C2678 digital_0.hold28.A a_12847_4915# 0.22302f
C2679 digital_0.input1.X a_12847_4915# 0.0576f
C2680 digital_0.output13.A a_12847_4915# 0.03576f
C2681 a_12919_2412# a_13155_2412# 0.22264f
C2682 digital_0._116_.Q a_12919_2412# 0.01249f
C2683 digital_0.output6.A a_12919_2412# 0.29721f
C2684 a_12919_2412# ui_in<0> 0.02115f
C2685 a_13042_1476# a_13348_1574# 0.06801f
C2686 digital_0._116_.D a_13042_1476# 0.20373f
C2687 digital_0._116_.Q a_13042_1476# 0.0434f
C2688 a_13042_1476# digital_0.hold18.X 0.17687f
C2689 digital_0.input1.X a_13042_1476# 0.0517f
C2690 digital_0.output12.A a_13042_1476# 0.0263f
C2691 a_13042_1476# uo_out<0> 0.0686f
C2692 a_13101_4915# clk 0.01812f
C2693 a_13101_4915# digital_0._100_.D 0.08113f
C2694 digital_0._108_.Q a_13101_4915# 0.19177f
C2695 digital_0._109_.Q a_13101_4915# 0.02608f
C2696 digital_0.clkbuf_1_0__f_clk.X a_13101_4915# 0.0136f
C2697 digital_0.hold25.X a_13101_4915# 0.11401f
C2698 digital_0.hold28.A a_13101_4915# 0.31845f
C2699 digital_0.load_slew15.X a_13101_4915# 0.01145f
C2700 digital_0.output13.A a_13101_4915# 0.03854f
C2701 digital_0._069_.A a_13132_4276# 0.13005f
C2702 digital_0._108_.Q a_13132_4276# 0.2103f
C2703 digital_0._109_.Q a_13132_4276# 0.0795f
C2704 digital_0._118_.RESET_B a_13132_4276# 0.01146f
C2705 digital_0.input1.X a_13132_4276# 0.029f
C2706 digital_0.output13.A a_13132_4276# 0.20621f
C2707 a_13132_4276# digital_0.output6.A 0.07057f
C2708 a_13141_2930# a_13428_3088# 0.23366f
C2709 a_13141_2930# a_13706_3072# 0.04182f
C2710 a_13141_2930# a_13745_3198# 0.04359f
C2711 digital_0._116_.Q a_13141_2930# 0.03125f
C2712 digital_0._118_.RESET_B a_13141_2930# 0.27681f
C2713 a_13141_2930# digital_0.hold28.X 0.06227f
C2714 digital_0.input2.X a_13141_2930# 0.01355f
C2715 digital_0.load_slew17.X a_13141_2930# 0.02191f
C2716 digital_0.output13.A a_13141_2930# 0.16783f
C2717 a_13155_2412# a_13261_2412# 0.41909f
C2718 digital_0._116_.Q a_13155_2412# 0.03522f
C2719 digital_0.load_slew15.X a_13155_2412# 0.02179f
C2720 a_13155_2412# ui_in<0> 0.02448f
C2721 digital_0._109_.Q a_13189_3750# 0.04897f
C2722 a_13189_3750# digital_0._115_.RESET_B 0.1524f
C2723 digital_0._116_.Q a_13189_3750# 0.09599f
C2724 digital_0.hold28.A a_13189_3750# 0.0425f
C2725 digital_0.load_slew17.X a_13189_3750# 0.0452f
C2726 digital_0.output13.A a_13189_3750# 0.01672f
C2727 digital_0._116_.Q a_13261_2412# 0.02974f
C2728 digital_0.clkbuf_1_0__f_clk.X a_13261_2412# 0.02045f
C2729 digital_0.hold22.X a_13261_2412# 0.13052f
C2730 digital_0.hold28.X a_13261_2412# 0.02464f
C2731 a_13261_2412# ui_in<0> 0.01682f
C2732 digital_0._080_.A2 a_13348_1574# 0.03996f
C2733 digital_0._116_.D a_13348_1574# 0.02948f
C2734 digital_0._116_.Q a_13348_1574# 0.05027f
C2735 digital_0.hold18.X a_13348_1574# 0.02809f
C2736 digital_0.input1.X a_13348_1574# 0.04141f
C2737 digital_0._116_.Q a_13420_1324# 0.0126f
C2738 a_13428_3088# a_13706_3072# 0.11842f
C2739 a_13428_3088# a_13745_3198# 0.10236f
C2740 a_13428_3088# a_13832_2956# 0.05116f
C2741 a_13428_3088# digital_0._080_.A2 0.04226f
C2742 digital_0._116_.Q a_13428_3088# 0.01394f
C2743 digital_0._118_.RESET_B a_13428_3088# 0.22627f
C2744 a_13428_3088# digital_0.hold28.X 0.01419f
C2745 digital_0.input2.X a_13428_3088# 0.0145f
C2746 digital_0.load_slew15.X a_13428_3088# 0.01564f
C2747 digital_0.output13.A a_13428_3088# 0.04112f
C2748 a_13541_1874# a_13707_1874# 0.57903f
C2749 a_13541_1874# a_13942_1324# 0.01087f
C2750 a_13541_1874# a_13962_2234# 0.08671f
C2751 a_13541_1874# a_14057_2246# 0.10599f
C2752 a_13541_1874# a_14275_1842# 0.05348f
C2753 a_13541_1874# a_14622_2246# 0.10236f
C2754 a_13541_1874# a_14627_1298# 0.01346f
C2755 a_13541_1874# a_14797_2172# 0.04359f
C2756 digital_0._080_.A2 a_13541_1874# 0.03336f
C2757 digital_0._116_.D a_13541_1874# 0.04048f
C2758 digital_0._116_.SET_B a_13541_1874# 0.14997f
C2759 a_13541_1874# digital_0._119_.RESET_B 0.29549f
C2760 digital_0.clkbuf_1_0__f_clk.X a_13541_1874# 0.26295f
C2761 digital_0.hold28.X a_13541_1874# 0.2739f
C2762 digital_0.load_slew15.X a_13541_1874# 0.64569f
C2763 a_13541_1874# ui_in<0> 0.01111f
C2764 a_13725_4588# a_13693_4018# 0.01127f
C2765 a_13693_4018# a_13980_4176# 0.23366f
C2766 a_13693_4018# a_14258_4160# 0.04242f
C2767 a_13693_4018# a_14297_4286# 0.04359f
C2768 digital_0._101_.RESET_B a_13693_4018# 0.33823f
C2769 digital_0.clkbuf_1_0__f_clk.X a_13693_4018# 0.0143f
C2770 digital_0.hold28.A a_13693_4018# 0.02428f
C2771 digital_0.load_slew15.X a_13693_4018# 0.02273f
C2772 digital_0.output13.A a_13693_4018# 0.01895f
C2773 a_13693_4018# digital_0.output6.A 0.14268f
C2774 a_13745_3198# a_13706_3072# 0.8999f
C2775 a_13706_3072# a_13832_2956# 0.18122f
C2776 a_13706_3072# a_13901_2930# 0.21686f
C2777 a_13706_3072# a_14046_2956# 0.02761f
C2778 a_13706_3072# a_14464_2956# 0.05936f
C2779 a_13706_3072# digital_0._080_.A2 0.54622f
C2780 digital_0._118_.D a_13706_3072# 0.22412f
C2781 digital_0._118_.RESET_B a_13706_3072# 0.02494f
C2782 digital_0.clkbuf_1_0__f_clk.X a_13706_3072# 0.01387f
C2783 digital_0.hold22.X a_13706_3072# 0.03825f
C2784 digital_0.input2.X a_13706_3072# 0.05857f
C2785 digital_0.load_slew15.X a_13706_3072# 0.03636f
C2786 digital_0.output13.A a_13706_3072# 0.0224f
C2787 a_13707_1874# a_13962_2234# 0.06121f
C2788 a_13707_1874# a_14057_2246# 0.21963f
C2789 a_13707_1874# a_14165_1868# 0.03462f
C2790 a_13707_1874# a_14275_1842# 0.17589f
C2791 a_13707_1874# a_14622_2246# 0.12532f
C2792 a_13707_1874# a_14797_2172# 0.04251f
C2793 digital_0._080_.A2 a_13707_1874# 0.01547f
C2794 digital_0._116_.D a_13707_1874# 0.04133f
C2795 digital_0._116_.SET_B a_13707_1874# 0.01992f
C2796 a_13707_1874# digital_0._119_.RESET_B 0.02491f
C2797 digital_0.hold28.X a_13707_1874# 0.21957f
C2798 digital_0.load_slew15.X a_13707_1874# 0.6009f
C2799 a_13725_1324# a_13942_1324# 0.11296f
C2800 digital_0._080_.A2 a_13725_1324# 0.0249f
C2801 digital_0._116_.D a_13725_1324# 0.02506f
C2802 digital_0.hold18.X a_13725_1324# 0.05334f
C2803 digital_0.input1.X a_13725_1324# 0.02833f
C2804 a_13725_1324# uo_out<0> 0.20108f
C2805 a_13725_2412# a_13891_2412# 0.55766f
C2806 a_13725_2412# a_14079_2412# 0.06473f
C2807 a_13725_2412# a_14174_2412# 0.20518f
C2808 a_13725_2412# a_14350_2386# 0.18443f
C2809 a_13725_2412# a_14726_2778# 0.18432f
C2810 a_13725_2412# a_14876_2626# 0.06363f
C2811 a_13725_2412# digital_0._116_.D 0.10248f
C2812 a_13725_2412# digital_0._116_.SET_B 0.04315f
C2813 digital_0.clkbuf_1_0__f_clk.X a_13725_2412# 0.80511f
C2814 digital_0.hold22.X a_13725_2412# 0.30264f
C2815 digital_0.load_slew15.X a_13725_2412# 0.04021f
C2816 a_13725_2412# ui_in<0> 0.05995f
C2817 a_13725_4588# a_13891_4588# 0.5826f
C2818 a_13725_4588# a_14146_4588# 0.09016f
C2819 a_13725_4588# a_14241_4588# 0.11082f
C2820 a_13725_4588# a_14459_4830# 0.05348f
C2821 a_13725_4588# a_14806_4588# 0.10236f
C2822 a_13725_4588# a_14981_4562# 0.04359f
C2823 a_13725_4588# clk 0.02654f
C2824 digital_0._100_.D a_13725_4588# 0.24083f
C2825 digital_0._100_.RESET_B a_13725_4588# 0.32537f
C2826 digital_0._101_.RESET_B a_13725_4588# 0.01698f
C2827 digital_0.clkbuf_1_0__f_clk.X a_13725_4588# 0.84952f
C2828 digital_0.hold28.A a_13725_4588# 0.031f
C2829 digital_0.load_slew15.X a_13725_4588# 0.03433f
C2830 a_13745_3198# a_13832_2956# 0.07009f
C2831 a_13745_3198# a_13901_2930# 0.11053f
C2832 a_13745_3198# a_14464_2956# 0.08968f
C2833 a_13745_3198# digital_0._080_.A2 0.05298f
C2834 digital_0._118_.D a_13745_3198# 0.28146f
C2835 digital_0._118_.RESET_B a_13745_3198# 0.29772f
C2836 digital_0.clkbuf_1_0__f_clk.X a_13745_3198# 0.27099f
C2837 digital_0.hold22.X a_13745_3198# 0.03637f
C2838 digital_0.input2.X a_13745_3198# 0.05903f
C2839 digital_0.load_slew15.X a_13745_3198# 0.03052f
C2840 digital_0.output13.A a_13745_3198# 0.15748f
C2841 a_13795_5828# a_13891_5650# 0.41909f
C2842 a_13795_5828# digital_0._100_.RESET_B 0.06915f
C2843 a_13795_5828# digital_0.hold25.X 0.13114f
C2844 digital_0.load_slew15.X a_13795_5828# 0.01599f
C2845 a_13901_2930# a_13832_2956# 0.20964f
C2846 a_13832_2956# a_14046_2956# 0.09774f
C2847 a_13832_2956# digital_0._080_.A2 0.0192f
C2848 digital_0._118_.RESET_B a_13832_2956# 0.15956f
C2849 digital_0.input2.X a_13832_2956# 0.01388f
C2850 digital_0.load_slew15.X a_13832_2956# 0.01295f
C2851 digital_0.output13.A a_13832_2956# 0.02199f
C2852 a_13891_2412# a_14079_2412# 0.15365f
C2853 a_13891_2412# a_14174_2412# 0.2094f
C2854 a_13891_2412# a_14350_2386# 0.07694f
C2855 a_13891_2412# a_14726_2778# 0.05758f
C2856 a_13891_2412# a_14797_2172# 0.01137f
C2857 a_13891_2412# a_14876_2626# 0.07272f
C2858 digital_0._116_.D a_13891_2412# 0.12989f
C2859 a_13891_2412# digital_0._116_.SET_B 0.20931f
C2860 digital_0.clkbuf_1_0__f_clk.X a_13891_2412# 0.37684f
C2861 digital_0.hold22.X a_13891_2412# 0.02056f
C2862 digital_0.load_slew15.X a_13891_2412# 0.01606f
C2863 a_13891_2412# ui_in<0> 0.0269f
C2864 a_13891_4588# a_14146_4588# 0.06121f
C2865 a_13891_4588# a_14241_4588# 0.21963f
C2866 a_13891_4588# a_14349_4954# 0.03462f
C2867 a_13891_4588# a_14459_4830# 0.17589f
C2868 a_13891_4588# a_14806_4588# 0.12532f
C2869 a_13891_4588# a_14981_4562# 0.04251f
C2870 a_13891_4588# clk 0.04028f
C2871 digital_0._100_.D a_13891_4588# 0.22439f
C2872 digital_0._100_.RESET_B a_13891_4588# 0.05687f
C2873 digital_0.clkbuf_1_0__f_clk.X a_13891_4588# 0.58826f
C2874 digital_0.hold28.A a_13891_4588# 0.03581f
C2875 digital_0.load_slew15.X a_13891_4588# 0.01351f
C2876 a_13891_5650# a_13969_5106# 0.01164f
C2877 a_13891_5650# a_14149_5650# 0.22264f
C2878 a_13891_5650# digital_0._100_.RESET_B 0.08202f
C2879 a_13891_5650# digital_0.hold25.X 0.01066f
C2880 a_13891_5650# uio_out<3> 0.01103f
C2881 a_13901_2930# a_14046_2956# 0.05722f
C2882 a_13901_2930# a_14211_3322# 0.01379f
C2883 a_13901_2930# a_14464_2956# 0.04983f
C2884 a_13901_2930# digital_0._080_.A2 0.02998f
C2885 digital_0._118_.RESET_B a_13901_2930# 0.15235f
C2886 digital_0.hold22.X a_13901_2930# 0.02302f
C2887 digital_0.input2.X a_13901_2930# 0.01082f
C2888 digital_0.output13.A a_13901_2930# 0.03568f
C2889 a_13942_1324# a_14053_1324# 0.34134f
C2890 digital_0._116_.D a_13942_1324# 0.03341f
C2891 digital_0.hold18.X a_13942_1324# 0.04152f
C2892 digital_0.input1.X a_13942_1324# 0.02675f
C2893 a_13942_1324# uo_out<0> 0.01202f
C2894 digital_0._109_.Q a_13951_3827# 0.13541f
C2895 digital_0._116_.Q a_13951_3827# 0.04967f
C2896 digital_0.clkbuf_1_0__f_clk.X a_13951_3827# 0.04734f
C2897 a_13951_3827# digital_0.hold22.X 0.03965f
C2898 digital_0.hold28.A a_13951_3827# 0.23278f
C2899 digital_0.load_slew15.X a_13951_3827# 0.0143f
C2900 a_14057_2246# a_13962_2234# 0.04983f
C2901 digital_0._116_.SET_B a_13962_2234# 0.02506f
C2902 digital_0.hold28.X a_13962_2234# 0.15761f
C2903 digital_0.load_slew15.X a_13962_2234# 0.01888f
C2904 a_13969_5106# a_14256_5264# 0.23366f
C2905 a_13969_5106# a_14459_4830# 0.0119f
C2906 a_13969_5106# a_14534_5248# 0.04251f
C2907 a_13969_5106# a_14573_5374# 0.04359f
C2908 a_13969_5106# clk 0.01885f
C2909 digital_0._100_.RESET_B a_13969_5106# 0.02119f
C2910 digital_0._117_.RESET_B a_13969_5106# 0.34077f
C2911 digital_0.hold28.A a_13969_5106# 0.10128f
C2912 digital_0.load_slew15.X a_13969_5106# 0.02484f
C2913 a_13980_4176# a_14258_4160# 0.11876f
C2914 a_13980_4176# a_14297_4286# 0.10236f
C2915 a_13980_4176# a_14384_4044# 0.05116f
C2916 digital_0._101_.RESET_B a_13980_4176# 0.24076f
C2917 digital_0.hold28.A a_13980_4176# 0.02285f
C2918 a_13980_4176# digital_0.output6.A 0.0553f
C2919 digital_0._080_.A2 a_14046_2956# 0.02662f
C2920 digital_0._118_.RESET_B a_14046_2956# 0.0122f
C2921 a_14275_1842# a_14053_1324# 0.01068f
C2922 a_14053_1324# a_14531_1476# 0.01251f
C2923 digital_0._116_.D a_14053_1324# 0.01954f
C2924 digital_0.hold18.X a_14053_1324# 0.05247f
C2925 digital_0.input1.X a_14053_1324# 0.11328f
C2926 a_14057_2246# a_14153_2246# 0.01379f
C2927 a_14057_2246# a_14165_1868# 0.05722f
C2928 a_14275_1842# a_14057_2246# 0.20964f
C2929 digital_0._116_.D a_14057_2246# 0.01864f
C2930 digital_0._116_.SET_B a_14057_2246# 0.04178f
C2931 digital_0._119_.RESET_B a_14057_2246# 0.15235f
C2932 digital_0.load_slew15.X a_14057_2246# 0.0342f
C2933 a_14174_2412# a_14079_2412# 0.03558f
C2934 digital_0._116_.D a_14079_2412# 0.15108f
C2935 digital_0.clkbuf_1_0__f_clk.X a_14079_2412# 0.01624f
C2936 digital_0.hold22.X a_14079_2412# 0.01608f
C2937 a_14241_4588# a_14146_4588# 0.04983f
C2938 digital_0._100_.D a_14146_4588# 0.16221f
C2939 digital_0.clkbuf_1_0__f_clk.X a_14146_4588# 0.01376f
C2940 a_14149_5650# a_14553_5676# 0.0425f
C2941 a_14149_5650# digital_0._100_.RESET_B 0.06405f
C2942 a_14149_5650# digital_0.output5.A 0.2875f
C2943 a_14275_1842# a_14165_1868# 0.09774f
C2944 digital_0._119_.RESET_B a_14165_1868# 0.0122f
C2945 a_14350_2386# a_14174_2412# 0.25769f
C2946 digital_0._116_.SET_B a_14174_2412# 0.21194f
C2947 digital_0._118_.D a_14174_2412# 0.01235f
C2948 digital_0.clkbuf_1_0__f_clk.X a_14174_2412# 0.04855f
C2949 digital_0.hold22.X a_14174_2412# 0.03025f
C2950 a_14174_2412# ui_in<0> 0.01523f
C2951 digital_0._101_.D a_14205_3827# 0.08082f
C2952 digital_0._109_.Q a_14205_3827# 0.19077f
C2953 digital_0._116_.Q a_14205_3827# 0.04067f
C2954 digital_0.clkbuf_1_0__f_clk.X a_14205_3827# 0.05431f
C2955 a_14205_3827# digital_0.hold22.X 0.06567f
C2956 digital_0.hold28.A a_14205_3827# 0.32286f
C2957 digital_0.output13.A a_14205_3827# 0.01941f
C2958 a_14241_4588# a_14337_4588# 0.01379f
C2959 a_14241_4588# a_14349_4954# 0.05722f
C2960 a_14459_4830# a_14241_4588# 0.20964f
C2961 a_14241_4588# clk 0.01275f
C2962 digital_0._100_.RESET_B a_14241_4588# 0.16654f
C2963 digital_0.clkbuf_1_0__f_clk.X a_14241_4588# 0.03349f
C2964 a_14256_5264# a_14534_5248# 0.12532f
C2965 a_14256_5264# a_14573_5374# 0.10236f
C2966 a_14256_5264# a_14660_5132# 0.05116f
C2967 a_14256_5264# clk 0.0141f
C2968 digital_0._100_.RESET_B a_14256_5264# 0.02939f
C2969 digital_0._117_.RESET_B a_14256_5264# 0.24269f
C2970 a_14297_4286# a_14258_4160# 0.72353f
C2971 a_14258_4160# a_14384_4044# 0.17513f
C2972 a_14258_4160# a_14453_4018# 0.20984f
C2973 a_14258_4160# a_14598_4044# 0.02761f
C2974 a_14258_4160# a_15016_4044# 0.05639f
C2975 a_14258_4160# digital_0._101_.D 0.56437f
C2976 digital_0._101_.RESET_B a_14258_4160# 0.02526f
C2977 digital_0.output4.A a_14258_4160# 0.03374f
C2978 a_14258_4160# digital_0.output6.A 0.5521f
C2979 a_14275_1842# a_14622_2246# 0.05116f
C2980 digital_0._116_.SET_B a_14275_1842# 0.01389f
C2981 a_14275_1842# digital_0._119_.RESET_B 0.16487f
C2982 digital_0.load_slew15.X a_14275_1842# 0.04311f
C2983 a_14297_4286# a_14384_4044# 0.06225f
C2984 a_14297_4286# a_14453_4018# 0.11238f
C2985 a_14297_4286# a_14759_3500# 0.0112f
C2986 a_14981_4562# a_14297_4286# 0.01127f
C2987 a_14297_4286# a_15016_4044# 0.09016f
C2988 a_14297_4286# digital_0._101_.D 0.45211f
C2989 digital_0._101_.RESET_B a_14297_4286# 0.29551f
C2990 digital_0.clkbuf_1_0__f_clk.X a_14297_4286# 0.26359f
C2991 digital_0.hold19.X a_14297_4286# 0.03043f
C2992 digital_0.output4.A a_14297_4286# 0.03999f
C2993 a_14297_4286# digital_0.output6.A 0.03779f
C2994 a_14459_4830# a_14349_4954# 0.09774f
C2995 digital_0._100_.RESET_B a_14349_4954# 0.02f
C2996 a_14350_2386# digital_0._116_.SET_B 0.16104f
C2997 digital_0.clkbuf_1_0__f_clk.X a_14350_2386# 0.02823f
C2998 a_14350_2386# ui_in<0> 0.01209f
C2999 a_14358_12740# a_14358_12600# 0.11733f
C3000 a_14358_13680# a_14358_13540# 0.11733f
C3001 a_14358_14620# a_14358_14480# 0.11733f
C3002 a_14358_15930# a_14358_15420# 0.02417f
C3003 a_14358_16870# a_14358_16730# 0.11733f
C3004 a_14358_17810# a_14358_17670# 0.11733f
C3005 a_14358_18750# a_14358_18610# 0.11733f
C3006 a_14453_4018# a_14384_4044# 0.20964f
C3007 a_14384_4044# a_14598_4044# 0.09774f
C3008 a_14384_4044# digital_0._101_.D 0.03284f
C3009 digital_0._101_.RESET_B a_14384_4044# 0.16612f
C3010 a_14384_4044# digital_0.output6.A 0.01866f
C3011 a_14453_4018# a_14598_4044# 0.05722f
C3012 a_14453_4018# a_14763_4410# 0.01379f
C3013 a_14453_4018# a_15016_4044# 0.04983f
C3014 a_14453_4018# digital_0._101_.D 0.03056f
C3015 digital_0._101_.RESET_B a_14453_4018# 0.15328f
C3016 a_14453_4018# digital_0.output6.A 0.02996f
C3017 a_14459_4830# a_14806_4588# 0.05116f
C3018 digital_0._100_.RESET_B a_14459_4830# 0.17454f
C3019 digital_0.clkbuf_1_0__f_clk.X a_14459_4830# 0.04293f
C3020 a_14464_2956# digital_0._080_.A2 0.01626f
C3021 digital_0._118_.D a_14464_2956# 0.1576f
C3022 digital_0.output13.A a_14464_2956# 0.02486f
C3023 a_14531_1476# a_14627_1298# 0.41909f
C3024 digital_0.hold18.X a_14531_1476# 0.13412f
C3025 a_14531_1476# uo_out<0> 0.01062f
C3026 a_14573_5374# a_14534_5248# 0.88863f
C3027 a_14534_5248# a_14660_5132# 0.18639f
C3028 a_14534_5248# a_14729_5106# 0.2298f
C3029 a_14534_5248# a_14874_5132# 0.03462f
C3030 a_14534_5248# a_15292_5132# 0.06418f
C3031 a_14534_5248# clk 0.04298f
C3032 digital_0._100_.RESET_B a_14534_5248# 0.02208f
C3033 digital_0._117_.RESET_B a_14534_5248# 0.02691f
C3034 a_14534_5248# digital_0.hold19.X 0.27766f
C3035 digital_0.output4.A a_14534_5248# 0.03979f
C3036 digital_0.output5.A a_14534_5248# 0.02964f
C3037 a_14534_5248# uo_out<1> 0.01733f
C3038 a_14553_5676# a_14770_5676# 0.11296f
C3039 a_14553_5676# digital_0._100_.RESET_B 0.01476f
C3040 digital_0.output4.A a_14553_5676# 0.22908f
C3041 digital_0.output5.A a_14553_5676# 0.06395f
C3042 a_14573_5374# a_14660_5132# 0.07009f
C3043 a_14573_5374# a_14729_5106# 0.11535f
C3044 a_14573_5374# a_15292_5132# 0.09313f
C3045 a_14573_5374# clk 0.02771f
C3046 digital_0._100_.RESET_B a_14573_5374# 0.01208f
C3047 digital_0._117_.RESET_B a_14573_5374# 0.29634f
C3048 a_14573_5374# digital_0.clkbuf_1_0__f_clk.X 0.25131f
C3049 a_14573_5374# digital_0.hold19.X 0.17059f
C3050 digital_0.output4.A a_14573_5374# 0.04107f
C3051 digital_0.output5.A a_14573_5374# 0.03934f
C3052 a_14573_5374# uo_out<1> 0.0456f
C3053 digital_0._101_.RESET_B a_14598_4044# 0.0122f
C3054 digital_0.output6.A a_14598_4044# 0.02655f
C3055 a_14797_2172# a_14622_2246# 0.23366f
C3056 digital_0._116_.SET_B a_14622_2246# 0.01513f
C3057 digital_0._119_.RESET_B a_14622_2246# 0.23197f
C3058 digital_0.load_slew15.X a_14622_2246# 0.0571f
C3059 digital_0.output4.A a_14622_2246# 0.01981f
C3060 a_14627_1298# a_14885_1298# 0.22264f
C3061 digital_0.hold18.X a_14627_1298# 0.01017f
C3062 a_14627_1298# uo_out<0> 0.01501f
C3063 a_14729_5106# a_14660_5132# 0.20964f
C3064 a_14660_5132# a_14874_5132# 0.09774f
C3065 a_14660_5132# a_14981_4562# 0.0119f
C3066 a_14660_5132# clk 0.01153f
C3067 digital_0._117_.RESET_B a_14660_5132# 0.16612f
C3068 a_14726_2778# a_14797_2172# 0.01027f
C3069 a_14876_2626# a_14726_2778# 0.34236f
C3070 a_14726_2778# a_15300_2412# 0.10799f
C3071 digital_0._116_.SET_B a_14726_2778# 0.2124f
C3072 digital_0.clkbuf_1_0__f_clk.X a_14726_2778# 0.05242f
C3073 digital_0.input2.X a_14726_2778# 0.01632f
C3074 digital_0.output4.A a_14726_2778# 0.01877f
C3075 digital_0.output6.A a_14726_2778# 0.01037f
C3076 a_14726_2778# ui_in<0> 0.0242f
C3077 a_14729_5106# a_14874_5132# 0.05722f
C3078 a_14729_5106# a_15039_5498# 0.01379f
C3079 a_14729_5106# a_15292_5132# 0.04983f
C3080 a_14729_5106# clk 0.01255f
C3081 digital_0._117_.RESET_B a_14729_5106# 0.15327f
C3082 digital_0.output4.A a_14729_5106# 0.02057f
C3083 a_14759_3500# a_14995_3500# 0.22264f
C3084 digital_0._101_.D a_14759_3500# 0.09178f
C3085 digital_0._116_.Q a_14759_3500# 0.03961f
C3086 digital_0.clkbuf_1_0__f_clk.X a_14759_3500# 0.06171f
C3087 digital_0.output13.A a_14759_3500# 0.29895f
C3088 a_14770_5676# a_14881_5676# 0.34134f
C3089 a_14770_5676# digital_0._117_.RESET_B 0.01275f
C3090 digital_0.output4.A a_14770_5676# 0.05307f
C3091 digital_0.output5.A a_14770_5676# 0.03614f
C3092 digital_0._119_.RESET_B a_14797_2172# 0.33236f
C3093 digital_0.load_slew15.X a_14797_2172# 0.08554f
C3094 digital_0.output13.A a_14797_2172# 0.01555f
C3095 digital_0.output4.A a_14797_2172# 0.13076f
C3096 a_14797_2172# ui_in<0> 0.01004f
C3097 a_14981_4562# a_14806_4588# 0.23366f
C3098 a_14806_4588# clk 0.01158f
C3099 digital_0._100_.RESET_B a_14806_4588# 0.23049f
C3100 digital_0.clkbuf_1_0__f_clk.X a_14806_4588# 0.05828f
C3101 digital_0.output4.A a_14806_4588# 0.01871f
C3102 digital_0._117_.RESET_B a_14874_5132# 0.0122f
C3103 a_14876_2626# a_15300_2412# 0.15326f
C3104 digital_0._116_.SET_B a_14876_2626# 0.12109f
C3105 digital_0.clkbuf_1_0__f_clk.X a_14876_2626# 0.0356f
C3106 digital_0.output4.A a_14876_2626# 0.02373f
C3107 a_14876_2626# ui_in<0> 0.01252f
C3108 digital_0.output4.A a_14881_5676# 0.04929f
C3109 digital_0.output5.A a_14881_5676# 0.06236f
C3110 a_14881_5676# uo_out<1> 0.09047f
C3111 a_14885_1298# a_15289_1324# 0.0425f
C3112 digital_0._119_.RESET_B a_14885_1298# 0.01234f
C3113 digital_0.output4.A a_14885_1298# 0.29967f
C3114 a_14885_1298# uo_out<0> 0.01093f
C3115 a_14981_4562# clk 0.01558f
C3116 digital_0._100_.RESET_B a_14981_4562# 0.27799f
C3117 digital_0.clkbuf_1_0__f_clk.X a_14981_4562# 0.08211f
C3118 digital_0.hold19.X a_14981_4562# 0.02437f
C3119 digital_0.output4.A a_14981_4562# 0.02787f
C3120 digital_0.output5.A a_14981_4562# 0.11346f
C3121 a_14995_3500# a_15101_3500# 0.41909f
C3122 digital_0._101_.D a_14995_3500# 0.01079f
C3123 digital_0._116_.Q a_14995_3500# 0.07156f
C3124 digital_0.clkbuf_1_0__f_clk.X a_14995_3500# 0.01406f
C3125 a_14995_3500# digital_0.input2.X 0.04949f
C3126 digital_0.output13.A a_14995_3500# 0.06875f
C3127 digital_0.output4.A a_14995_3500# 0.02257f
C3128 digital_0._101_.D a_15016_4044# 0.17124f
C3129 digital_0.output6.A a_15016_4044# 0.01644f
C3130 digital_0._116_.Q a_15101_3500# 0.06256f
C3131 digital_0.hold19.X a_15101_3500# 0.13065f
C3132 a_15101_3500# digital_0.input2.X 0.05384f
C3133 digital_0.output13.A a_15101_3500# 0.03631f
C3134 digital_0.output4.A a_15101_3500# 0.0215f
C3135 digital_0.output6.A a_15101_3500# 0.01227f
C3136 a_15289_1324# a_15506_1324# 0.11296f
C3137 digital_0.output13.A a_15289_1324# 0.20929f
C3138 digital_0.output4.A a_15289_1324# 0.02365f
C3139 a_15289_2956# a_15506_2956# 0.11296f
C3140 digital_0._116_.Q a_15289_2956# 0.01966f
C3141 digital_0._118_.D a_15289_2956# 0.04095f
C3142 digital_0.clkbuf_1_0__f_clk.X a_15289_2956# 0.05881f
C3143 digital_0.output13.A a_15289_2956# 0.02978f
C3144 digital_0.output6.A a_15289_2956# 0.2018f
C3145 a_15289_5676# a_15506_5676# 0.11296f
C3146 digital_0.output5.A a_15289_5676# 0.22457f
C3147 a_15289_5676# uo_out<1> 0.19376f
C3148 digital_0.hold19.X a_15292_5132# 0.16052f
C3149 digital_0.output5.A a_15292_5132# 0.01496f
C3150 digital_0._116_.Q a_15300_2412# 0.12158f
C3151 digital_0.load_slew15.X a_15300_2412# 0.0115f
C3152 digital_0.output13.A a_15300_2412# 0.02643f
C3153 a_15300_2412# ui_in<0> 0.01436f
C3154 a_15300_2412# uo_out<1> 0.01166f
C3155 a_15506_1324# a_15617_1324# 0.34134f
C3156 digital_0.output13.A a_15506_1324# 0.01024f
C3157 a_15506_2956# a_15617_2956# 0.34134f
C3158 digital_0._116_.Q a_15506_2956# 0.02312f
C3159 digital_0._118_.D a_15506_2956# 0.04847f
C3160 digital_0.clkbuf_1_0__f_clk.X a_15506_2956# 0.05232f
C3161 a_15506_2956# uo_out<1> 0.02674f
C3162 a_15506_5676# a_15617_5676# 0.34134f
C3163 a_15506_5676# uo_out<1> 0.04771f
C3164 digital_0._116_.Q a_15507_3528# 0.09323f
C3165 a_15507_3528# digital_0._118_.D 0.15255f
C3166 digital_0.clkbuf_1_0__f_clk.X a_15507_3528# 0.0174f
C3167 digital_0.hold19.X a_15507_3528# 0.0384f
C3168 a_15507_3528# digital_0.input2.X 0.19057f
C3169 a_15507_3528# uo_out<1> 0.01736f
C3170 digital_0._118_.D a_15617_2956# 0.05418f
C3171 digital_0.clkbuf_1_0__f_clk.X a_15617_2956# 0.04552f
C3172 a_15617_2956# uio_out<1> 0.09445f
C3173 a_15617_2956# uo_out<1> 0.01687f
C3174 a_15617_5676# uio_out<0> 0.09147f
C3175 a_15617_5676# uo_out<1> 0.02407f
C3176 a_15998_13144# a_16214_13144# 0.01515f
C3177 a_15998_13144# a_16646_13144# 0.06667f
C3178 a_16008_16644# a_16224_16644# 0.01515f
C3179 a_16008_16644# uio_out<2> 0.02051f
C3180 a_16008_16644# uio_out<3> 0.02047f
C3181 a_16214_13144# a_16646_13144# 0.01515f
C3182 a_16214_13144# uio_out<1> 0.02197f
C3183 a_16224_16644# a_16656_16644# 0.14233f
C3184 a_16224_16644# uio_out<1> 0.02667f
C3185 a_16440_18564# a_16872_18564# 0.21349f
C3186 a_16440_18564# uio_out<0> 0.02004f
C3187 a_16646_13144# a_17508_13144# 0.04861f
C3188 a_16646_13144# uio_out<0> 0.02317f
C3189 a_16646_13144# uo_out<1> 0.02313f
C3190 a_16656_16644# a_17088_16644# 0.14233f
C3191 a_16656_16644# uo_out<1> 0.02667f
C3192 a_16872_18564# a_17304_18564# 0.21349f
C3193 a_17088_16644# a_17520_16644# 0.14233f
C3194 a_17304_18564# a_17736_18564# 0.21349f
C3195 a_17508_13144# a_17724_13144# 0.01515f
C3196 a_17508_13144# a_18156_13144# 0.06667f
C3197 a_17508_13144# uo_out<1> 0.01537f
C3198 a_17520_16644# a_17952_16644# 0.14233f
C3199 a_17520_16644# uo_out<1> 0.01047f
C3200 a_17724_13144# a_18156_13144# 0.01515f
C3201 a_17736_18564# a_18168_18564# 0.21349f
C3202 a_17952_16644# a_18384_16644# 0.14233f
C3203 a_18156_13144# a_19018_13144# 0.04861f
C3204 a_18168_18564# a_18600_18564# 0.21349f
C3205 a_18384_16644# a_18816_16644# 0.14233f
C3206 a_18456_11509# a_18456_10709# 0.0149f
C3207 a_18600_18564# a_19032_18564# 0.21349f
C3208 a_18816_16644# a_19248_16644# 0.14233f
C3209 a_19018_13144# a_19234_13144# 0.01515f
C3210 a_19018_13144# a_19666_13144# 0.06667f
C3211 a_19234_13144# a_19666_13144# 0.01515f
C3212 a_19248_16644# a_19680_16644# 0.01515f
C3213 a_19666_13144# a_20528_13144# 0.04861f
C3214 a_19680_16644# a_20538_16644# 0.04885f
C3215 a_20156_9909# a_19706_9559# 0.01328f
C3216 a_20372_11267# a_20156_10709# 0.01519f
C3217 a_20372_12347# a_20372_11267# 0.0381f
C3218 a_20372_11267# a_21554_10625# 0.01541f
C3219 a_22292_11483# a_20372_11267# 0.01515f
C3220 a_20372_12347# a_22292_11915# 0.01515f
C3221 a_20412_20698# a_20412_20378# 0.01f
C3222 a_20528_13144# a_20744_13144# 0.01515f
C3223 a_20528_13144# a_21176_13144# 0.06667f
C3224 a_20538_16644# a_20754_16644# 0.01515f
C3225 a_20744_13144# a_21176_13144# 0.01515f
C3226 a_20754_16644# a_21186_16644# 0.14233f
C3227 a_20970_18564# a_21402_18564# 0.21349f
C3228 a_21176_13144# a_22038_13144# 0.04861f
C3229 a_21186_16644# a_21618_16644# 0.14233f
C3230 a_21252_20698# a_21252_20378# 0.01f
C3231 a_21402_18564# a_21834_18564# 0.21349f
C3232 a_21554_8773# a_21558_8509# 0.05091f
C3233 a_21554_9825# a_21554_9573# 0.05415f
C3234 a_21618_16644# a_22050_16644# 0.14233f
C3235 a_21834_18564# a_22266_18564# 0.21349f
C3236 a_22038_13144# a_22254_13144# 0.01515f
C3237 a_22050_16644# a_22482_16644# 0.14233f
C3238 a_22254_13144# a_22686_13144# 0.14233f
C3239 a_22266_18564# a_22698_18564# 0.21349f
C3240 a_22292_11915# a_22292_11483# 0.14233f
C3241 a_22470_15064# a_22902_15064# 0.21349f
C3242 a_22482_16644# a_22914_16644# 0.14233f
C3243 a_22686_13144# a_23118_13144# 0.14233f
C3244 a_22698_18564# a_23130_18564# 0.21349f
C3245 a_22902_15064# a_23334_15064# 0.21349f
C3246 a_22914_16644# a_23346_16644# 0.14233f
C3247 a_23118_13144# a_23550_13144# 0.14233f
C3248 a_23130_18564# a_23562_18564# 0.21349f
C3249 a_23138_8685# a_23138_8427# 0.05264f
C3250 a_23346_16644# a_23778_16644# 0.14233f
C3251 a_23550_13144# a_23982_13144# 0.01515f
C3252 a_23778_16644# a_24210_16644# 0.01515f
C3253 a_23824_11183# a_23816_10541# 0.01862f
C3254 a_23982_13144# a_24838_13144# 0.04898f
C3255 a_24210_16644# a_25078_16644# 0.04824f
C3256 a_24508_7627# a_24510_7235# 0.03228f
C3257 a_24508_8687# a_24508_8427# 0.05215f
C3258 a_2478_11750# a_2478_11240# 0.02417f
C3259 a_2478_13060# a_2478_12550# 0.02417f
C3260 a_2478_14370# a_2478_13860# 0.02417f
C3261 a_2478_15680# a_2478_15170# 0.02417f
C3262 a_2478_16990# a_2478_16480# 0.02417f
C3263 a_2478_18300# a_2478_17790# 0.02417f
C3264 a_2478_19610# a_2478_19100# 0.02417f
C3265 a_24838_13144# a_25054_13144# 0.01515f
C3266 a_25054_13144# a_25486_13144# 0.14233f
C3267 a_25078_16644# a_25294_16644# 0.01515f
C3268 a_25270_15064# a_25702_15064# 0.21349f
C3269 a_25270_15064# uo_out<0> 0.0138f
C3270 a_25294_16644# a_25726_16644# 0.14233f
C3271 a_25294_16644# uo_out<0> 0.01133f
C3272 a_25486_13144# a_25918_13144# 0.14233f
C3273 a_25486_13144# uo_out<0> 0.01404f
C3274 a_25510_18564# a_25942_18564# 0.21349f
C3275 a_25510_18564# uo_out<0> 0.018f
C3276 a_25702_15064# a_26134_15064# 0.21349f
C3277 a_25702_15064# uo_out<0> 0.02153f
C3278 a_25726_16644# a_26158_16644# 0.14233f
C3279 a_25726_16644# uo_out<0> 0.01758f
C3280 a_25918_13144# a_26350_13144# 0.14233f
C3281 a_25918_13144# uo_out<0> 0.0197f
C3282 a_25942_18564# a_26374_18564# 0.21349f
C3283 a_25942_18564# uo_out<0> 0.02854f
C3284 a_26086_6851# a_26086_6531# 0.01f
C3285 a_26088_7351# a_26086_6851# 0.02044f
C3286 a_26088_7671# a_26088_7351# 0.01f
C3287 a_26090_8213# a_26088_7671# 0.01876f
C3288 a_26090_10613# a_26090_10293# 0.01f
C3289 a_26090_11093# uo_out<0> 0.03259f
C3290 a_26090_12053# a_26090_11733# 0.01f
C3291 a_26090_11733# uo_out<0> 0.11583f
C3292 a_26090_12053# uo_out<0> 0.10209f
C3293 a_26090_8533# a_26090_8213# 0.01f
C3294 a_26090_9333# a_26090_9013# 0.01f
C3295 a_26090_9333# uo_out<0> 0.061f
C3296 a_26134_15064# uo_out<0> 0.03084f
C3297 a_26158_16644# a_26590_16644# 0.14233f
C3298 a_26158_16644# uo_out<0> 0.02563f
C3299 a_26350_13144# a_26782_13144# 0.01515f
C3300 a_26350_13144# uo_out<0> 0.02945f
C3301 a_26374_18564# a_26806_18564# 0.21349f
C3302 a_26374_18564# uo_out<0> 0.02396f
C3303 a_26590_16644# a_27022_16644# 0.14233f
C3304 a_26590_16644# uo_out<0> 0.01573f
C3305 a_26782_13144# a_27638_13144# 0.04898f
C3306 a_26782_13144# ui_in<0> 0.01225f
C3307 a_26782_13144# uo_out<0> 0.01977f
C3308 a_26806_18564# a_27238_18564# 0.21349f
C3309 a_26806_18564# ui_in<0> 0.01515f
C3310 a_26806_18564# uo_out<0> 0.01567f
C3311 a_26926_6851# a_26926_6531# 0.01f
C3312 a_26928_7351# a_26926_6851# 0.02044f
C3313 a_26928_7671# a_26928_7351# 0.01f
C3314 a_26930_8213# a_26928_7671# 0.01876f
C3315 a_26930_10613# a_26930_10293# 0.01f
C3316 a_26930_11093# uo_out<0> 0.0217f
C3317 a_26930_12053# a_26930_11733# 0.01f
C3318 a_26930_11733# uo_out<0> 0.08024f
C3319 a_26930_12053# uo_out<0> 0.06047f
C3320 a_26930_8533# a_26930_8213# 0.01f
C3321 a_26930_9333# a_26930_9013# 0.01f
C3322 a_26930_9333# uo_out<0> 0.06598f
C3323 a_26930_9813# uo_out<0> 0.0107f
C3324 a_27022_16644# a_27454_16644# 0.14233f
C3325 a_27022_16644# ui_in<0> 0.01527f
C3326 a_27238_18564# a_27670_18564# 0.21349f
C3327 a_27238_18564# ui_in<0> 0.023f
C3328 a_27238_18564# ui_in<1> 0.02262f
C3329 a_27454_16644# a_27886_16644# 0.14233f
C3330 a_27454_16644# ui_in<0> 0.02453f
C3331 a_27638_13144# a_27854_13144# 0.01515f
C3332 a_27638_13144# ui_in<0> 0.0377f
C3333 a_27670_18564# a_28102_18564# 0.21349f
C3334 a_27670_18564# ui_in<0> 0.03253f
C3335 a_27670_18564# ui_in<1> 0.02262f
C3336 a_27854_13144# a_28286_13144# 0.14233f
C3337 a_27854_13144# ui_in<0> 0.01838f
C3338 a_27886_16644# a_28318_16644# 0.14233f
C3339 a_27886_16644# ui_in<0> 0.01798f
C3340 a_28070_15064# a_28502_15064# 0.21349f
C3341 a_28070_15064# ui_in<0> 0.01657f
C3342 a_28102_18564# clk 0.01864f
C3343 a_28102_18564# ui_in<0> 0.01857f
C3344 a_28102_18564# ui_in<1> 0.02262f
C3345 a_28286_13144# a_28718_13144# 0.14233f
C3346 a_28318_16644# a_28750_16644# 0.01515f
C3347 a_28318_16644# clk 0.0144f
C3348 a_28318_16644# ui_in<0> 0.01172f
C3349 a_28502_15064# a_28934_15064# 0.21349f
C3350 a_2858_6904# a_3074_6904# 0.01515f
C3351 a_2858_6904# uio_out<4> 0.01787f
C3352 a_28718_13144# a_29150_13144# 0.14233f
C3353 a_28750_16644# clk 0.03619f
C3354 a_29150_13144# a_29582_13144# 0.01515f
C3355 a_29432_20986# a_29432_20666# 0.01f
C3356 a_29432_20666# ui_in<1> 0.06218f
C3357 a_29432_21305# a_29432_20986# 0.01003f
C3358 a_29432_20986# rst_n 0.05976f
C3359 a_29432_21624# a_29432_21305# 0.01007f
C3360 a_29432_21305# rst_n 0.06232f
C3361 a_29432_21944# a_29432_21624# 0.01003f
C3362 a_30272_20186# ui_in<1> 0.01295f
C3363 a_30272_20986# a_30272_20666# 0.01f
C3364 a_30272_20666# ui_in<1> 0.06648f
C3365 a_30272_21305# a_30272_20986# 0.01003f
C3366 a_30272_20986# rst_n 0.06732f
C3367 a_30272_21624# a_30272_21305# 0.01007f
C3368 a_30272_21305# rst_n 0.06013f
C3369 a_30272_21944# a_30272_21624# 0.01003f
C3370 a_3074_6904# a_3506_6904# 0.14233f
C3371 a_3074_6904# uio_out<4> 0.04769f
C3372 a_3290_8824# a_3722_8824# 0.21349f
C3373 a_3336_4018# a_3462_4282# 0.34134f
C3374 a_3336_4018# digital_0.output9.A 0.05454f
C3375 a_3336_4018# uio_out<4> 0.09518f
C3376 a_3389_2930# a_3676_3088# 0.23366f
C3377 a_3389_2930# a_3679_2412# 0.01412f
C3378 a_3730_3500# a_3389_2930# 0.01365f
C3379 a_3389_2930# a_3954_3072# 0.04251f
C3380 a_3389_2930# a_3993_3198# 0.04359f
C3381 digital_0._104_.RESET_B a_3389_2930# 0.27961f
C3382 digital_0._116_.Q a_3389_2930# 0.01544f
C3383 digital_0.input3.X a_3389_2930# 0.03121f
C3384 digital_0.output9.A a_3389_2930# 0.1187f
C3385 a_3903_1324# a_3437_1574# 0.04406f
C3386 digital_0._112_.RESET_B a_3437_1574# 0.171f
C3387 digital_0._116_.Q a_3437_1574# 0.10493f
C3388 digital_0.load_slew17.X a_3437_1574# 0.09045f
C3389 digital_0.output10.A a_3437_1574# 0.01849f
C3390 digital_0._112_.RESET_B a_3437_1868# 0.01612f
C3391 digital_0._113_.RESET_B a_3437_1868# 0.15506f
C3392 digital_0._116_.Q a_3437_1868# 0.10988f
C3393 digital_0.input3.X a_3437_1868# 0.0498f
C3394 a_3443_2412# a_3679_2412# 0.22264f
C3395 a_3443_2412# digital_0._112_.RESET_B 0.04908f
C3396 digital_0._116_.Q a_3443_2412# 0.01071f
C3397 digital_0.input3.X a_3443_2412# 0.05386f
C3398 digital_0.output9.A a_3443_2412# 0.29644f
C3399 a_3462_4282# a_3702_4018# 0.11296f
C3400 digital_0._116_.Q a_3462_4282# 0.01415f
C3401 a_3462_4282# digital_0.output9.A 0.0735f
C3402 a_3506_6904# a_3938_6904# 0.14233f
C3403 a_3506_6904# uio_out<4> 0.04603f
C3404 a_3513_3500# a_3676_3088# 0.01257f
C3405 a_3702_4018# a_3513_3500# 0.01067f
C3406 a_3513_3500# a_3730_3500# 0.11296f
C3407 a_3513_3500# digital_0._113_.RESET_B 0.05421f
C3408 digital_0._116_.Q a_3513_3500# 0.01381f
C3409 digital_0.input3.X a_3513_3500# 0.21856f
C3410 digital_0.output9.A a_3513_3500# 0.01758f
C3411 a_3676_3088# a_3954_3072# 0.12532f
C3412 a_3676_3088# a_3993_3198# 0.10236f
C3413 a_3676_3088# a_4080_2956# 0.05116f
C3414 digital_0._104_.RESET_B a_3676_3088# 0.24255f
C3415 digital_0._116_.Q a_3676_3088# 0.02502f
C3416 a_3679_2412# a_3785_2412# 0.41909f
C3417 a_3679_2412# digital_0._112_.RESET_B 0.07401f
C3418 digital_0._116_.Q a_3679_2412# 0.03753f
C3419 digital_0.input3.X a_3679_2412# 0.09301f
C3420 a_3702_4018# digital_0._104_.RESET_B 0.01053f
C3421 digital_0._116_.Q a_3702_4018# 0.05468f
C3422 a_3702_4018# digital_0.output9.A 0.23716f
C3423 a_3722_8824# a_4154_8824# 0.21349f
C3424 a_3730_3500# a_3841_3500# 0.34134f
C3425 a_3730_3500# digital_0._113_.RESET_B 0.05524f
C3426 digital_0._116_.Q a_3730_3500# 0.02863f
C3427 a_3785_2412# digital_0._112_.RESET_B 0.062f
C3428 digital_0._116_.Q a_3785_2412# 0.02336f
C3429 digital_0.hold23.X a_3785_2412# 0.13052f
C3430 digital_0.input3.X a_3785_2412# 0.06382f
C3431 digital_0._104_.RESET_B a_3841_3500# 0.01467f
C3432 a_3841_3500# digital_0._113_.RESET_B 0.05822f
C3433 digital_0._116_.Q a_3841_3500# 0.01631f
C3434 digital_0.load_slew17.A a_3841_3500# 0.09342f
C3435 a_3903_1324# a_4139_1324# 0.22264f
C3436 digital_0.load_slew17.X a_3903_1324# 0.04269f
C3437 digital_0.output10.A a_3903_1324# 0.32551f
C3438 a_3938_6904# a_4370_6904# 0.14233f
C3439 a_3938_6904# uio_out<4> 0.04493f
C3440 a_3941_1842# a_4228_2000# 0.23366f
C3441 a_3941_1842# a_4506_1984# 0.04251f
C3442 a_3941_1842# a_4545_2110# 0.04359f
C3443 a_3941_1842# digital_0._105_.RESET_B 0.27927f
C3444 digital_0._116_.Q a_3941_1842# 0.03126f
C3445 digital_0.hold28.A a_3941_1842# 0.01504f
C3446 a_3941_1842# digital_0.output10.A 0.10933f
C3447 a_3993_3198# a_3954_3072# 0.88854f
C3448 a_3954_3072# a_4080_2956# 0.18639f
C3449 a_3954_3072# a_4149_2930# 0.2298f
C3450 a_3954_3072# a_4294_2956# 0.03462f
C3451 a_3954_3072# a_4712_2956# 0.06418f
C3452 digital_0._104_.D a_3954_3072# 0.25815f
C3453 digital_0._104_.RESET_B a_3954_3072# 0.03186f
C3454 digital_0.hold23.X a_3954_3072# 0.03307f
C3455 digital_0.hold28.A a_3954_3072# 0.03705f
C3456 digital_0.load_slew17.X a_3954_3072# 0.02513f
C3457 a_3993_3198# a_4080_2956# 0.06944f
C3458 a_3993_3198# a_4149_2930# 0.11535f
C3459 a_3993_3198# a_4712_2956# 0.09313f
C3460 a_3993_3198# a_5461_2956# 0.0129f
C3461 digital_0._104_.D a_3993_3198# 0.19514f
C3462 digital_0._104_.RESET_B a_3993_3198# 0.30695f
C3463 a_3993_3198# digital_0._112_.D 0.01008f
C3464 digital_0._112_.Q a_3993_3198# 0.01995f
C3465 digital_0.clkload0.A a_3993_3198# 0.2481f
C3466 digital_0.hold23.X a_3993_3198# 0.04872f
C3467 digital_0.hold28.A a_3993_3198# 0.03214f
C3468 digital_0.load_slew17.X a_3993_3198# 0.02587f
C3469 a_4033_5106# a_4320_5264# 0.23366f
C3470 a_4033_5106# a_4598_5248# 0.04251f
C3471 a_4033_5106# a_4637_5374# 0.04359f
C3472 a_4033_5106# digital_0._102_.RESET_B 0.28095f
C3473 digital_0.output7.A a_4033_5106# 0.10784f
C3474 a_4149_2930# a_4080_2956# 0.20964f
C3475 a_4080_2956# a_4294_2956# 0.09774f
C3476 digital_0._104_.RESET_B a_4080_2956# 0.17107f
C3477 digital_0.hold28.A a_4080_2956# 0.01837f
C3478 a_4139_1324# a_4245_1324# 0.41909f
C3479 digital_0._105_.RESET_B a_4139_1324# 0.01499f
C3480 digital_0.load_slew17.X a_4139_1324# 0.07019f
C3481 digital_0.output10.A a_4139_1324# 0.07618f
C3482 a_4149_2930# a_4294_2956# 0.05722f
C3483 a_4149_2930# a_4459_3322# 0.01379f
C3484 a_4149_2930# a_4712_2956# 0.04983f
C3485 digital_0._104_.RESET_B a_4149_2930# 0.15622f
C3486 digital_0.hold28.A a_4149_2930# 0.0243f
C3487 a_4154_8824# a_4586_8824# 0.21349f
C3488 a_4157_2412# a_4374_2412# 0.11296f
C3489 digital_0._104_.RESET_B a_4157_2412# 0.01226f
C3490 a_4157_2412# digital_0._105_.RESET_B 0.01301f
C3491 a_4157_2412# digital_0._112_.RESET_B 0.05598f
C3492 digital_0.hold23.X a_4157_2412# 0.16949f
C3493 digital_0.hold28.A a_4157_2412# 0.01066f
C3494 digital_0.input3.X a_4157_2412# 0.0449f
C3495 a_4228_2000# a_4506_1984# 0.12532f
C3496 a_4228_2000# a_4545_2110# 0.10236f
C3497 a_4228_2000# a_4632_1868# 0.05116f
C3498 a_4228_2000# digital_0._105_.RESET_B 0.23846f
C3499 digital_0.hold28.A a_4228_2000# 0.02767f
C3500 a_4245_1324# digital_0.hold27.X 0.13553f
C3501 digital_0.hold28.A a_4245_1324# 0.01114f
C3502 digital_0.load_slew17.X a_4245_1324# 0.06502f
C3503 digital_0.output10.A a_4245_1324# 0.05511f
C3504 digital_0._104_.RESET_B a_4294_2956# 0.0122f
C3505 a_4320_5264# a_4598_5248# 0.11876f
C3506 a_4320_5264# a_4637_5374# 0.10236f
C3507 a_4320_5264# a_4724_5132# 0.05116f
C3508 a_4320_5264# digital_0._102_.RESET_B 0.23803f
C3509 digital_0.hold28.A a_4320_5264# 0.04247f
C3510 digital_0._116_.Q a_4341_4052# 0.04522f
C3511 digital_0.hold28.A a_4341_4052# 0.01966f
C3512 digital_0.load_slew17.A a_4341_4052# 0.20835f
C3513 a_4341_4052# digital_0.load_slew17.X 0.15507f
C3514 a_4370_6904# a_4802_6904# 0.14233f
C3515 a_4370_6904# uio_out<4> 0.04354f
C3516 a_4374_2412# a_4485_2412# 0.34134f
C3517 a_4374_2412# a_4545_2110# 0.0107f
C3518 a_4374_2412# digital_0._112_.RESET_B 0.05059f
C3519 digital_0.hold23.X a_4374_2412# 0.02874f
C3520 digital_0.hold28.A a_4374_2412# 0.02259f
C3521 digital_0.input3.X a_4374_2412# 0.03824f
C3522 digital_0._104_.RESET_B a_4383_3827# 0.01089f
C3523 digital_0._112_.Q a_4383_3827# 0.10179f
C3524 digital_0._113_.RESET_B a_4383_3827# 0.05845f
C3525 a_4383_3827# digital_0.hold23.X 0.03924f
C3526 digital_0.hold28.A a_4383_3827# 0.21748f
C3527 digital_0.load_slew17.A a_4383_3827# 0.09843f
C3528 a_4455_5676# a_4637_5374# 0.0135f
C3529 a_4455_5676# a_4691_5676# 0.22264f
C3530 digital_0.output7.A a_4455_5676# 0.33721f
C3531 a_4485_2412# digital_0._112_.RESET_B 0.055f
C3532 digital_0.hold23.X a_4485_2412# 0.02107f
C3533 digital_0.hold28.A a_4485_2412# 0.01997f
C3534 digital_0.input3.X a_4485_2412# 0.12626f
C3535 a_4545_2110# a_4506_1984# 0.88354f
C3536 a_4506_1984# a_4632_1868# 0.18517f
C3537 a_4506_1984# a_4701_1842# 0.21772f
C3538 a_4506_1984# a_4846_1868# 0.02757f
C3539 a_4506_1984# a_5264_1868# 0.05936f
C3540 a_4506_1984# digital_0._105_.D 0.26638f
C3541 digital_0._105_.RESET_B a_4506_1984# 0.0568f
C3542 digital_0._113_.Q a_4506_1984# 0.04626f
C3543 digital_0.hold28.A a_4506_1984# 0.02941f
C3544 digital_0.load_slew17.X a_4506_1984# 0.44761f
C3545 a_4545_2110# a_4632_1868# 0.06944f
C3546 a_4545_2110# a_4701_1842# 0.11535f
C3547 a_4545_2110# a_5264_1868# 0.08813f
C3548 a_4545_2110# digital_0._105_.D 0.16659f
C3549 digital_0._105_.RESET_B a_4545_2110# 0.32663f
C3550 digital_0._113_.Q a_4545_2110# 0.25134f
C3551 digital_0.clkload0.A a_4545_2110# 0.25797f
C3552 digital_0.hold28.A a_4545_2110# 0.02312f
C3553 digital_0.load_slew17.X a_4545_2110# 0.07514f
C3554 a_4578_12610# a_4578_12200# 0.03078f
C3555 a_4578_13670# a_4578_13410# 0.05215f
C3556 a_4578_17320# a_4580_16870# 0.02767f
C3557 a_4578_18260# a_4578_18120# 0.11733f
C3558 a_4578_19200# a_4578_19060# 0.11733f
C3559 a_4578_20140# a_4578_20000# 0.11733f
C3560 a_4586_8824# a_5018_8824# 0.21349f
C3561 a_4637_5374# a_4598_5248# 0.90347f
C3562 a_4598_5248# a_4724_5132# 0.18122f
C3563 a_4598_5248# a_4793_5106# 0.21686f
C3564 a_4598_5248# a_4938_5132# 0.02761f
C3565 a_4598_5248# a_5356_5132# 0.05936f
C3566 a_4598_5248# digital_0._102_.D 0.22772f
C3567 digital_0._102_.RESET_B a_4598_5248# 0.06095f
C3568 digital_0.hold28.A a_4598_5248# 0.54831f
C3569 digital_0.load_slew17.A a_4598_5248# 0.01236f
C3570 a_4701_1842# a_4632_1868# 0.20964f
C3571 a_4632_1868# a_4846_1868# 0.09774f
C3572 digital_0._105_.RESET_B a_4632_1868# 0.17615f
C3573 digital_0.hold28.A a_4632_1868# 0.01124f
C3574 digital_0.load_slew17.X a_4632_1868# 0.02229f
C3575 a_4637_3827# a_5321_3474# 0.01071f
C3576 a_4637_3827# digital_0._104_.D 0.11042f
C3577 digital_0._112_.Q a_4637_3827# 0.22896f
C3578 a_4637_3827# digital_0._113_.RESET_B 0.04992f
C3579 a_4637_3827# digital_0.hold23.X 0.0633f
C3580 digital_0.hold28.A a_4637_3827# 0.32161f
C3581 digital_0.load_slew17.A a_4637_3827# 0.03657f
C3582 digital_0.load_slew17.X a_4637_3827# 0.02193f
C3583 a_4637_5374# a_4724_5132# 0.07009f
C3584 a_4637_5374# a_4793_5106# 0.11535f
C3585 a_5169_5676# a_4637_5374# 0.0146f
C3586 a_4637_5374# a_5356_5132# 0.09313f
C3587 a_4637_5374# digital_0._102_.D 0.25021f
C3588 digital_0._102_.RESET_B a_4637_5374# 0.33077f
C3589 a_4637_5374# digital_0.clkload0.A 0.24455f
C3590 digital_0.hold28.A a_4637_5374# 0.05199f
C3591 a_4691_5676# a_4793_5106# 0.01674f
C3592 a_4691_5676# a_4797_5676# 0.41909f
C3593 digital_0.output7.A a_4691_5676# 0.09919f
C3594 a_4701_1842# a_4846_1868# 0.05722f
C3595 a_4701_1842# a_5011_2234# 0.01379f
C3596 a_4701_1842# a_5264_1868# 0.04983f
C3597 digital_0._105_.RESET_B a_4701_1842# 0.15995f
C3598 digital_0.load_slew17.X a_4701_1842# 0.04828f
C3599 digital_0._104_.D a_4712_2956# 0.15816f
C3600 digital_0.hold23.X a_4712_2956# 0.01201f
C3601 digital_0.load_slew17.X a_4712_2956# 0.0127f
C3602 a_4793_5106# a_4724_5132# 0.20964f
C3603 a_4724_5132# a_4938_5132# 0.09774f
C3604 digital_0._102_.RESET_B a_4724_5132# 0.17703f
C3605 digital_0.hold28.A a_4724_5132# 0.01984f
C3606 a_4793_5106# a_4938_5132# 0.05722f
C3607 a_4793_5106# a_5103_5498# 0.01379f
C3608 a_4793_5106# a_5356_5132# 0.04983f
C3609 digital_0._102_.RESET_B a_4793_5106# 0.16585f
C3610 digital_0.hold28.A a_4793_5106# 0.03014f
C3611 a_4797_5676# digital_0.hold24.X 0.13051f
C3612 digital_0.output7.A a_4797_5676# 0.08742f
C3613 a_4802_6904# a_5234_6904# 0.14233f
C3614 a_4802_6904# uio_out<4> 0.04325f
C3615 digital_0._105_.RESET_B a_4846_1868# 0.01234f
C3616 digital_0.load_slew17.X a_4846_1868# 0.03329f
C3617 digital_0._105_.RESET_B a_4935_1651# 0.01405f
C3618 digital_0._113_.Q a_4935_1651# 0.10119f
C3619 digital_0.hold27.X a_4935_1651# 0.09101f
C3620 digital_0.hold28.A a_4935_1651# 0.23303f
C3621 digital_0.load_slew17.X a_4935_1651# 0.0388f
C3622 digital_0.output10.A a_4935_1651# 0.05543f
C3623 digital_0._102_.RESET_B a_4938_5132# 0.01854f
C3624 digital_0.hold28.A a_4938_5132# 0.02687f
C3625 a_5018_8824# a_5450_8824# 0.21349f
C3626 a_5169_5676# a_5386_5676# 0.11296f
C3627 a_5169_5676# digital_0.hold24.X 0.19269f
C3628 digital_0.output7.A a_5169_5676# 0.19817f
C3629 digital_0._105_.D a_5189_1651# 0.08812f
C3630 digital_0._113_.Q a_5189_1651# 0.2042f
C3631 a_5189_1651# digital_0.hold27.X 0.05505f
C3632 digital_0.hold28.A a_5189_1651# 0.36904f
C3633 digital_0.output10.A a_5189_1651# 0.07327f
C3634 a_5234_6904# a_5666_6904# 0.14233f
C3635 a_5234_6904# uio_out<2> 0.02531f
C3636 a_5234_6904# uio_out<4> 0.04325f
C3637 digital_0._105_.D a_5264_1868# 0.15794f
C3638 digital_0._113_.Q a_5264_1868# 0.02109f
C3639 digital_0.load_slew17.X a_5264_1868# 0.01781f
C3640 a_5321_2386# a_5608_2664# 0.23366f
C3641 a_5321_2386# a_5886_2680# 0.04251f
C3642 a_5321_2386# a_5925_2554# 0.04359f
C3643 a_5321_2386# digital_0._105_.D 0.0117f
C3644 digital_0._112_.D a_5321_2386# 0.07146f
C3645 digital_0._112_.Q a_5321_2386# 0.13799f
C3646 a_5321_2386# digital_0._112_.RESET_B 0.32475f
C3647 digital_0._113_.Q a_5321_2386# 0.01298f
C3648 a_5321_3474# a_5608_3752# 0.23366f
C3649 a_5321_3474# a_5886_3768# 0.04251f
C3650 a_5321_3474# a_5925_3642# 0.04359f
C3651 a_5321_3474# digital_0._063_.B 0.05501f
C3652 digital_0._112_.Q a_5321_3474# 0.073f
C3653 a_5321_3474# digital_0._113_.Q 0.09983f
C3654 a_5321_3474# digital_0._113_.RESET_B 0.31828f
C3655 digital_0._102_.D a_5356_5132# 0.16221f
C3656 digital_0.hold28.A a_5356_5132# 0.01625f
C3657 a_5386_5676# a_5497_5676# 0.34134f
C3658 a_5386_5676# digital_0.hold24.X 0.04731f
C3659 a_5450_8824# a_5882_8824# 0.21349f
C3660 digital_0._063_.A a_5461_2956# 0.08935f
C3661 digital_0._063_.B a_5461_2956# 0.04505f
C3662 digital_0._112_.D a_5461_2956# 0.17222f
C3663 digital_0.clkload0.A a_5461_2956# 0.05786f
C3664 a_5497_5676# digital_0.hold24.X 0.04161f
C3665 a_5497_5676# uio_out<2> 0.0971f
C3666 a_5608_2664# a_5886_2680# 0.11876f
C3667 a_5608_2664# a_5925_2554# 0.10236f
C3668 a_5608_2664# a_6012_2778# 0.05116f
C3669 digital_0._112_.D a_5608_2664# 0.0484f
C3670 digital_0._112_.Q a_5608_2664# 0.05449f
C3671 a_5608_2664# digital_0._112_.RESET_B 0.22575f
C3672 a_5608_3752# a_5886_3768# 0.12532f
C3673 a_5608_3752# a_5925_3642# 0.10236f
C3674 a_5608_3752# a_6012_3866# 0.05116f
C3675 a_5608_3752# digital_0._063_.B 0.045f
C3676 digital_0._112_.Q a_5608_3752# 0.05762f
C3677 a_5608_3752# digital_0._113_.RESET_B 0.21676f
C3678 a_5666_6904# a_6098_6904# 0.14233f
C3679 a_5666_6904# uio_out<2> 0.09919f
C3680 a_5666_6904# uio_out<4> 0.03276f
C3681 a_5873_4562# a_6160_4840# 0.23366f
C3682 a_5873_4562# a_6438_4856# 0.04251f
C3683 a_5873_4562# a_6477_4730# 0.04348f
C3684 digital_0._110_.Q a_5873_4562# 0.15429f
C3685 a_5873_4562# digital_0._110_.RESET_B 0.29183f
C3686 digital_0.load_slew17.A a_5873_4562# 0.08003f
C3687 a_5886_2680# a_5925_2554# 0.69088f
C3688 a_5886_2680# a_6012_2778# 0.17513f
C3689 a_5886_2680# a_6081_2649# 0.20984f
C3690 a_5886_2680# a_6226_2778# 0.02761f
C3691 a_6343_2930# a_5886_2680# 0.01118f
C3692 a_5886_2680# a_6644_2778# 0.05639f
C3693 digital_0._063_.A a_5886_2680# 0.01705f
C3694 digital_0._112_.D a_5886_2680# 0.22499f
C3695 digital_0._112_.Q a_5886_2680# 0.54816f
C3696 digital_0._112_.RESET_B a_5886_2680# 0.02394f
C3697 digital_0._113_.D a_5886_2680# 0.03764f
C3698 digital_0.clkload0.A a_5886_2680# 0.42157f
C3699 a_5886_3768# a_5925_3642# 0.57808f
C3700 a_5886_3768# a_6012_3866# 0.1745f
C3701 a_5886_3768# a_6081_3737# 0.20646f
C3702 a_5886_3768# a_6226_3866# 0.02761f
C3703 a_5886_3768# a_6343_2930# 0.01142f
C3704 a_5886_3768# a_6644_3866# 0.05639f
C3705 digital_0._063_.A a_5886_3768# 0.01642f
C3706 a_5886_3768# digital_0._063_.B 0.02126f
C3707 digital_0._112_.Q a_5886_3768# 0.58748f
C3708 a_5886_3768# digital_0._113_.D 0.22012f
C3709 digital_0._113_.RESET_B a_5886_3768# 0.02136f
C3710 digital_0._116_.Q a_5886_3768# 0.46975f
C3711 digital_0.clkload0.A a_5886_3768# 0.03155f
C3712 a_5925_2554# a_6012_2778# 0.06225f
C3713 a_5925_2554# a_6081_2649# 0.10756f
C3714 a_6343_2930# a_5925_2554# 0.01925f
C3715 a_5925_2554# a_6644_2778# 0.08671f
C3716 digital_0._063_.A a_5925_2554# 0.04705f
C3717 digital_0._112_.D a_5925_2554# 0.28454f
C3718 digital_0._112_.Q a_5925_2554# 0.03217f
C3719 digital_0._112_.RESET_B a_5925_2554# 0.29503f
C3720 digital_0._113_.D a_5925_2554# 0.03512f
C3721 digital_0.clkload0.A a_5925_2554# 0.46589f
C3722 a_5925_2554# digital_0.clkload0.X 0.01846f
C3723 digital_0.input1.X a_5925_2554# 0.26507f
C3724 a_5925_3642# a_6012_3866# 0.05348f
C3725 a_5925_3642# a_6081_3737# 0.10591f
C3726 a_5925_3642# a_6343_2930# 0.0151f
C3727 a_5925_3642# a_6644_3866# 0.08341f
C3728 a_6968_4276# a_5925_3642# 0.01052f
C3729 a_5925_3642# a_7385_3750# 0.01371f
C3730 digital_0._063_.A a_5925_3642# 0.03888f
C3731 a_5925_3642# digital_0._063_.B 0.12895f
C3732 digital_0._110_.Q a_5925_3642# 0.01233f
C3733 digital_0._112_.Q a_5925_3642# 0.61031f
C3734 a_5925_3642# digital_0._113_.D 0.31715f
C3735 digital_0._113_.RESET_B a_5925_3642# 0.29446f
C3736 digital_0._116_.Q a_5925_3642# 0.03354f
C3737 digital_0.clkload0.A a_5925_3642# 0.02839f
C3738 digital_0.input1.X a_5925_3642# 0.2685f
C3739 a_5997_4044# a_6457_4044# 0.04637f
C3740 digital_0._110_.RESET_B a_5997_4044# 0.15239f
C3741 digital_0._116_.Q a_5997_4044# 0.1029f
C3742 digital_0.clkload0.A a_5997_4044# 0.01228f
C3743 digital_0.load_slew17.A a_5997_4044# 0.09383f
C3744 a_6081_2649# a_6012_2778# 0.20964f
C3745 a_6012_2778# a_6226_2778# 0.09774f
C3746 digital_0._112_.D a_6012_2778# 0.02423f
C3747 digital_0._112_.Q a_6012_2778# 0.01855f
C3748 digital_0._112_.RESET_B a_6012_2778# 0.15941f
C3749 digital_0.clkload0.A a_6012_2778# 0.03872f
C3750 a_6081_3737# a_6012_3866# 0.20964f
C3751 a_6012_3866# a_6226_3866# 0.09774f
C3752 a_6012_3866# digital_0._063_.B 0.02229f
C3753 digital_0._112_.Q a_6012_3866# 0.04302f
C3754 digital_0._113_.RESET_B a_6012_3866# 0.15941f
C3755 digital_0._116_.Q a_6012_3866# 0.01673f
C3756 digital_0.clkload0.A a_6012_3866# 0.01114f
C3757 digital_0._102_.D a_6046_5364# 0.08097f
C3758 a_6046_5364# digital_0._110_.Q 0.19068f
C3759 digital_0.clkload0.A a_6046_5364# 0.06293f
C3760 digital_0.hold24.X a_6046_5364# 0.06547f
C3761 digital_0.hold28.A a_6046_5364# 0.36492f
C3762 digital_0.load_slew17.A a_6046_5364# 0.02246f
C3763 digital_0._057_.D a_6075_1842# 0.18216f
C3764 digital_0._113_.D a_6075_1842# 0.01671f
C3765 digital_0._113_.Q a_6075_1842# 0.19479f
C3766 digital_0._114_.Q a_6075_1842# 0.08777f
C3767 digital_0.clkload0.A a_6075_1842# 0.03663f
C3768 digital_0.load_slew17.X a_6075_1842# 0.02868f
C3769 a_6081_2649# a_6226_2778# 0.05722f
C3770 a_6081_2649# a_6391_2412# 0.01379f
C3771 a_6081_2649# a_6644_2778# 0.04983f
C3772 digital_0._112_.D a_6081_2649# 0.03721f
C3773 digital_0._112_.Q a_6081_2649# 0.02968f
C3774 digital_0._112_.RESET_B a_6081_2649# 0.15227f
C3775 digital_0._113_.D a_6081_2649# 0.01345f
C3776 digital_0.clkload0.A a_6081_2649# 0.0383f
C3777 a_6081_3737# a_6226_3866# 0.05722f
C3778 a_6081_3737# a_6391_3500# 0.01379f
C3779 a_6081_3737# a_6644_3866# 0.04983f
C3780 a_6081_3737# digital_0._063_.B 0.03579f
C3781 digital_0._112_.Q a_6081_3737# 0.03367f
C3782 digital_0._113_.RESET_B a_6081_3737# 0.15227f
C3783 digital_0._116_.Q a_6081_3737# 0.0357f
C3784 digital_0.clkload0.A a_6081_3737# 0.01233f
C3785 a_6098_6904# a_6530_6904# 0.01515f
C3786 a_6098_6904# uio_out<2> 0.05631f
C3787 a_6098_6904# uio_out<4> 0.03865f
C3788 a_6160_4840# a_6438_4856# 0.12532f
C3789 a_6160_4840# a_6477_4730# 0.10232f
C3790 a_6160_4840# a_6564_4954# 0.05116f
C3791 digital_0._110_.Q a_6160_4840# 0.05048f
C3792 a_6160_4840# digital_0._110_.RESET_B 0.23011f
C3793 digital_0.clkload0.A a_6160_4840# 0.01422f
C3794 digital_0.load_slew17.A a_6160_4840# 0.02309f
C3795 digital_0.hold28.A a_6188_5171# 0.01002f
C3796 digital_0._112_.Q a_6226_2778# 0.02638f
C3797 digital_0._112_.RESET_B a_6226_2778# 0.0122f
C3798 digital_0._113_.RESET_B a_6226_3866# 0.0122f
C3799 digital_0._116_.Q a_6226_3866# 0.0283f
C3800 a_6280_5650# a_6406_5834# 0.34134f
C3801 a_6280_5650# digital_0.hold24.X 0.01182f
C3802 a_6280_5650# digital_0.hold28.A 0.01518f
C3803 a_6280_5650# digital_0.load_slew17.A 0.05892f
C3804 a_6280_5650# uio_out<3> 0.10475f
C3805 a_6343_2930# a_7253_2386# 0.01467f
C3806 digital_0._063_.A a_6343_2930# 0.15277f
C3807 digital_0._065_.A2_N a_6343_2930# 0.01442f
C3808 digital_0._069_.A a_6343_2930# 0.07827f
C3809 a_6343_2930# digital_0._112_.D 0.01208f
C3810 digital_0._112_.Q a_6343_2930# 0.03217f
C3811 digital_0._113_.D a_6343_2930# 0.03541f
C3812 digital_0._113_.Q a_6343_2930# 0.11853f
C3813 digital_0.clkbuf_1_1__f_clk.A a_6343_2930# 0.31527f
C3814 digital_0.clkload0.A a_6343_2930# 1.63614f
C3815 digital_0.input1.X a_6343_2930# 0.04636f
C3816 a_6343_2930# uio_out<6> 0.01603f
C3817 a_6372_1298# a_6498_1482# 0.34134f
C3818 digital_0.hold28.A a_6372_1298# 0.04085f
C3819 digital_0.output10.A a_6372_1298# 0.04042f
C3820 a_6372_1298# uio_out<6> 0.10697f
C3821 a_6406_5834# a_6646_5650# 0.11296f
C3822 a_6406_5834# digital_0.hold28.A 0.04305f
C3823 a_6406_5834# digital_0.load_slew17.A 0.05028f
C3824 a_6406_5834# uio_out<3> 0.0174f
C3825 a_6438_4856# a_6477_4730# 0.87953f
C3826 a_6438_4856# a_6564_4954# 0.18639f
C3827 a_6438_4856# a_6633_4825# 0.2298f
C3828 a_6438_4856# a_6778_4954# 0.03462f
C3829 a_6438_4856# a_7196_4954# 0.06418f
C3830 digital_0._067_.B a_6438_4856# 0.04654f
C3831 digital_0._110_.D a_6438_4856# 0.28168f
C3832 digital_0._110_.Q a_6438_4856# 0.04463f
C3833 digital_0._110_.RESET_B a_6438_4856# 0.0256f
C3834 a_6438_4856# digital_0.input1.X 0.03384f
C3835 digital_0._067_.B a_6457_4044# 0.1551f
C3836 digital_0._069_.A a_6457_4044# 0.04577f
C3837 digital_0._110_.Q a_6457_4044# 0.14651f
C3838 digital_0._110_.RESET_B a_6457_4044# 0.01901f
C3839 a_6475_5430# digital_0._067_.B 0.02078f
C3840 a_6475_5430# digital_0._110_.D 0.0229f
C3841 digital_0._110_.Q a_6475_5430# 0.10396f
C3842 digital_0.hold24.X a_6475_5430# 0.03924f
C3843 digital_0.hold28.A a_6475_5430# 0.22282f
C3844 a_6477_4730# a_6564_4954# 0.07009f
C3845 a_6477_4730# a_6633_4825# 0.11276f
C3846 a_6477_4730# a_7196_4954# 0.08638f
C3847 a_7529_5106# a_6477_4730# 0.01052f
C3848 a_6477_4730# a_7871_4616# 0.01758f
C3849 a_6477_4730# digital_0._065_.A2_N 0.02135f
C3850 digital_0._067_.B a_6477_4730# 0.03952f
C3851 digital_0._110_.D a_6477_4730# 0.16707f
C3852 digital_0._110_.Q a_6477_4730# 0.0417f
C3853 digital_0._110_.RESET_B a_6477_4730# 0.29517f
C3854 a_6477_4730# digital_0.input1.X 0.58278f
C3855 a_6498_1482# a_6738_1298# 0.11296f
C3856 digital_0.hold28.A a_6498_1482# 0.03853f
C3857 digital_0.output10.A a_6498_1482# 0.0456f
C3858 a_6498_1482# uio_out<6> 0.03049f
C3859 a_6530_6904# a_7388_6904# 0.04885f
C3860 a_6530_6904# uio_out<2> 0.02122f
C3861 a_6633_4825# a_6564_4954# 0.20964f
C3862 a_6564_4954# a_6778_4954# 0.09774f
C3863 digital_0._067_.B a_6564_4954# 0.01661f
C3864 digital_0._110_.Q a_6564_4954# 0.01009f
C3865 digital_0._110_.RESET_B a_6564_4954# 0.16613f
C3866 a_6631_1842# a_6575_1868# 0.27101f
C3867 a_6575_1868# a_7302_1868# 0.02551f
C3868 digital_0._063_.A a_6575_1868# 0.03053f
C3869 digital_0._113_.D a_6575_1868# 0.11811f
C3870 digital_0._113_.Q a_6575_1868# 0.02856f
C3871 digital_0._114_.Q a_6575_1868# 0.04965f
C3872 digital_0.load_slew17.X a_6575_1868# 0.14202f
C3873 a_6631_1842# a_6851_2188# 0.01892f
C3874 a_6631_1842# a_7302_1868# 0.15521f
C3875 digital_0._057_.D a_6631_1842# 0.05684f
C3876 digital_0._063_.A a_6631_1842# 0.19905f
C3877 a_6631_1842# digital_0._106_.RESET_B 0.01207f
C3878 digital_0._112_.D a_6631_1842# 0.01104f
C3879 digital_0._113_.D a_6631_1842# 0.20193f
C3880 digital_0._113_.Q a_6631_1842# 0.45f
C3881 digital_0._114_.Q a_6631_1842# 0.09812f
C3882 digital_0.load_slew17.X a_6631_1842# 0.10776f
C3883 a_6633_4825# a_6778_4954# 0.05722f
C3884 a_6633_4825# a_6943_4588# 0.01379f
C3885 a_6633_4825# a_7196_4954# 0.04983f
C3886 digital_0._067_.B a_6633_4825# 0.0178f
C3887 digital_0._110_.RESET_B a_6633_4825# 0.15328f
C3888 a_6633_4825# digital_0.input1.X 0.01298f
C3889 a_6636_19810# a_6636_19010# 0.0149f
C3890 digital_0._112_.D a_6644_2778# 0.18319f
C3891 digital_0._112_.Q a_6644_2778# 0.01619f
C3892 digital_0.clkload0.A a_6644_2778# 0.01378f
C3893 a_6644_3866# digital_0._063_.B 0.02188f
C3894 digital_0._112_.Q a_6644_3866# 0.01373f
C3895 digital_0._113_.D a_6644_3866# 0.17079f
C3896 digital_0._116_.Q a_6644_3866# 0.01625f
C3897 a_6646_5650# a_6939_5676# 0.08501f
C3898 a_6646_5650# digital_0.hold28.A 0.07923f
C3899 a_6646_5650# digital_0.load_slew17.A 0.05256f
C3900 a_6646_5650# digital_0.output8.A 0.2107f
C3901 a_6646_5650# uio_out<3> 0.01316f
C3902 a_6738_1298# a_7009_1324# 0.14228f
C3903 digital_0.hold28.A a_6738_1298# 0.03941f
C3904 digital_0.output10.A a_6738_1298# 0.05432f
C3905 digital_0.output11.A a_6738_1298# 0.2312f
C3906 a_6738_1298# uio_out<6> 0.02581f
C3907 digital_0._110_.RESET_B a_6778_4954# 0.0122f
C3908 digital_0._057_.D a_6851_2188# 0.06224f
C3909 digital_0._063_.A a_6851_2188# 0.03973f
C3910 digital_0._113_.D a_6851_2188# 0.08678f
C3911 digital_0._113_.Q a_6851_2188# 0.1402f
C3912 a_6939_5676# a_7175_5676# 0.22264f
C3913 a_6939_5676# digital_0._067_.B 0.02069f
C3914 a_6939_5676# digital_0.hold28.A 0.04232f
C3915 a_6939_5676# digital_0.load_slew17.A 0.05435f
C3916 digital_0.output8.A a_6939_5676# 0.2967f
C3917 a_6939_5676# uio_out<3> 0.01332f
C3918 a_6968_4276# digital_0._063_.A 0.12815f
C3919 digital_0._065_.A2_N a_6968_4276# 0.23344f
C3920 digital_0._069_.A a_6968_4276# 0.12215f
C3921 digital_0._110_.Q a_6968_4276# 0.06036f
C3922 a_6968_4276# digital_0._112_.Q 0.14687f
C3923 digital_0.input1.X a_6968_4276# 0.05464f
C3924 a_7009_1324# a_7226_1324# 0.11296f
C3925 digital_0.hold28.A a_7009_1324# 0.02815f
C3926 digital_0.output10.A a_7009_1324# 0.21927f
C3927 digital_0.output11.A a_7009_1324# 0.05536f
C3928 a_7009_1324# uio_out<6> 0.02661f
C3929 digital_0._067_.A a_7025_5132# 0.09606f
C3930 digital_0._067_.B a_7025_5132# 0.05839f
C3931 digital_0._110_.D a_7025_5132# 0.21477f
C3932 a_7148_11234# a_7364_11234# 0.01515f
C3933 a_7148_11234# a_8228_11234# 0.0381f
C3934 a_7175_5676# a_7281_5676# 0.41909f
C3935 a_7175_5676# digital_0._067_.A 0.01288f
C3936 a_7175_5676# digital_0.hold28.A 0.07125f
C3937 a_7175_5676# digital_0.load_slew17.A 0.07848f
C3938 digital_0.output8.A a_7175_5676# 0.01092f
C3939 a_7175_5676# uio_out<3> 0.01643f
C3940 digital_0._110_.D a_7196_4954# 0.16124f
C3941 a_7196_4954# digital_0.input1.X 0.02185f
C3942 a_7226_1324# a_7337_1324# 0.34134f
C3943 digital_0.hold28.A a_7226_1324# 0.02479f
C3944 digital_0.output11.A a_7226_1324# 0.04489f
C3945 a_7226_1324# uio_out<6> 0.03178f
C3946 a_7253_2386# a_7745_2412# 0.03366f
C3947 digital_0._063_.A a_7253_2386# 0.01783f
C3948 digital_0._112_.Q a_7253_2386# 0.15246f
C3949 digital_0._113_.Q a_7253_2386# 0.03324f
C3950 digital_0._114_.Q a_7253_2386# 0.05501f
C3951 digital_0.clkload0.A a_7253_2386# 0.29151f
C3952 a_7253_2386# digital_0.clkload0.X 0.3277f
C3953 digital_0.input1.X a_7253_2386# 0.03529f
C3954 a_7281_5676# digital_0.hold20.X 0.13551f
C3955 a_7281_5676# digital_0.hold28.A 0.06142f
C3956 a_7281_5676# digital_0.load_slew17.A 0.04995f
C3957 a_7281_5676# uio_out<3> 0.01265f
C3958 digital_0._063_.A a_7302_1868# 0.01995f
C3959 digital_0._113_.Q a_7302_1868# 0.02112f
C3960 digital_0.load_slew17.X a_7302_1868# 0.1139f
C3961 digital_0.output11.A a_7302_1868# 0.01364f
C3962 digital_0.hold28.A a_7337_1324# 0.02315f
C3963 digital_0.output11.A a_7337_1324# 0.06953f
C3964 a_7337_1324# uio_out<5> 0.09046f
C3965 a_7337_1324# uio_out<6> 0.02158f
C3966 a_7364_11234# a_7796_11234# 0.14233f
C3967 a_7385_3750# digital_0._063_.B 0.09493f
C3968 digital_0._065_.A2_N a_7385_3750# 0.23515f
C3969 digital_0._069_.A a_7385_3750# 0.03427f
C3970 digital_0._112_.Q a_7385_3750# 0.07183f
C3971 digital_0._116_.Q a_7385_3750# 0.11782f
C3972 a_7388_6904# a_7604_6904# 0.01515f
C3973 a_7388_6904# uio_out<2> 0.0193f
C3974 a_7529_5106# a_7816_5264# 0.23366f
C3975 a_7529_5106# a_8094_5248# 0.04251f
C3976 a_7529_5106# a_8133_5374# 0.04348f
C3977 digital_0._067_.A a_7529_5106# 0.08334f
C3978 digital_0._103_.RESET_B a_7529_5106# 0.27546f
C3979 digital_0._111_.Q a_7529_5106# 0.01945f
C3980 a_7529_5106# digital_0.input1.X 0.0102f
C3981 digital_0.output8.A a_7529_5106# 0.10334f
C3982 digital_0._065_.A2_N a_7547_4018# 0.18087f
C3983 digital_0._069_.A a_7547_4018# 0.08146f
C3984 digital_0._110_.Q a_7547_4018# 0.1842f
C3985 digital_0._111_.Q a_7547_4018# 0.09446f
C3986 digital_0._112_.Q a_7547_4018# 0.02786f
C3987 digital_0.input1.X a_7547_4018# 0.04179f
C3988 a_7604_6904# a_8036_6904# 0.14233f
C3989 a_7604_6904# uio_out<2> 0.02922f
C3990 a_7604_6904# uio_out<4> 0.03865f
C3991 a_7695_6003# digital_0._103_.RESET_B 0.01104f
C3992 a_7695_6003# digital_0._111_.Q 0.10192f
C3993 digital_0.hold20.X a_7695_6003# 0.22687f
C3994 digital_0.hold28.A a_7695_6003# 0.23122f
C3995 digital_0.load_slew17.A a_7695_6003# 0.04186f
C3996 digital_0._057_.D a_7745_2412# 0.10953f
C3997 digital_0._060_.A_N a_7745_2412# 0.11444f
C3998 digital_0._065_.A2_N a_7745_2412# 0.08028f
C3999 digital_0._069_.A a_7745_2412# 0.15376f
C4000 digital_0._112_.Q a_7745_2412# 0.21804f
C4001 digital_0._114_.Q a_7745_2412# 0.03347f
C4002 digital_0.clkload0.A a_7745_2412# 0.07585f
C4003 a_7767_1324# a_8003_1324# 0.22264f
C4004 digital_0.hold28.A a_7767_1324# 0.04551f
C4005 digital_0.output11.A a_7767_1324# 0.30019f
C4006 a_7767_1324# uio_out<5> 0.13269f
C4007 a_7767_1324# uio_out<6> 0.04134f
C4008 a_7796_11234# a_8228_11234# 0.01515f
C4009 a_7816_5264# a_8094_5248# 0.12532f
C4010 a_7816_5264# a_8133_5374# 0.10236f
C4011 a_7816_5264# a_8220_5132# 0.05116f
C4012 digital_0._103_.RESET_B a_7816_5264# 0.23669f
C4013 digital_0._111_.Q a_7816_5264# 0.02563f
C4014 a_7820_8824# a_8252_8824# 0.21349f
C4015 a_7871_4616# digital_0._065_.A2_N 0.04936f
C4016 digital_0._067_.A a_7871_4616# 0.17951f
C4017 digital_0._069_.A a_7871_4616# 0.18407f
C4018 digital_0._110_.Q a_7871_4616# 0.09101f
C4019 digital_0._111_.Q a_7871_4616# 0.05623f
C4020 a_8336_18210# a_7886_17860# 0.01328f
C4021 a_7949_6003# digital_0._103_.D 0.08235f
C4022 a_7949_6003# digital_0._111_.Q 0.19245f
C4023 a_7949_6003# digital_0.hold20.X 0.0578f
C4024 a_7949_6003# digital_0.hold28.A 0.31844f
C4025 a_7949_6003# digital_0.load_slew17.A 0.06939f
C4026 a_7949_6003# uio_out<3> 0.01157f
C4027 a_8081_1842# a_8003_1324# 0.01537f
C4028 a_8003_1324# a_8109_1324# 0.41909f
C4029 digital_0.hold28.A a_8003_1324# 0.06614f
C4030 digital_0.output11.A a_8003_1324# 0.01211f
C4031 a_8003_1324# uio_out<5> 0.05786f
C4032 a_8003_1324# uio_out<6> 0.07642f
C4033 a_8036_6904# a_8468_6904# 0.14233f
C4034 a_8036_6904# uio_out<2> 0.02922f
C4035 a_8036_6904# uio_out<4> 0.03865f
C4036 a_8081_1842# a_8368_2000# 0.23366f
C4037 a_8081_1842# a_8646_1984# 0.04251f
C4038 a_8081_1842# a_8685_2110# 0.04359f
C4039 digital_0._057_.D a_8081_1842# 0.0192f
C4040 a_8081_1842# digital_0._106_.RESET_B 0.33297f
C4041 digital_0.load_slew17.X a_8081_1842# 0.07847f
C4042 a_8081_1842# digital_0.output11.A 0.10199f
C4043 a_8081_1842# uio_out<6> 0.01617f
C4044 a_8081_4018# a_8368_4176# 0.23366f
C4045 a_8081_4018# a_8646_4160# 0.04206f
C4046 a_8081_4018# a_8685_4286# 0.04358f
C4047 digital_0._067_.A a_8081_4018# 0.01082f
C4048 digital_0._069_.A a_8081_4018# 0.02029f
C4049 digital_0._111_.Q a_8081_4018# 0.12856f
C4050 digital_0._111_.RESET_B a_8081_4018# 0.27934f
C4051 digital_0.input1.X a_8081_4018# 0.06197f
C4052 a_8081_4018# uio_out<6> 0.01091f
C4053 a_8133_5374# a_8094_5248# 0.90596f
C4054 a_8094_5248# a_8220_5132# 0.18639f
C4055 a_8094_5248# a_8289_5106# 0.2298f
C4056 a_8094_5248# a_8434_5132# 0.03462f
C4057 a_8094_5248# a_8852_5132# 0.06418f
C4058 digital_0._103_.D a_8094_5248# 0.23454f
C4059 digital_0._103_.RESET_B a_8094_5248# 0.02906f
C4060 digital_0._111_.Q a_8094_5248# 0.01035f
C4061 a_8094_5248# uio_out<5> 0.01122f
C4062 a_8109_1324# digital_0.hold21.X 0.1356f
C4063 digital_0.hold28.A a_8109_1324# 0.06789f
C4064 a_8109_1324# uio_out<5> 0.05222f
C4065 a_8109_1324# uio_out<6> 0.07503f
C4066 a_8133_5374# a_8220_5132# 0.07009f
C4067 a_8133_5374# a_8289_5106# 0.11053f
C4068 a_8133_5374# a_8739_4910# 0.01118f
C4069 a_8133_5374# a_8852_5132# 0.08968f
C4070 digital_0._103_.D a_8133_5374# 0.28907f
C4071 digital_0._103_.RESET_B a_8133_5374# 0.30279f
C4072 digital_0._111_.Q a_8133_5374# 0.0202f
C4073 digital_0.clkload0.A a_8133_5374# 0.25364f
C4074 a_8133_5374# uio_out<5> 0.01257f
C4075 a_8289_5106# a_8220_5132# 0.20964f
C4076 a_8220_5132# a_8434_5132# 0.09774f
C4077 digital_0._103_.D a_8220_5132# 0.01402f
C4078 digital_0._103_.RESET_B a_8220_5132# 0.16835f
C4079 a_8228_11234# a_9218_11234# 0.04183f
C4080 a_8252_8824# a_8684_8824# 0.21349f
C4081 a_8289_5106# a_8434_5132# 0.05722f
C4082 a_8289_5106# a_8599_5498# 0.01379f
C4083 a_8289_5106# a_8852_5132# 0.04983f
C4084 digital_0._103_.D a_8289_5106# 0.03997f
C4085 digital_0._103_.RESET_B a_8289_5106# 0.157f
C4086 a_8552_19568# a_8336_19010# 0.01519f
C4087 a_8368_2000# a_8646_1984# 0.12532f
C4088 a_8368_2000# a_8685_2110# 0.10236f
C4089 a_8368_2000# a_8772_1868# 0.05116f
C4090 a_8368_2000# digital_0._106_.RESET_B 0.23197f
C4091 digital_0._114_.Q a_8368_2000# 0.01523f
C4092 digital_0.load_slew17.X a_8368_2000# 0.05733f
C4093 a_8368_2000# uio_out<5> 0.011f
C4094 a_8368_4176# a_8646_4160# 0.12499f
C4095 a_8368_4176# a_8685_4286# 0.10236f
C4096 a_8368_4176# a_8772_4044# 0.05116f
C4097 digital_0._111_.RESET_B a_8368_4176# 0.23459f
C4098 digital_0.input1.X a_8368_4176# 0.07247f
C4099 a_8389_3276# a_8389_2956# 0.06889f
C4100 digital_0._065_.A2_N a_8389_2956# 0.05724f
C4101 digital_0._069_.A a_8389_2956# 0.09902f
C4102 digital_0._112_.Q a_8389_2956# 0.05323f
C4103 digital_0._113_.Q a_8389_2956# 0.03678f
C4104 a_8389_3276# a_8555_3276# 0.01408f
C4105 a_8735_3474# a_8389_3276# 0.02665f
C4106 a_8389_3276# digital_0._060_.B 0.14334f
C4107 digital_0._065_.A2_N a_8389_3276# 0.07749f
C4108 digital_0._069_.A a_8389_3276# 0.02944f
C4109 digital_0._112_.Q a_8389_3276# 0.03684f
C4110 digital_0._113_.Q a_8389_3276# 0.03129f
C4111 digital_0._114_.Q a_8389_3276# 0.16072f
C4112 digital_0.load_slew17.X a_8389_3276# 0.03163f
C4113 a_8389_3276# uio_out<5> 0.01049f
C4114 digital_0._103_.RESET_B a_8434_5132# 0.01264f
C4115 a_8468_6904# a_8900_6904# 0.14233f
C4116 a_8468_6904# uio_out<2> 0.02922f
C4117 a_8468_6904# uio_out<4> 0.03865f
C4118 a_8552_20648# a_8552_19568# 0.0381f
C4119 a_8552_19568# a_9734_18926# 0.01541f
C4120 a_8552_20648# uio_out<5> 0.01005f
C4121 a_8552_20648# uio_out<7> 0.01718f
C4122 a_8739_4910# a_8573_4588# 0.04867f
C4123 digital_0._065_.A2_N a_8573_4588# 0.04285f
C4124 digital_0._067_.A a_8573_4588# 0.05273f
C4125 digital_0._069_.A a_8573_4588# 0.01725f
C4126 digital_0._111_.Q a_8573_4588# 0.0635f
C4127 digital_0._114_.Q a_8615_1651# 0.10785f
C4128 digital_0.hold21.X a_8615_1651# 0.11721f
C4129 digital_0.hold28.A a_8615_1651# 0.24806f
C4130 a_8615_1651# uio_out<5> 0.01557f
C4131 a_8615_1651# uio_out<6> 0.0103f
C4132 a_8685_2110# a_8646_1984# 0.71139f
C4133 a_8646_1984# a_8772_1868# 0.17589f
C4134 a_8817_2386# a_8646_1984# 0.01571f
C4135 a_8646_1984# a_8841_1842# 0.21986f
C4136 a_8646_1984# a_8986_1868# 0.03462f
C4137 a_8646_1984# a_9404_1868# 0.06418f
C4138 digital_0._060_.B a_8646_1984# 0.02586f
C4139 a_8646_1984# digital_0._106_.D 0.28157f
C4140 digital_0._106_.RESET_B a_8646_1984# 0.025f
C4141 digital_0._114_.Q a_8646_1984# 0.03081f
C4142 digital_0.load_slew17.X a_8646_1984# 0.34377f
C4143 a_8646_1984# uio_out<5> 0.01132f
C4144 a_8685_4286# a_8646_4160# 0.58439f
C4145 a_8646_4160# a_8772_4044# 0.17589f
C4146 a_8646_4160# a_8841_4018# 0.21963f
C4147 a_8646_4160# a_8986_4044# 0.03462f
C4148 a_8646_4160# a_9404_4044# 0.06121f
C4149 digital_0._111_.D a_8646_4160# 0.21216f
C4150 digital_0._111_.RESET_B a_8646_4160# 0.02764f
C4151 digital_0._116_.Q a_8646_4160# 0.03574f
C4152 digital_0.clkload0.A a_8646_4160# 0.0398f
C4153 digital_0.input1.X a_8646_4160# 0.5984f
C4154 a_8684_8824# a_9116_8824# 0.21349f
C4155 a_8685_2110# a_8772_1868# 0.05348f
C4156 a_8685_2110# a_8841_1842# 0.11104f
C4157 a_8685_2110# a_9404_1868# 0.09313f
C4158 digital_0._060_.A_N a_8685_2110# 0.01437f
C4159 digital_0._060_.B a_8685_2110# 0.02059f
C4160 a_8685_2110# digital_0._106_.D 0.17578f
C4161 digital_0._106_.RESET_B a_8685_2110# 0.29575f
C4162 digital_0._114_.Q a_8685_2110# 0.02565f
C4163 digital_0.clkload0.A a_8685_2110# 0.26106f
C4164 digital_0.load_slew17.X a_8685_2110# 0.34076f
C4165 a_8685_2110# uio_out<5> 0.0138f
C4166 a_8685_4286# a_8735_3474# 0.02154f
C4167 a_8685_4286# a_8772_4044# 0.05348f
C4168 a_8685_4286# a_8841_4018# 0.11067f
C4169 a_8685_4286# a_9404_4044# 0.09016f
C4170 digital_0._111_.D a_8685_4286# 0.16301f
C4171 digital_0._111_.Q a_8685_4286# 0.01316f
C4172 digital_0._111_.RESET_B a_8685_4286# 0.30569f
C4173 digital_0._116_.Q a_8685_4286# 0.04863f
C4174 digital_0.clkload0.A a_8685_4286# 0.03523f
C4175 digital_0.input1.X a_8685_4286# 0.85093f
C4176 a_8685_4286# uio_out<5> 0.01116f
C4177 a_8841_4018# a_8735_3474# 0.01201f
C4178 a_8735_3474# a_9217_2956# 0.01168f
C4179 a_8735_3474# a_9434_2956# 0.01771f
C4180 a_8735_3474# a_9545_2956# 0.01256f
C4181 a_8735_3474# clk 0.32451f
C4182 digital_0._065_.A2_N a_8735_3474# 0.02293f
C4183 a_8735_3474# digital_0._114_.Q 0.01113f
C4184 digital_0._116_.Q a_8735_3474# 0.22559f
C4185 a_8735_3474# digital_0.clkbuf_1_1__f_clk.A 1.7641f
C4186 digital_0.clkload0.A a_8735_3474# 0.03468f
C4187 digital_0.load_slew15.A a_8735_3474# 0.10404f
C4188 digital_0.load_slew17.X a_8735_3474# 0.04199f
C4189 a_8735_3474# uio_out<5> 0.01668f
C4190 a_8793_4562# a_8739_4910# 0.27272f
C4191 digital_0._065_.A2_N a_8739_4910# 0.03186f
C4192 digital_0._069_.A a_8739_4910# 0.1628f
C4193 a_8739_4910# digital_0._111_.D 0.13689f
C4194 digital_0._111_.Q a_8739_4910# 0.14549f
C4195 a_8739_4910# digital_0._111_.RESET_B 0.01815f
C4196 digital_0.clkload0.A a_8739_4910# 0.02183f
C4197 digital_0.load_slew17.A a_8739_4910# 0.01558f
C4198 a_8841_1842# a_8772_1868# 0.20964f
C4199 a_8772_1868# a_8986_1868# 0.09774f
C4200 digital_0._106_.RESET_B a_8772_1868# 0.16611f
C4201 digital_0._114_.Q a_8772_1868# 0.01652f
C4202 digital_0.load_slew17.X a_8772_1868# 0.04773f
C4203 a_8841_4018# a_8772_4044# 0.20964f
C4204 a_8772_4044# a_8986_4044# 0.09774f
C4205 digital_0._111_.RESET_B a_8772_4044# 0.17458f
C4206 digital_0.input1.X a_8772_4044# 0.04358f
C4207 a_8793_4562# digital_0._065_.A2_N 0.17239f
C4208 digital_0._069_.A a_8793_4562# 0.07268f
C4209 digital_0._111_.Q a_8793_4562# 0.09477f
C4210 a_8793_4562# digital_0._111_.RESET_B 0.01417f
C4211 a_8817_2386# a_8841_1842# 0.01024f
C4212 a_8817_2386# a_9104_2664# 0.23366f
C4213 a_8817_2386# a_9382_2680# 0.04251f
C4214 a_8817_2386# a_9421_2554# 0.04359f
C4215 digital_0._060_.A_N a_8817_2386# 0.0923f
C4216 digital_0._060_.B a_8817_2386# 0.02474f
C4217 digital_0._114_.Q a_8817_2386# 0.12191f
C4218 digital_0._114_.RESET_B a_8817_2386# 0.26934f
C4219 digital_0.clkload0.A a_8817_2386# 0.06264f
C4220 digital_0.load_slew17.X a_8817_2386# 0.01558f
C4221 a_8841_1842# a_8986_1868# 0.05722f
C4222 a_8841_1842# a_9151_2234# 0.01379f
C4223 a_8841_1842# a_9404_1868# 0.04983f
C4224 digital_0._060_.B a_8841_1842# 0.01098f
C4225 digital_0._106_.RESET_B a_8841_1842# 0.15327f
C4226 digital_0._114_.Q a_8841_1842# 0.01244f
C4227 digital_0.load_slew17.X a_8841_1842# 0.04534f
C4228 a_8841_4018# a_8986_4044# 0.05722f
C4229 a_8841_4018# a_9151_4410# 0.01379f
C4230 a_8841_4018# a_9404_4044# 0.04983f
C4231 digital_0._111_.RESET_B a_8841_4018# 0.15779f
C4232 digital_0.clkload0.A a_8841_4018# 0.01894f
C4233 digital_0.input1.X a_8841_4018# 0.03365f
C4234 digital_0._103_.D a_8852_5132# 0.18336f
C4235 digital_0._060_.B a_8869_1651# 0.03878f
C4236 digital_0._106_.D a_8869_1651# 0.08019f
C4237 digital_0._114_.Q a_8869_1651# 0.19386f
C4238 a_8869_1651# digital_0.hold21.X 0.0578f
C4239 digital_0.hold28.A a_8869_1651# 0.37603f
C4240 a_8900_6904# a_9332_6904# 0.14233f
C4241 a_8900_6904# uio_out<2> 0.02922f
C4242 a_8900_6904# uio_out<4> 0.03865f
C4243 digital_0._106_.RESET_B a_8986_1868# 0.0122f
C4244 digital_0._111_.RESET_B a_8986_4044# 0.0122f
C4245 a_9104_2664# a_9382_2680# 0.12532f
C4246 a_9104_2664# a_9421_2554# 0.10236f
C4247 a_9104_2664# a_9508_2778# 0.05116f
C4248 digital_0._060_.A_N a_9104_2664# 0.04191f
C4249 digital_0._114_.RESET_B a_9104_2664# 0.21442f
C4250 digital_0.clkload0.A a_9104_2664# 0.06764f
C4251 digital_0.load_slew17.X a_9104_2664# 0.01685f
C4252 a_9116_8824# a_9548_8824# 0.21349f
C4253 a_9116_8824# uio_out<7> 0.01246f
C4254 a_9217_2956# a_9382_2680# 0.01331f
C4255 a_9217_2956# a_9434_2956# 0.11296f
C4256 a_9217_2956# digital_0._060_.B 0.0123f
C4257 digital_0.clkload0.A a_9217_2956# 0.02558f
C4258 digital_0.load_slew17.X a_9217_2956# 0.22317f
C4259 a_9218_11234# a_9434_11234# 0.01515f
C4260 a_9218_11234# uio_out<7> 0.01006f
C4261 a_9332_6904# a_9764_6904# 0.14233f
C4262 a_9332_6904# uio_out<2> 0.02922f
C4263 a_9332_6904# uio_out<4> 0.03867f
C4264 a_9382_2680# a_9421_2554# 0.72771f
C4265 a_9382_2680# a_9508_2778# 0.17589f
C4266 a_9382_2680# a_9577_2649# 0.21986f
C4267 a_9382_2680# a_9722_2778# 0.03462f
C4268 digital_0._060_.A_N a_9382_2680# 0.05119f
C4269 a_9382_2680# digital_0._114_.D 0.22225f
C4270 digital_0._114_.RESET_B a_9382_2680# 0.05072f
C4271 digital_0.clkload0.A a_9382_2680# 0.34733f
C4272 digital_0.input1.X a_9382_2680# 0.01523f
C4273 digital_0.input2.X a_9382_2680# 0.02778f
C4274 digital_0.load_slew15.A a_9382_2680# 0.0113f
C4275 digital_0.load_slew15.X a_9382_2680# 0.03256f
C4276 digital_0._106_.D a_9404_1868# 0.16124f
C4277 digital_0._111_.D a_9404_4044# 0.16138f
C4278 digital_0.input1.X a_9404_4044# 0.01378f
C4279 a_9417_4838# digital_0._111_.RESET_B 0.15292f
C4280 digital_0._116_.Q a_9417_4838# 0.11413f
C4281 digital_0.load_slew17.A a_9417_4838# 0.06209f
C4282 a_9421_2554# a_9508_2778# 0.05348f
C4283 a_9421_2554# a_9577_2649# 0.10687f
C4284 digital_0._060_.A_N a_9421_2554# 0.0892f
C4285 a_9421_2554# digital_0._114_.D 0.21987f
C4286 digital_0._114_.RESET_B a_9421_2554# 0.31949f
C4287 digital_0.clkload0.A a_9421_2554# 0.32466f
C4288 digital_0.input1.X a_9421_2554# 0.27488f
C4289 digital_0.input2.X a_9421_2554# 0.02991f
C4290 digital_0.load_slew15.A a_9421_2554# 0.01003f
C4291 digital_0.load_slew15.X a_9421_2554# 0.046f
C4292 digital_0.load_slew17.X a_9421_2554# 0.01028f
C4293 a_9434_11234# a_9866_11234# 0.14233f
C4294 a_9434_11234# uio_out<7> 0.01425f
C4295 a_9434_2956# a_9545_2956# 0.34134f
C4296 digital_0.clkload0.A a_9434_2956# 0.01896f
C4297 digital_0.load_slew17.X a_9434_2956# 0.02336f
C4298 a_9577_2649# a_9508_2778# 0.20964f
C4299 a_9508_2778# a_9722_2778# 0.09774f
C4300 digital_0._060_.A_N a_9508_2778# 0.02268f
C4301 digital_0._114_.RESET_B a_9508_2778# 0.16893f
C4302 digital_0.clkload0.A a_9508_2778# 0.05511f
C4303 a_9545_2956# digital_0._114_.RESET_B 0.02681f
C4304 digital_0._116_.Q a_9545_2956# 0.02163f
C4305 digital_0.clkload0.A a_9545_2956# 0.01027f
C4306 digital_0.load_slew15.A a_9545_2956# 0.10984f
C4307 digital_0.load_slew17.X a_9545_2956# 0.0197f
C4308 a_9548_8824# a_9980_8824# 0.21349f
C4309 a_9548_8824# uio_out<7> 0.01995f
C4310 a_9577_2649# a_9722_2778# 0.05722f
C4311 a_9577_2649# a_9887_2412# 0.01379f
C4312 digital_0._060_.A_N a_9577_2649# 0.04713f
C4313 digital_0._114_.RESET_B a_9577_2649# 0.16228f
C4314 digital_0.clkload0.A a_9577_2649# 0.04177f
C4315 a_9677_1690# a_9862_1690# 0.18284f
C4316 digital_0._060_.A_N a_9677_1690# 0.21739f
C4317 digital_0._060_.B a_9677_1690# 0.12037f
C4318 digital_0.hold28.A a_9677_1690# 0.03595f
C4319 digital_0._114_.RESET_B a_9722_2778# 0.02006f
C4320 a_9734_17074# a_9738_16810# 0.05091f
C4321 a_9734_18126# a_9734_17874# 0.05415f
C4322 a_9764_6904# uio_out<2> 0.02924f
C4323 a_9764_6904# uio_out<4> 0.03871f
C4324 a_9764_6904# uio_out<7> 0.01414f
C4325 digital_0._060_.A_N a_9862_1690# 0.05057f
C4326 digital_0._060_.B a_9862_1690# 0.20723f
C4327 digital_0._114_.D a_9862_1690# 0.11686f
C4328 digital_0.hold28.A a_9862_1690# 0.07162f
C4329 digital_0.load_slew15.X a_9862_1690# 0.02441f
C4330 a_9862_1690# uio_out<7> 0.01077f
C4331 digital_0._060_.A_N a_9969_2956# 0.06276f
C4332 digital_0._114_.RESET_B a_9969_2956# 0.15798f
C4333 digital_0._116_.Q a_9969_2956# 0.08964f
C4334 digital_0.input2.X a_9969_2956# 0.01646f
C4335 digital_0.load_slew15.A a_9969_2956# 0.10021f
C4336 a_9980_8824# uio_out<7> 0.03092f
C4337 digital_0._069_.A clk 0.15221f
C4338 digital_0._100_.D clk 0.01981f
C4339 digital_0._100_.RESET_B clk 0.05988f
C4340 digital_0._101_.RESET_B clk 0.04204f
C4341 digital_0._108_.D clk 0.04255f
C4342 digital_0._108_.Q clk 0.08955f
C4343 digital_0._108_.RESET_B clk 0.14285f
C4344 digital_0._109_.D clk 0.04646f
C4345 digital_0._109_.Q clk 0.09772f
C4346 digital_0._109_.RESET_B clk 0.06624f
C4347 digital_0._116_.Q clk 0.19461f
C4348 digital_0._117_.RESET_B clk 0.02719f
C4349 digital_0._118_.RESET_B clk 0.03859f
C4350 digital_0.clkbuf_1_0__f_clk.X clk 0.08199f
C4351 digital_0.clkbuf_1_1__f_clk.A clk 0.08325f
C4352 digital_0.hold19.X clk 0.04535f
C4353 digital_0.hold25.X clk 0.05023f
C4354 digital_0.hold28.A clk 0.12393f
C4355 digital_0.input1.X clk 0.06462f
C4356 digital_0.load_slew15.A clk 0.26639f
C4357 digital_0.load_slew15.X clk 0.23626f
C4358 digital_0.load_slew17.X clk 0.02208f
C4359 digital_0.output13.A clk 0.09547f
C4360 digital_0.output4.A clk 0.04168f
C4361 digital_0.output5.A clk 0.04403f
C4362 clk ena 0.03102f
C4363 rst_n clk 0.40096f
C4364 ui_in<0> clk 1.82722f
C4365 ui_in<1> clk 0.07374f
C4366 uio_out<0> clk 0.04168f
C4367 clk uio_out<1> 0.15458f
C4368 uio_out<2> clk 0.01188f
C4369 uio_out<3> clk 0.13157f
C4370 clk uio_out<7> 0.12948f
C4371 uo_out<0> clk 0.35692f
C4372 uo_out<1> clk 1.00199f
C4373 digital_0._060_.A_N digital_0._057_.D 0.0102f
C4374 digital_0._063_.A digital_0._057_.D 0.03085f
C4375 digital_0._065_.A2_N digital_0._057_.D 0.19574f
C4376 digital_0._057_.D digital_0._106_.RESET_B 0.1952f
C4377 digital_0._113_.D digital_0._057_.D 0.05052f
C4378 digital_0._113_.Q digital_0._057_.D 0.83281f
C4379 digital_0._114_.Q digital_0._057_.D 0.1217f
C4380 digital_0.clkload0.A digital_0._057_.D 0.07254f
C4381 digital_0.load_slew17.X digital_0._057_.D 0.08998f
C4382 digital_0._057_.D digital_0.output11.A 0.01745f
C4383 digital_0._057_.D uio_out<6> 0.01296f
C4384 digital_0._060_.A_N digital_0._060_.B 0.23709f
C4385 digital_0._065_.A2_N digital_0._060_.A_N 0.28392f
C4386 digital_0._060_.A_N digital_0._106_.D 0.0378f
C4387 digital_0._060_.A_N digital_0._107_.RESET_B 0.01882f
C4388 digital_0._112_.Q digital_0._060_.A_N 0.02707f
C4389 digital_0._060_.A_N digital_0._114_.D 0.2278f
C4390 digital_0._114_.Q digital_0._060_.A_N 0.41411f
C4391 digital_0._060_.A_N digital_0._114_.RESET_B 0.56493f
C4392 digital_0._060_.A_N digital_0._115_.D 0.06145f
C4393 digital_0._115_.Q digital_0._060_.A_N 0.51122f
C4394 digital_0._115_.RESET_B digital_0._060_.A_N 0.04698f
C4395 digital_0._116_.Q digital_0._060_.A_N 0.21917f
C4396 digital_0.clkbuf_1_1__f_clk.A digital_0._060_.A_N 0.01683f
C4397 digital_0.clkload0.A digital_0._060_.A_N 0.44309f
C4398 digital_0.hold28.A digital_0._060_.A_N 0.319f
C4399 digital_0.input2.X digital_0._060_.A_N 0.15931f
C4400 digital_0.load_slew15.A digital_0._060_.A_N 0.12024f
C4401 digital_0.load_slew15.X digital_0._060_.A_N 0.15303f
C4402 digital_0.load_slew17.X digital_0._060_.A_N 0.10855f
C4403 digital_0._060_.A_N uio_out<5> 0.01274f
C4404 digital_0._060_.A_N uio_out<7> 0.01621f
C4405 digital_0._060_.B digital_0._106_.D 0.23259f
C4406 digital_0._060_.B digital_0._106_.RESET_B 0.03316f
C4407 digital_0._060_.B digital_0._114_.D 0.03251f
C4408 digital_0._114_.Q digital_0._060_.B 0.34891f
C4409 digital_0._060_.B digital_0._114_.RESET_B 0.01056f
C4410 digital_0.clkload0.A digital_0._060_.B 0.0287f
C4411 digital_0.hold28.A digital_0._060_.B 0.22298f
C4412 digital_0.load_slew17.X digital_0._060_.B 0.27403f
C4413 digital_0._060_.B uio_out<5> 0.01515f
C4414 digital_0._063_.A digital_0._063_.B 0.10792f
C4415 digital_0._065_.A2_N digital_0._063_.A 0.01725f
C4416 digital_0._067_.B digital_0._063_.A 0.05164f
C4417 digital_0._069_.A digital_0._063_.A 0.05653f
C4418 digital_0._110_.Q digital_0._063_.A 0.05077f
C4419 digital_0._063_.A digital_0._112_.D 0.06733f
C4420 digital_0._063_.A digital_0._112_.Q 0.04419f
C4421 digital_0._063_.A digital_0._113_.D 0.26285f
C4422 digital_0._063_.A digital_0._113_.Q 0.67609f
C4423 digital_0._063_.A digital_0._114_.Q 0.33693f
C4424 digital_0._116_.Q digital_0._063_.A 0.02243f
C4425 digital_0.clkload0.A digital_0._063_.A 0.57774f
C4426 digital_0.input1.X digital_0._063_.A 0.66668f
C4427 digital_0.load_slew17.X digital_0._063_.A 0.09461f
C4428 digital_0._065_.A2_N digital_0._063_.B 0.07695f
C4429 digital_0._069_.A digital_0._063_.B 0.07845f
C4430 digital_0._063_.B digital_0._112_.D 0.22726f
C4431 digital_0._112_.Q digital_0._063_.B 0.19593f
C4432 digital_0._113_.D digital_0._063_.B 0.20707f
C4433 digital_0._113_.Q digital_0._063_.B 0.11351f
C4434 digital_0._113_.RESET_B digital_0._063_.B 0.46526f
C4435 digital_0._116_.Q digital_0._063_.B 0.03106f
C4436 digital_0.clkload0.A digital_0._063_.B 0.11409f
C4437 digital_0.input1.X digital_0._063_.B 0.05111f
C4438 digital_0._067_.A digital_0._065_.A2_N 0.05698f
C4439 digital_0._069_.A digital_0._065_.A2_N 1.54718f
C4440 digital_0._110_.Q digital_0._065_.A2_N 0.28222f
C4441 digital_0._065_.A2_N digital_0._111_.D 0.01862f
C4442 digital_0._111_.Q digital_0._065_.A2_N 0.04647f
C4443 digital_0._065_.A2_N digital_0._111_.RESET_B 0.13394f
C4444 digital_0._065_.A2_N digital_0._112_.Q 0.29321f
C4445 digital_0._065_.A2_N digital_0._114_.Q 0.55858f
C4446 digital_0._116_.Q digital_0._065_.A2_N 0.41011f
C4447 digital_0._065_.A2_N digital_0.clkbuf_1_1__f_clk.A 0.34f
C4448 digital_0.clkload0.A digital_0._065_.A2_N 0.47362f
C4449 digital_0.input1.X digital_0._065_.A2_N 0.08836f
C4450 digital_0._065_.A2_N uio_out<5> 0.04028f
C4451 digital_0._065_.A2_N uio_out<6> 0.0354f
C4452 digital_0._067_.B digital_0._067_.A 0.0927f
C4453 digital_0._069_.A digital_0._067_.A 0.27725f
C4454 digital_0._103_.RESET_B digital_0._067_.A 0.01925f
C4455 digital_0._067_.A digital_0._110_.D 0.14772f
C4456 digital_0._110_.Q digital_0._067_.A 0.02392f
C4457 digital_0._111_.Q digital_0._067_.A 0.70965f
C4458 digital_0.output8.A digital_0._067_.A 0.12235f
C4459 digital_0._067_.A uio_out<6> 0.01818f
C4460 digital_0._069_.A digital_0._067_.B 0.24686f
C4461 digital_0._067_.B digital_0._110_.D 0.29553f
C4462 digital_0._110_.Q digital_0._067_.B 0.23129f
C4463 digital_0._067_.B digital_0._110_.RESET_B 0.04137f
C4464 digital_0.hold28.A digital_0._067_.B 0.03715f
C4465 digital_0._067_.B digital_0.input1.X 0.06946f
C4466 digital_0.output8.A digital_0._067_.B 0.05923f
C4467 digital_0._069_.A digital_0._069_.B 0.17689f
C4468 digital_0._069_.A digital_0._108_.D 0.19325f
C4469 digital_0._069_.A digital_0._108_.Q 0.21107f
C4470 digital_0._069_.A digital_0._108_.RESET_B 0.1311f
C4471 digital_0._069_.A digital_0._109_.D 0.24586f
C4472 digital_0._069_.A digital_0._109_.Q 0.09364f
C4473 digital_0._069_.A digital_0._109_.RESET_B 0.13826f
C4474 digital_0._069_.A digital_0._110_.Q 0.84045f
C4475 digital_0._069_.A digital_0._111_.D 0.11545f
C4476 digital_0._069_.A digital_0._111_.Q 0.5148f
C4477 digital_0._069_.A digital_0._111_.RESET_B 0.40185f
C4478 digital_0._069_.A digital_0._112_.Q 0.55488f
C4479 digital_0._069_.A digital_0._113_.Q 0.44561f
C4480 digital_0._069_.A digital_0._114_.Q 0.11348f
C4481 digital_0._116_.Q digital_0._069_.A 0.40126f
C4482 digital_0._069_.A digital_0._117_.RESET_B 0.02538f
C4483 digital_0._069_.A digital_0.clkbuf_1_1__f_clk.A 0.17589f
C4484 digital_0._069_.A digital_0.clkload0.A 0.19013f
C4485 digital_0._069_.A digital_0.hold28.A 0.2176f
C4486 digital_0._069_.A digital_0.input1.X 0.74263f
C4487 digital_0.load_slew15.A digital_0._069_.A 0.14422f
C4488 digital_0._069_.A digital_0.load_slew15.X 0.06805f
C4489 digital_0.load_slew17.A digital_0._069_.A 0.08367f
C4490 digital_0._069_.A digital_0.load_slew17.X 0.01229f
C4491 digital_0._069_.A digital_0.output13.A 0.39387f
C4492 digital_0._069_.A digital_0.output6.A 0.05638f
C4493 digital_0._069_.A uio_out<3> 0.01014f
C4494 digital_0._069_.A uio_out<5> 0.01837f
C4495 digital_0._069_.A uio_out<6> 0.05223f
C4496 digital_0._069_.A uio_out<7> 0.01359f
C4497 digital_0._069_.B digital_0._108_.Q 0.09275f
C4498 digital_0._069_.B digital_0._109_.D 0.31606f
C4499 digital_0._069_.B digital_0._109_.Q 0.15126f
C4500 digital_0._069_.B digital_0._109_.RESET_B 0.05146f
C4501 digital_0._069_.B digital_0.load_slew15.X 0.19832f
C4502 digital_0._069_.B digital_0.output13.A 0.06911f
C4503 digital_0._080_.A2 digital_0._116_.D 0.05981f
C4504 digital_0._116_.Q digital_0._080_.A2 0.29289f
C4505 digital_0._080_.A2 digital_0._116_.SET_B 0.01838f
C4506 digital_0._118_.D digital_0._080_.A2 0.04205f
C4507 digital_0._118_.RESET_B digital_0._080_.A2 0.0312f
C4508 digital_0.clkbuf_1_0__f_clk.X digital_0._080_.A2 0.43503f
C4509 digital_0._080_.A2 digital_0.hold18.X 0.03079f
C4510 digital_0.hold22.X digital_0._080_.A2 0.05558f
C4511 digital_0.hold28.X digital_0._080_.A2 0.10369f
C4512 digital_0.input1.X digital_0._080_.A2 0.02508f
C4513 digital_0.input2.X digital_0._080_.A2 0.16724f
C4514 digital_0.load_slew15.X digital_0._080_.A2 0.28327f
C4515 digital_0.output13.A digital_0._080_.A2 0.02f
C4516 digital_0.output4.A digital_0._080_.A2 0.01573f
C4517 digital_0._080_.A2 ui_in<0> 0.04989f
C4518 digital_0._080_.A2 uo_out<0> 0.15986f
C4519 digital_0._101_.RESET_B digital_0._100_.D 0.02215f
C4520 digital_0._118_.RESET_B digital_0._100_.D 0.02835f
C4521 digital_0.clkbuf_1_0__f_clk.X digital_0._100_.D 0.07483f
C4522 digital_0.hold25.X digital_0._100_.D 0.05078f
C4523 digital_0.hold28.A digital_0._100_.D 0.05039f
C4524 digital_0.load_slew15.X digital_0._100_.D 0.02447f
C4525 digital_0._117_.RESET_B digital_0._100_.RESET_B 0.0533f
C4526 digital_0._100_.RESET_B digital_0.clkbuf_1_0__f_clk.X 0.13573f
C4527 digital_0._100_.RESET_B digital_0.hold25.X 0.20198f
C4528 digital_0.hold28.A digital_0._100_.RESET_B 0.05884f
C4529 digital_0.load_slew15.X digital_0._100_.RESET_B 0.13419f
C4530 digital_0.output4.A digital_0._100_.RESET_B 0.11602f
C4531 digital_0.output5.A digital_0._100_.RESET_B 0.07313f
C4532 digital_0._116_.Q digital_0._101_.D 0.03774f
C4533 digital_0.clkbuf_1_0__f_clk.X digital_0._101_.D 0.02324f
C4534 digital_0.hold28.A digital_0._101_.D 0.04388f
C4535 digital_0.output13.A digital_0._101_.D 0.05223f
C4536 digital_0.output4.A digital_0._101_.D 0.07036f
C4537 digital_0._101_.D digital_0.output6.A 0.04718f
C4538 digital_0._117_.RESET_B digital_0._101_.RESET_B 0.02368f
C4539 digital_0._118_.RESET_B digital_0._101_.RESET_B 0.40332f
C4540 digital_0.clkbuf_1_0__f_clk.X digital_0._101_.RESET_B 0.03102f
C4541 digital_0.hold28.A digital_0._101_.RESET_B 0.07022f
C4542 digital_0.load_slew15.X digital_0._101_.RESET_B 0.52783f
C4543 digital_0.output13.A digital_0._101_.RESET_B 0.01338f
C4544 digital_0._101_.RESET_B digital_0.output6.A 0.12575f
C4545 digital_0._102_.D digital_0.clkload0.A 0.10539f
C4546 digital_0.hold28.A digital_0._102_.D 0.0588f
C4547 digital_0.load_slew17.A digital_0._102_.D 0.01949f
C4548 digital_0.hold28.A digital_0._102_.RESET_B 0.07102f
C4549 digital_0.load_slew17.A digital_0._102_.RESET_B 0.12537f
C4550 digital_0._103_.D digital_0._103_.RESET_B 0.2639f
C4551 digital_0._111_.Q digital_0._103_.D 0.03409f
C4552 digital_0.load_slew17.A digital_0._103_.D 0.05237f
C4553 digital_0._103_.D uio_out<5> 0.01407f
C4554 digital_0._111_.Q digital_0._103_.RESET_B 0.05597f
C4555 digital_0.load_slew17.A digital_0._103_.RESET_B 0.19207f
C4556 digital_0._103_.RESET_B uio_out<3> 0.01084f
C4557 digital_0._103_.RESET_B uio_out<5> 0.01543f
C4558 digital_0._103_.RESET_B uio_out<6> 0.01359f
C4559 digital_0._112_.Q digital_0._104_.D 0.09994f
C4560 digital_0._104_.D digital_0._113_.Q 0.02179f
C4561 digital_0._113_.RESET_B digital_0._104_.D 0.14716f
C4562 digital_0.clkload0.A digital_0._104_.D 0.01129f
C4563 digital_0.hold23.X digital_0._104_.D 0.01575f
C4564 digital_0.hold28.A digital_0._104_.D 0.01437f
C4565 digital_0.load_slew17.X digital_0._104_.D 0.21508f
C4566 digital_0._104_.RESET_B digital_0._113_.RESET_B 0.02895f
C4567 digital_0._116_.Q digital_0._104_.RESET_B 0.21132f
C4568 digital_0.hold28.A digital_0._104_.RESET_B 0.12906f
C4569 digital_0._104_.RESET_B digital_0.input3.X 0.01169f
C4570 digital_0.load_slew17.A digital_0._104_.RESET_B 0.17179f
C4571 digital_0.output9.A digital_0._104_.RESET_B 0.01331f
C4572 digital_0._113_.Q digital_0._105_.D 0.21485f
C4573 digital_0.hold28.A digital_0._105_.D 0.19054f
C4574 digital_0.load_slew17.X digital_0._105_.D 0.04227f
C4575 digital_0._105_.D digital_0.output10.A 0.02499f
C4576 digital_0._105_.RESET_B digital_0.hold27.X 0.04646f
C4577 digital_0.hold28.A digital_0._105_.RESET_B 0.21906f
C4578 digital_0.load_slew17.X digital_0._105_.RESET_B 0.37488f
C4579 digital_0._105_.RESET_B digital_0.output10.A 0.02137f
C4580 digital_0.clkload0.A digital_0._106_.D 0.02166f
C4581 digital_0.hold28.A digital_0._106_.D 0.03543f
C4582 digital_0.load_slew17.X digital_0._106_.D 0.02067f
C4583 digital_0._113_.Q digital_0._106_.RESET_B 0.01161f
C4584 digital_0._114_.Q digital_0._106_.RESET_B 0.02897f
C4585 digital_0.load_slew17.X digital_0._106_.RESET_B 0.40971f
C4586 digital_0._106_.RESET_B digital_0.output11.A 0.05555f
C4587 digital_0._106_.RESET_B uio_out<6> 0.01162f
C4588 digital_0._107_.D digital_0._107_.RESET_B 0.02736f
C4589 digital_0._114_.D digital_0._107_.D 0.01863f
C4590 digital_0._115_.Q digital_0._107_.D 0.05963f
C4591 digital_0._107_.D digital_0.hold26.X 0.2083f
C4592 digital_0.hold28.A digital_0._107_.D 0.33909f
C4593 digital_0._107_.D digital_0.output12.A 0.13431f
C4594 digital_0._107_.D uio_out<7> 0.02263f
C4595 digital_0._114_.D digital_0._107_.RESET_B 0.03531f
C4596 digital_0._115_.Q digital_0._107_.RESET_B 0.02898f
C4597 digital_0.clkload0.A digital_0._107_.RESET_B 0.27625f
C4598 digital_0.hold28.A digital_0._107_.RESET_B 0.02622f
C4599 digital_0.input1.X digital_0._107_.RESET_B 0.0466f
C4600 digital_0.input2.X digital_0._107_.RESET_B 0.08188f
C4601 digital_0.load_slew15.X digital_0._107_.RESET_B 0.2566f
C4602 digital_0._107_.RESET_B ui_in<0> 0.08022f
C4603 digital_0._107_.RESET_B uio_out<7> 0.01142f
C4604 digital_0._108_.Q digital_0._108_.D 0.13134f
C4605 digital_0._109_.Q digital_0._108_.D 0.26774f
C4606 digital_0._117_.RESET_B digital_0._108_.D 0.02801f
C4607 digital_0.hold28.A digital_0._108_.D 0.26157f
C4608 digital_0._108_.D digital_0.input1.X 0.13216f
C4609 digital_0.load_slew15.X digital_0._108_.D 0.18257f
C4610 digital_0.output13.A digital_0._108_.D 0.0461f
C4611 digital_0._108_.D digital_0.output6.A 0.03091f
C4612 digital_0._108_.Q digital_0._108_.RESET_B 0.43139f
C4613 digital_0._109_.D digital_0._108_.Q 0.28004f
C4614 digital_0._109_.Q digital_0._108_.Q 0.45233f
C4615 digital_0._109_.RESET_B digital_0._108_.Q 0.08246f
C4616 digital_0.hold25.X digital_0._108_.Q 0.29922f
C4617 digital_0.hold28.A digital_0._108_.Q 0.11226f
C4618 digital_0._108_.Q digital_0.input1.X 0.36036f
C4619 digital_0.load_slew15.X digital_0._108_.Q 0.39674f
C4620 digital_0._108_.Q digital_0.output13.A 1.1935f
C4621 digital_0._108_.Q digital_0.output6.A 0.02626f
C4622 digital_0._108_.Q uio_out<7> 0.0166f
C4623 digital_0._109_.Q digital_0._108_.RESET_B 0.02202f
C4624 digital_0._116_.Q digital_0._108_.RESET_B 0.06544f
C4625 digital_0.input1.X digital_0._108_.RESET_B 0.48039f
C4626 digital_0.load_slew15.A digital_0._108_.RESET_B 0.34851f
C4627 digital_0.load_slew15.X digital_0._108_.RESET_B 0.0316f
C4628 digital_0._108_.RESET_B uio_out<7> 0.01481f
C4629 digital_0._109_.D digital_0._109_.Q 0.02f
C4630 digital_0._109_.RESET_B digital_0._109_.D 0.01991f
C4631 digital_0.load_slew15.X digital_0._109_.D 0.02615f
C4632 digital_0._109_.D digital_0.output13.A 0.09898f
C4633 digital_0._109_.RESET_B digital_0._109_.Q 0.05103f
C4634 digital_0._116_.Q digital_0._109_.Q 0.15483f
C4635 digital_0._109_.Q digital_0._118_.RESET_B 0.20949f
C4636 digital_0._109_.Q digital_0.clkbuf_1_0__f_clk.X 0.02899f
C4637 digital_0._109_.Q digital_0.hold22.X 0.27301f
C4638 digital_0.hold25.X digital_0._109_.Q 0.14024f
C4639 digital_0.hold28.A digital_0._109_.Q 0.5474f
C4640 digital_0.load_slew15.A digital_0._109_.Q 0.04547f
C4641 digital_0.load_slew15.X digital_0._109_.Q 0.3838f
C4642 digital_0._109_.Q digital_0.output13.A 0.65918f
C4643 digital_0._109_.Q digital_0.output6.A 0.08051f
C4644 digital_0._109_.Q uio_out<7> 0.01636f
C4645 digital_0._116_.Q digital_0._109_.RESET_B 0.14924f
C4646 digital_0.load_slew15.A digital_0._109_.RESET_B 0.2238f
C4647 digital_0.load_slew15.X digital_0._109_.RESET_B 0.13693f
C4648 digital_0._109_.RESET_B uio_out<7> 0.02878f
C4649 digital_0._111_.Q digital_0._110_.D 0.01381f
C4650 digital_0._110_.D digital_0._112_.Q 0.01027f
C4651 digital_0._110_.D digital_0.input1.X 0.03238f
C4652 digital_0.output8.A digital_0._110_.D 0.10382f
C4653 digital_0._110_.Q digital_0._110_.RESET_B 0.30578f
C4654 digital_0._111_.Q digital_0._110_.Q 0.40253f
C4655 digital_0._110_.Q digital_0._112_.Q 0.02813f
C4656 digital_0.clkload0.A digital_0._110_.Q 0.30798f
C4657 digital_0.hold24.X digital_0._110_.Q 0.27296f
C4658 digital_0.hold28.A digital_0._110_.Q 0.24467f
C4659 digital_0._110_.Q digital_0.input1.X 0.46751f
C4660 digital_0.load_slew17.A digital_0._110_.Q 0.14159f
C4661 digital_0._116_.Q digital_0._110_.RESET_B 0.10541f
C4662 digital_0.clkload0.A digital_0._110_.RESET_B 0.06392f
C4663 digital_0.hold28.A digital_0._110_.RESET_B 0.01111f
C4664 digital_0._110_.RESET_B digital_0.input1.X 0.01407f
C4665 digital_0.load_slew17.A digital_0._110_.RESET_B 0.4928f
C4666 digital_0._111_.D digital_0._111_.RESET_B 0.20385f
C4667 digital_0._116_.Q digital_0._111_.D 0.15825f
C4668 digital_0.clkload0.A digital_0._111_.D 0.09416f
C4669 digital_0.input1.X digital_0._111_.D 0.02973f
C4670 digital_0.load_slew17.A digital_0._111_.D 0.03874f
C4671 digital_0._111_.Q digital_0.clkload0.A 0.02186f
C4672 digital_0.hold20.X digital_0._111_.Q 0.33141f
C4673 digital_0.hold28.A digital_0._111_.Q 0.09371f
C4674 digital_0._111_.Q digital_0.input1.X 0.1283f
C4675 digital_0.load_slew17.A digital_0._111_.Q 0.0457f
C4676 digital_0.output8.A digital_0._111_.Q 0.01689f
C4677 digital_0._111_.Q uio_out<6> 0.03125f
C4678 digital_0._116_.Q digital_0._111_.RESET_B 0.06315f
C4679 digital_0.clkload0.A digital_0._111_.RESET_B 0.0905f
C4680 digital_0.input1.X digital_0._111_.RESET_B 0.09595f
C4681 digital_0.load_slew17.A digital_0._111_.RESET_B 0.18865f
C4682 digital_0._111_.RESET_B uio_out<5> 0.01946f
C4683 digital_0._112_.Q digital_0._112_.D 0.05172f
C4684 digital_0._112_.D digital_0._112_.RESET_B 0.50234f
C4685 digital_0._113_.D digital_0._112_.D 0.03199f
C4686 digital_0._113_.Q digital_0._112_.D 0.16698f
C4687 digital_0.clkload0.A digital_0._112_.D 0.19682f
C4688 digital_0._112_.Q digital_0._112_.RESET_B 0.1416f
C4689 digital_0._112_.Q digital_0._113_.D 0.05158f
C4690 digital_0._112_.Q digital_0._113_.Q 0.60249f
C4691 digital_0._112_.Q digital_0._113_.RESET_B 0.61482f
C4692 digital_0._112_.Q digital_0._114_.Q 0.01919f
C4693 digital_0._116_.Q digital_0._112_.Q 0.16413f
C4694 digital_0._112_.Q digital_0.clkbuf_1_1__f_clk.A 0.01425f
C4695 digital_0.clkload0.A digital_0._112_.Q 0.59782f
C4696 digital_0._112_.Q digital_0.clkload0.X 0.05079f
C4697 digital_0._112_.Q digital_0.hold23.X 0.29752f
C4698 digital_0.hold28.A digital_0._112_.Q 0.12694f
C4699 digital_0.input1.X digital_0._112_.Q 0.27047f
C4700 digital_0.load_slew17.A digital_0._112_.Q 0.10061f
C4701 digital_0.load_slew17.X digital_0._112_.Q 0.10167f
C4702 digital_0._112_.Q uio_out<5> 0.01154f
C4703 digital_0._112_.Q uio_out<6> 0.02219f
C4704 digital_0._113_.Q digital_0._112_.RESET_B 0.03559f
C4705 digital_0._113_.RESET_B digital_0._112_.RESET_B 0.12568f
C4706 digital_0._116_.Q digital_0._112_.RESET_B 0.16563f
C4707 digital_0.clkload0.A digital_0._112_.RESET_B 0.04217f
C4708 digital_0.hold23.X digital_0._112_.RESET_B 0.03501f
C4709 digital_0.hold28.A digital_0._112_.RESET_B 0.02994f
C4710 digital_0.input3.X digital_0._112_.RESET_B 0.51331f
C4711 digital_0.load_slew17.X digital_0._112_.RESET_B 0.22865f
C4712 digital_0._113_.D digital_0._113_.Q 0.13305f
C4713 digital_0._113_.RESET_B digital_0._113_.D 0.0128f
C4714 digital_0._113_.D digital_0._114_.Q 0.1414f
C4715 digital_0._116_.Q digital_0._113_.D 0.02084f
C4716 digital_0.clkload0.A digital_0._113_.D 0.33859f
C4717 digital_0.load_slew17.X digital_0._113_.D 0.01383f
C4718 digital_0._113_.RESET_B digital_0._113_.Q 0.06051f
C4719 digital_0._113_.Q digital_0._114_.Q 0.3881f
C4720 digital_0._113_.Q digital_0.clkbuf_1_1__f_clk.A 0.06071f
C4721 digital_0.clkload0.A digital_0._113_.Q 0.5049f
C4722 digital_0._113_.Q digital_0.clkload0.X 0.01348f
C4723 digital_0._113_.Q digital_0.hold27.X 0.29726f
C4724 digital_0.hold28.A digital_0._113_.Q 0.30888f
C4725 digital_0.input1.X digital_0._113_.Q 0.06947f
C4726 digital_0.load_slew17.X digital_0._113_.Q 0.30514f
C4727 digital_0._113_.Q digital_0.output10.A 0.17074f
C4728 digital_0._113_.Q uio_out<6> 0.019f
C4729 digital_0._116_.Q digital_0._113_.RESET_B 0.0903f
C4730 digital_0.clkload0.A digital_0._113_.RESET_B 0.03427f
C4731 digital_0._113_.RESET_B digital_0.hold23.X 0.05674f
C4732 digital_0.hold28.A digital_0._113_.RESET_B 0.06194f
C4733 digital_0.input3.X digital_0._113_.RESET_B 0.31841f
C4734 digital_0.load_slew17.A digital_0._113_.RESET_B 0.11366f
C4735 digital_0.load_slew17.X digital_0._113_.RESET_B 0.02542f
C4736 digital_0.output9.A digital_0._113_.RESET_B 0.45713f
C4737 digital_0._116_.Q digital_0._114_.D 0.01083f
C4738 digital_0.clkload0.A digital_0._114_.D 0.02722f
C4739 digital_0.hold28.A digital_0._114_.D 0.05847f
C4740 digital_0.input2.X digital_0._114_.D 0.1958f
C4741 digital_0.load_slew15.X digital_0._114_.D 0.07006f
C4742 digital_0._114_.D uio_out<7> 0.04762f
C4743 digital_0.clkload0.A digital_0._114_.Q 0.2557f
C4744 digital_0._114_.Q digital_0.clkload0.X 0.05621f
C4745 digital_0._114_.Q digital_0.hold21.X 0.33446f
C4746 digital_0.hold28.A digital_0._114_.Q 0.24425f
C4747 digital_0.load_slew17.X digital_0._114_.Q 0.33859f
C4748 digital_0._114_.Q digital_0.output11.A 0.0114f
C4749 digital_0._114_.Q uio_out<5> 0.03418f
C4750 digital_0._114_.Q uio_out<6> 0.03732f
C4751 digital_0._116_.Q digital_0._114_.RESET_B 0.21966f
C4752 digital_0.clkload0.A digital_0._114_.RESET_B 0.28573f
C4753 digital_0.load_slew15.A digital_0._114_.RESET_B 0.46709f
C4754 digital_0.load_slew17.X digital_0._114_.RESET_B 0.10871f
C4755 digital_0._115_.RESET_B digital_0._115_.D 0.0605f
C4756 digital_0.hold28.A digital_0._115_.D 0.23905f
C4757 digital_0.input1.X digital_0._115_.D 0.16136f
C4758 digital_0.input2.X digital_0._115_.D 0.04459f
C4759 digital_0.load_slew17.X digital_0._115_.D 0.02542f
C4760 digital_0._115_.D ui_in<0> 0.04405f
C4761 digital_0._115_.RESET_B digital_0._115_.Q 0.61892f
C4762 digital_0.clkbuf_1_1__f_clk.A digital_0._115_.Q 0.01221f
C4763 digital_0._115_.Q digital_0.hold26.X 0.28428f
C4764 digital_0.hold28.A digital_0._115_.Q 0.67138f
C4765 digital_0.input1.X digital_0._115_.Q 0.13125f
C4766 digital_0.input2.X digital_0._115_.Q 0.05497f
C4767 digital_0.load_slew15.A digital_0._115_.Q 0.01104f
C4768 digital_0.load_slew17.X digital_0._115_.Q 0.02243f
C4769 digital_0._115_.Q digital_0.output12.A 0.08304f
C4770 digital_0._115_.Q ui_in<0> 0.08289f
C4771 digital_0._115_.Q uio_out<7> 0.02437f
C4772 digital_0._116_.Q digital_0._115_.RESET_B 0.12965f
C4773 digital_0.clkbuf_1_0__f_clk.X digital_0._115_.RESET_B 0.47971f
C4774 digital_0.hold28.A digital_0._115_.RESET_B 0.19886f
C4775 digital_0.input1.X digital_0._115_.RESET_B 0.12763f
C4776 digital_0._115_.RESET_B digital_0.input2.X 0.03306f
C4777 digital_0.load_slew15.X digital_0._115_.RESET_B 0.01898f
C4778 digital_0.load_slew17.X digital_0._115_.RESET_B 0.2603f
C4779 digital_0.output13.A digital_0._115_.RESET_B 0.03636f
C4780 digital_0.output6.A digital_0._115_.RESET_B 0.0225f
C4781 digital_0._115_.RESET_B ui_in<0> 0.06503f
C4782 digital_0._115_.RESET_B uio_out<7> 0.01577f
C4783 digital_0._116_.Q digital_0._116_.D 0.02774f
C4784 digital_0._116_.D digital_0._116_.SET_B 0.06808f
C4785 digital_0.clkbuf_1_0__f_clk.X digital_0._116_.D 0.06069f
C4786 digital_0.input1.X digital_0._116_.D 0.56277f
C4787 digital_0.load_slew15.X digital_0._116_.D 0.12639f
C4788 digital_0._116_.D digital_0.output12.A 0.02365f
C4789 digital_0.output4.A digital_0._116_.D 0.02714f
C4790 digital_0._116_.D ui_in<0> 0.01751f
C4791 digital_0._116_.D uo_out<0> 0.0398f
C4792 digital_0._116_.Q digital_0._116_.SET_B 0.04016f
C4793 digital_0._116_.Q digital_0._118_.D 0.02374f
C4794 digital_0._116_.Q digital_0._118_.RESET_B 0.12979f
C4795 digital_0._116_.Q digital_0.clkbuf_1_0__f_clk.X 0.85211f
C4796 digital_0._116_.Q digital_0.clkbuf_1_1__f_clk.A 0.51145f
C4797 digital_0._116_.Q digital_0.clkload0.A 0.2873f
C4798 digital_0._116_.Q digital_0.hold18.X 0.10082f
C4799 digital_0._116_.Q digital_0.hold19.X 0.16979f
C4800 digital_0._116_.Q digital_0.hold22.X 0.02396f
C4801 digital_0._116_.Q digital_0.hold28.A 0.54204f
C4802 digital_0._116_.Q digital_0.hold28.X 0.43768f
C4803 digital_0._116_.Q digital_0.input1.X 0.16959f
C4804 digital_0._116_.Q digital_0.input2.X 0.28045f
C4805 digital_0._116_.Q digital_0.input3.X 0.50477f
C4806 digital_0.load_slew15.A digital_0._116_.Q 1.4133f
C4807 digital_0._116_.Q digital_0.load_slew15.X 0.44422f
C4808 digital_0.load_slew17.A digital_0._116_.Q 1.44653f
C4809 digital_0._116_.Q digital_0.load_slew17.X 1.04879f
C4810 digital_0._116_.Q digital_0.output10.A 0.15667f
C4811 digital_0._116_.Q digital_0.output12.A 0.0318f
C4812 digital_0._116_.Q digital_0.output13.A 0.51717f
C4813 digital_0._116_.Q digital_0.output4.A 0.02618f
C4814 digital_0._116_.Q digital_0.output6.A 0.35713f
C4815 digital_0._116_.Q digital_0.output9.A 0.19446f
C4816 digital_0._116_.Q ui_in<0> 0.0649f
C4817 digital_0._116_.Q uio_out<3> 0.01421f
C4818 digital_0._116_.Q uio_out<5> 0.01897f
C4819 digital_0._116_.Q uio_out<7> 0.10003f
C4820 digital_0._116_.Q uo_out<0> 0.13098f
C4821 digital_0._116_.Q uo_out<1> 0.26466f
C4822 digital_0._116_.SET_B digital_0._119_.RESET_B 0.1434f
C4823 digital_0.clkbuf_1_0__f_clk.X digital_0._116_.SET_B 0.10059f
C4824 digital_0.hold28.X digital_0._116_.SET_B 0.2535f
C4825 digital_0.input2.X digital_0._116_.SET_B 0.01256f
C4826 digital_0.load_slew15.X digital_0._116_.SET_B 0.17291f
C4827 digital_0.output4.A digital_0._116_.SET_B 0.0386f
C4828 digital_0._116_.SET_B ui_in<0> 0.03281f
C4829 digital_0._117_.RESET_B digital_0._118_.RESET_B 0.02389f
C4830 digital_0._117_.RESET_B digital_0.hold25.X 0.03177f
C4831 digital_0.hold28.A digital_0._117_.RESET_B 0.04061f
C4832 digital_0.load_slew15.X digital_0._117_.RESET_B 0.66421f
C4833 digital_0.clkbuf_1_0__f_clk.X digital_0._118_.D 0.39504f
C4834 digital_0.input2.X digital_0._118_.D 0.13337f
C4835 digital_0.output13.A digital_0._118_.D 0.38036f
C4836 digital_0.output4.A digital_0._118_.D 0.01499f
C4837 digital_0.output6.A digital_0._118_.D 0.10602f
C4838 digital_0._118_.D uio_out<1> 0.11305f
C4839 digital_0._118_.D uo_out<1> 0.02734f
C4840 digital_0.clkbuf_1_0__f_clk.X digital_0._118_.RESET_B 0.02881f
C4841 digital_0._118_.RESET_B digital_0.hold22.X 0.01385f
C4842 digital_0.hold25.X digital_0._118_.RESET_B 0.23246f
C4843 digital_0.hold28.A digital_0._118_.RESET_B 0.0236f
C4844 digital_0._118_.RESET_B digital_0.hold28.X 0.01443f
C4845 digital_0._118_.RESET_B digital_0.input2.X 0.03142f
C4846 digital_0.load_slew15.X digital_0._118_.RESET_B 0.46938f
C4847 digital_0.output13.A digital_0._118_.RESET_B 0.44902f
C4848 digital_0._118_.RESET_B digital_0.output6.A 0.03979f
C4849 digital_0.load_slew15.X digital_0._119_.RESET_B 0.37097f
C4850 digital_0.output13.A digital_0._119_.RESET_B 0.02817f
C4851 digital_0.output4.A digital_0._119_.RESET_B 0.14082f
C4852 digital_0._119_.RESET_B ui_in<0> 0.01381f
C4853 digital_0.hold19.X digital_0.clkbuf_1_0__f_clk.X 0.06948f
C4854 digital_0.clkbuf_1_0__f_clk.X digital_0.hold22.X 0.25958f
C4855 digital_0.hold28.A digital_0.clkbuf_1_0__f_clk.X 0.29617f
C4856 digital_0.clkbuf_1_0__f_clk.X digital_0.hold28.X 0.28879f
C4857 digital_0.clkbuf_1_0__f_clk.X digital_0.input1.X 0.04278f
C4858 digital_0.clkbuf_1_0__f_clk.X digital_0.input2.X 0.3598f
C4859 digital_0.load_slew15.X digital_0.clkbuf_1_0__f_clk.X 0.19843f
C4860 digital_0.clkbuf_1_0__f_clk.X digital_0.load_slew17.X 0.08061f
C4861 digital_0.output13.A digital_0.clkbuf_1_0__f_clk.X 0.18952f
C4862 digital_0.output4.A digital_0.clkbuf_1_0__f_clk.X 0.11998f
C4863 digital_0.output5.A digital_0.clkbuf_1_0__f_clk.X 0.10018f
C4864 digital_0.clkbuf_1_0__f_clk.X digital_0.output6.A 0.1337f
C4865 digital_0.clkbuf_1_0__f_clk.X ui_in<0> 0.10865f
C4866 digital_0.clkbuf_1_0__f_clk.X uio_out<1> 0.20119f
C4867 digital_0.clkbuf_1_0__f_clk.X uo_out<1> 1.00213f
C4868 digital_0.clkload0.A digital_0.clkbuf_1_1__f_clk.A 0.08502f
C4869 digital_0.load_slew15.A digital_0.clkbuf_1_1__f_clk.A 0.33672f
C4870 digital_0.load_slew15.X digital_0.clkbuf_1_1__f_clk.A 0.08471f
C4871 digital_0.load_slew17.X digital_0.clkbuf_1_1__f_clk.A 0.03332f
C4872 digital_0.clkbuf_1_1__f_clk.A uio_out<5> 0.0295f
C4873 digital_0.clkbuf_1_1__f_clk.A uio_out<6> 0.01716f
C4874 digital_0.clkbuf_1_1__f_clk.A uio_out<7> 0.0161f
C4875 digital_0.clkload0.A digital_0.clkload0.X 0.07299f
C4876 digital_0.hold28.A digital_0.clkload0.A 0.20811f
C4877 digital_0.clkload0.A digital_0.input1.X 0.16048f
C4878 digital_0.clkload0.A digital_0.input2.X 0.04461f
C4879 digital_0.load_slew15.X digital_0.clkload0.A 0.16115f
C4880 digital_0.load_slew17.A digital_0.clkload0.A 0.60112f
C4881 digital_0.clkload0.A digital_0.load_slew17.X 0.48212f
C4882 digital_0.clkload0.A ui_in<0> 0.07979f
C4883 digital_0.clkload0.A uio_out<5> 0.02477f
C4884 digital_0.clkload0.A uio_out<6> 0.02192f
C4885 digital_0.input1.X digital_0.clkload0.X 0.0693f
C4886 digital_0.input1.X digital_0.hold18.X 0.79772f
C4887 digital_0.load_slew15.X digital_0.hold18.X 0.01308f
C4888 digital_0.hold18.X uo_out<0> 0.27898f
C4889 digital_0.hold19.X digital_0.input2.X 0.03513f
C4890 digital_0.output4.A digital_0.hold19.X 0.13728f
C4891 digital_0.output5.A digital_0.hold19.X 0.14207f
C4892 digital_0.hold19.X digital_0.output6.A 0.15532f
C4893 digital_0.hold19.X uo_out<1> 0.35801f
C4894 digital_0.hold20.X digital_0.hold28.A 0.07362f
C4895 digital_0.load_slew17.A digital_0.hold20.X 0.30012f
C4896 digital_0.hold20.X uio_out<3> 0.01223f
C4897 digital_0.hold28.A digital_0.hold21.X 0.2375f
C4898 digital_0.hold21.X uio_out<5> 0.12524f
C4899 digital_0.hold21.X uio_out<6> 0.03386f
C4900 digital_0.hold28.A digital_0.hold22.X 0.03679f
C4901 digital_0.hold22.X digital_0.hold28.X 0.01557f
C4902 digital_0.hold22.X digital_0.input2.X 0.05323f
C4903 digital_0.load_slew15.X digital_0.hold22.X 0.10557f
C4904 digital_0.output13.A digital_0.hold22.X 0.02676f
C4905 digital_0.hold22.X ui_in<0> 0.03205f
C4906 digital_0.hold28.A digital_0.hold23.X 0.25288f
C4907 digital_0.input3.X digital_0.hold23.X 0.40399f
C4908 digital_0.load_slew17.X digital_0.hold23.X 0.343f
C4909 digital_0.hold24.X digital_0.hold28.A 0.12063f
C4910 digital_0.load_slew17.A digital_0.hold24.X 0.22808f
C4911 digital_0.output7.A digital_0.hold24.X 0.11322f
C4912 digital_0.hold24.X uio_out<2> 0.05424f
C4913 digital_0.hold24.X uio_out<3> 0.03746f
C4914 digital_0.hold28.A digital_0.hold25.X 0.05966f
C4915 digital_0.hold25.X digital_0.input1.X 0.01397f
C4916 digital_0.load_slew15.X digital_0.hold25.X 0.17724f
C4917 digital_0.hold25.X digital_0.output13.A 0.05899f
C4918 digital_0.hold28.A digital_0.hold26.X 0.04233f
C4919 digital_0.output12.A digital_0.hold26.X 0.30982f
C4920 digital_0.hold28.A digital_0.hold27.X 0.06978f
C4921 digital_0.load_slew17.X digital_0.hold27.X 0.21125f
C4922 digital_0.output10.A digital_0.hold27.X 0.26256f
C4923 digital_0.hold28.A digital_0.input1.X 0.79051f
C4924 digital_0.hold28.A digital_0.input2.X 0.08662f
C4925 digital_0.hold28.A digital_0.input3.X 0.03172f
C4926 digital_0.load_slew15.X digital_0.hold28.A 0.39788f
C4927 digital_0.load_slew17.A digital_0.hold28.A 0.74228f
C4928 digital_0.hold28.A digital_0.load_slew17.X 0.38972f
C4929 digital_0.hold28.A digital_0.output10.A 0.60659f
C4930 digital_0.hold28.A digital_0.output11.A 0.55539f
C4931 digital_0.hold28.A digital_0.output12.A 0.37337f
C4932 digital_0.hold28.A digital_0.output13.A 0.27307f
C4933 digital_0.output4.A digital_0.hold28.A 0.02309f
C4934 digital_0.hold28.A digital_0.output6.A 0.47557f
C4935 digital_0.output8.A digital_0.hold28.A 0.21345f
C4936 digital_0.hold28.A ui_in<0> 0.10389f
C4937 digital_0.hold28.A uio_out<3> 0.05417f
C4938 digital_0.hold28.A uio_out<5> 0.12959f
C4939 digital_0.hold28.A uio_out<6> 1.12194f
C4940 digital_0.hold28.A uio_out<7> 0.2553f
C4941 digital_0.input2.X digital_0.hold28.X 0.04255f
C4942 digital_0.load_slew15.X digital_0.hold28.X 0.10298f
C4943 digital_0.load_slew17.X digital_0.hold28.X 0.01551f
C4944 digital_0.output13.A digital_0.hold28.X 0.09624f
C4945 digital_0.output6.A digital_0.hold28.X 0.01221f
C4946 digital_0.hold28.X ui_in<0> 0.0359f
C4947 digital_0.input1.X digital_0.input2.X 0.05681f
C4948 digital_0.load_slew15.A digital_0.input1.X 0.0333f
C4949 digital_0.load_slew15.X digital_0.input1.X 0.06421f
C4950 digital_0.input1.X digital_0.load_slew17.X 0.03512f
C4951 digital_0.input1.X digital_0.output12.A 0.26695f
C4952 digital_0.output13.A digital_0.input1.X 0.1634f
C4953 digital_0.input1.X digital_0.output6.A 0.27898f
C4954 digital_0.input1.X ui_in<0> 0.09853f
C4955 digital_0.input1.X uio_out<6> 0.01629f
C4956 digital_0.input1.X uio_out<7> 0.02072f
C4957 digital_0.input1.X uo_out<0> 0.08507f
C4958 digital_0.load_slew15.X digital_0.input2.X 0.51945f
C4959 digital_0.load_slew17.X digital_0.input2.X 1.43539f
C4960 digital_0.output13.A digital_0.input2.X 0.21738f
C4961 digital_0.output4.A digital_0.input2.X 0.28315f
C4962 digital_0.output6.A digital_0.input2.X 0.13132f
C4963 digital_0.input2.X ui_in<0> 0.6795f
C4964 digital_0.input2.X uio_out<7> 0.06805f
C4965 digital_0.input2.X uo_out<1> 0.03742f
C4966 digital_0.load_slew17.X digital_0.input3.X 0.07283f
C4967 digital_0.output9.A digital_0.input3.X 0.28586f
C4968 digital_0.load_slew15.A digital_0.load_slew15.X 0.2211f
C4969 digital_0.load_slew15.A digital_0.load_slew17.X 0.07051f
C4970 digital_0.load_slew15.A uio_out<7> 0.05561f
C4971 digital_0.load_slew15.X digital_0.load_slew17.X 0.06339f
C4972 digital_0.load_slew15.X digital_0.output13.A 0.30872f
C4973 digital_0.load_slew15.X digital_0.output4.A 0.06758f
C4974 digital_0.load_slew15.X digital_0.output6.A 0.03649f
C4975 digital_0.load_slew15.X ui_in<0> 0.12154f
C4976 digital_0.load_slew15.X uio_out<3> 0.0143f
C4977 digital_0.load_slew15.X uio_out<7> 0.05038f
C4978 digital_0.load_slew17.A digital_0.load_slew17.X 0.21454f
C4979 digital_0.output8.A digital_0.load_slew17.A 0.18684f
C4980 digital_0.load_slew17.A digital_0.output9.A 0.03145f
C4981 digital_0.load_slew17.A uio_out<3> 0.10303f
C4982 digital_0.load_slew17.A uio_out<5> 0.0183f
C4983 digital_0.load_slew17.A uio_out<6> 0.01092f
C4984 digital_0.load_slew17.X digital_0.output10.A 0.56578f
C4985 digital_0.load_slew17.X digital_0.output11.A 0.13483f
C4986 digital_0.output13.A digital_0.load_slew17.X 0.23645f
C4987 digital_0.load_slew17.X digital_0.output6.A 0.0407f
C4988 digital_0.load_slew17.X uio_out<5> 0.01481f
C4989 digital_0.load_slew17.X uio_out<6> 0.01272f
C4990 digital_0.load_slew17.X uio_out<7> 0.06187f
C4991 digital_0.output10.A digital_0.output11.A 0.16386f
C4992 digital_0.output10.A uio_out<6> 0.04392f
C4993 digital_0.output11.A uio_out<5> 0.15818f
C4994 digital_0.output11.A uio_out<6> 0.06871f
C4995 digital_0.output12.A ui_in<0> 0.01916f
C4996 digital_0.output12.A uio_out<7> 0.16317f
C4997 digital_0.output12.A uo_out<0> 0.09365f
C4998 digital_0.output4.A digital_0.output13.A 0.98451f
C4999 digital_0.output13.A digital_0.output6.A 0.44247f
C5000 digital_0.output13.A ui_in<0> 0.03984f
C5001 digital_0.output13.A uo_out<1> 0.04974f
C5002 digital_0.output5.A digital_0.output4.A 0.81276f
C5003 digital_0.output4.A digital_0.output6.A 0.11904f
C5004 digital_0.output4.A ui_in<0> 0.03944f
C5005 digital_0.output4.A uo_out<1> 0.07504f
C5006 digital_0.output5.A uo_out<1> 0.18016f
C5007 digital_0.output6.A ui_in<0> 0.05109f
C5008 digital_0.output6.A uo_out<1> 0.01398f
C5009 digital_0.output8.A uio_out<3> 0.01381f
C5010 digital_0.output9.A uio_out<4> 0.10699f
C5011 ui_in<0> rst_n 0.40613f
C5012 ui_in<1> rst_n 0.61892f
C5013 ui_in<1> ui_in<0> 0.51629f
C5014 ui_in<0> uio_out<7> 0.07513f
C5015 ui_in<0> uo_out<0> 2.55924f
C5016 ui_in<0> uo_out<1> 0.41023f
C5017 ui_in<1> ui_in<2> 0.03102f
C5018 ui_in<1> uo_out<0> 0.17977f
C5019 ui_in<3> ui_in<2> 0.03102f
C5020 ui_in<4> ui_in<3> 0.03102f
C5021 ui_in<5> ui_in<4> 0.03102f
C5022 ui_in<6> ui_in<5> 0.03102f
C5023 ui_in<7> ui_in<6> 0.03102f
C5024 uio_in<0> ui_in<7> 0.03102f
C5025 uio_in<1> uio_in<0> 0.03102f
C5026 uio_in<2> uio_in<1> 0.03102f
C5027 uio_in<3> uio_in<2> 0.03102f
C5028 uio_in<4> uio_in<3> 0.03102f
C5029 uio_in<5> uio_in<4> 0.03102f
C5030 uio_in<6> uio_in<5> 0.03102f
C5031 uio_in<7> uio_in<6> 0.03102f
C5032 uo_out<0> uio_in<7> 0.03182f
C5033 uio_oe<1> uio_oe<0> 0.02823f
C5034 uio_out<7> uio_oe<0> 0.02823f
C5035 uio_oe<2> uio_oe<1> 0.03071f
C5036 uio_oe<3> uio_oe<2> 0.03071f
C5037 uio_oe<4> uio_oe<3> 0.03102f
C5038 uio_oe<5> uio_oe<4> 0.03102f
C5039 uio_oe<6> uio_oe<5> 0.03102f
C5040 uio_oe<7> uio_oe<6> 0.03102f
C5041 uio_out<0> uio_out<1> 6.38665f
C5042 uio_out<2> uio_out<0> 0.55594f
C5043 uo_out<1> uio_out<0> 5.51099f
C5044 uio_out<0> uo_out<7> 0.03123f
C5045 uio_out<2> uio_out<1> 4.99516f
C5046 uo_out<1> uio_out<1> 0.28246f
C5047 uio_out<2> uio_out<3> 7.72257f
C5048 uio_out<2> uio_out<4> 1.36379f
C5049 uio_out<2> uio_out<5> 0.06396f
C5050 uio_out<2> uio_out<6> 0.33178f
C5051 uio_out<2> uio_out<7> 0.0662f
C5052 uio_out<3> uio_out<4> 0.27537f
C5053 uio_out<3> uio_out<5> 0.08251f
C5054 uio_out<3> uio_out<6> 1.29019f
C5055 uio_out<3> uio_out<7> 0.52831f
C5056 uio_out<4> uio_out<5> 3.97334f
C5057 uio_out<4> uio_out<6> 3.48473f
C5058 uio_out<4> uio_out<7> 0.08534f
C5059 uio_out<6> uio_out<5> 2.16491f
C5060 uio_out<5> uio_out<7> 2.90181f
C5061 uio_out<6> uio_out<7> 0.15752f
C5062 uo_out<0> uio_out<7> 0.01933f
C5063 uo_out<0> uo_out<1> 0.16341f
C5064 uo_out<1> uo_out<2> 0.03234f
C5065 uo_out<3> uo_out<2> 0.03102f
C5066 uo_out<4> uo_out<3> 0.03102f
C5067 uo_out<5> uo_out<4> 0.03102f
C5068 uo_out<6> uo_out<5> 0.03102f
C5069 uo_out<7> uo_out<6> 0.03102f
.ends
