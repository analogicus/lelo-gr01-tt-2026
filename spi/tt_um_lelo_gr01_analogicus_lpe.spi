* NGSPICE file created from tt_um_lelo_gr01_analogicus.ext - technology: sky130A

* Replacing the lpe port list (../tech/scripts/fixlpe)
.subckt tt_um_lelo_gr01_analogicus uo_out<7> uo_out<6> uo_out<5> uo_out<4> uo_out<3> uo_out<2>
+ uio_out<7> uio_out<6> uio_out<5> uio_out<4> uio_out<3> uio_out<2> uio_out<1> uio_out<0> uio_oe<7> uio_oe<6> uio_oe<5> uio_oe<4> uio_oe<3> uio_oe<2> uio_oe<1> uio_oe<0> VDPWR VGND
+ ui_in<7> ui_in<6> ui_in<5> ui_in<4> ui_in<3> ui_in<2> ui_in<1> ui_in<0> uio_in<7> uio_in<6> uio_in<5> uio_in<4> uio_in<3> uio_in<2> uio_in<1> uio_in<0> ena rst_n clk uo_out<0> uo_out<1>
*.subckt tt_um_lelo_gr01_analogicus clk ena rst_n ui_in<0> ui_in<1> ui_in<2> ui_in<3>
*+ ui_in<4> ui_in<5> ui_in<6> ui_in<7> uio_in<0> uio_in<1> uio_in<2> uio_in<3> uio_in<4>
*+ uio_in<5> uio_in<6> uio_in<7> uio_oe<0> uio_oe<1> uio_oe<2> uio_oe<3> uio_oe<4>
*+ uio_oe<5> uio_oe<6> uio_oe<7> uio_out<0> uio_out<1> uio_out<2> uio_out<3> uio_out<4>
*+ uio_out<5> uio_out<6> uio_out<7> uo_out<0> uo_out<1> uo_out<2> uo_out<3> uo_out<4>
*+ uo_out<5> uo_out<6> uo_out<7> VDPWR VGND
X0 a_7501_2588# a_7055_2588# a_7405_2588# VGND sky130_fd_pr__special_nfet_01v8 ad=0.1401 pd=1.1 as=0.0594 ps=0.69 w=0.36 l=0.15
X1 a_11758_188# digital_0._063_.A a_11673_n132# VDPWR sky130_fd_pr__pfet_01v8_hvt ad=0.135 pd=1.27 as=0.135 ps=1.27 w=1 l=0.15
X2 a_7302_n132# a_7088_n132# VDPWR VDPWR sky130_fd_pr__pfet_01v8_hvt ad=0.1155 pd=0.97 as=0.07035 ps=0.755 w=0.42 l=0.15
X3 a_8324_2588# digital_0._109_.RESET_B VGND VGND sky130_fd_pr__nfet_01v8 ad=0.06405 pd=0.725 as=0.12495 ps=1.015 w=0.42 l=0.15
X4 digital_0.clkbuf_1_0__f_clk.X a_6315_1474# VGND VGND sky130_fd_pr__nfet_01v8 ad=0.0588 pd=0.7 as=0.0588 ps=0.7 w=0.42 l=0.15
X5 VGND a_10253_930# digital_0._060_.B VGND sky130_fd_pr__nfet_01v8 ad=0.169 pd=1.82 as=0.08775 ps=0.92 w=0.65 l=0.15
X6 LELO_GR01_0.x7.x3.P a_9434_9234# VGND sky130_fd_pr__res_high_po w=0.36 l=7.36
X7 VDPWR LELO_GR01_0.x7.xd1<4>.A sky130_fd_pr__cap_mim_m3_1 l=5 w=5
X8 VGND VGND LELO_GR01_0.x7.x15.I1 sky130_fd_pr__pnp_05v5_W3p40L3p40
**devattr s=462400,2720
X9 a_6959_234# a_6397_n158# VGND VGND sky130_fd_pr__nfet_01v8 ad=0.0669 pd=0.75 as=0.12495 ps=1.015 w=0.42 l=0.15
X10 VGND digital_0.clkbuf_1_1__f_clk.A a_11388_956# VGND sky130_fd_pr__nfet_01v8 ad=0.0588 pd=0.7 as=0.0588 ps=0.7 w=0.42 l=0.15
X11 VDPWR VGND VDPWR VDPWR sky130_fd_pr__pfet_01v8_hvt ad=0.2262 pd=2.26 as=144.64371 ps=1.26674k w=0.87 l=0.59
X12 VDPWR a_12929_2562# digital_0._110_.Q VDPWR sky130_fd_pr__pfet_01v8_hvt ad=0.26 pd=2.52 as=0.135 ps=1.27 w=1 l=0.15
X13 a_7349_3132# digital_0._109_.Q digital_0._069_.B VDPWR sky130_fd_pr__pfet_01v8_hvt ad=0.36 pd=2.72 as=0.135 ps=1.27 w=1 l=0.15
X14 VDPWR VGND VDPWR VDPWR sky130_fd_pr__pfet_01v8_hvt ad=0.2262 pd=2.26 as=0 ps=0 w=0.87 l=0.59
X15 a_7786_412# a_6705_412# a_7439_654# VDPWR sky130_fd_pr__pfet_01v8_hvt ad=0.0588 pd=0.7 as=0.12915 ps=1.185 w=0.42 l=0.15
X16 a_9631_2050# a_9465_2050# VDPWR VDPWR sky130_fd_pr__pfet_01v8_hvt ad=0.1664 pd=1.8 as=0.0864 ps=0.91 w=0.64 l=0.15
X17 VGND digital_0.hold28.X a_5328_n132# VGND sky130_fd_pr__nfet_01v8 ad=0.2205 pd=1.89 as=0.066 ps=0.745 w=0.42 l=0.15
X18 digital_0.clkbuf_1_1__f_clk.A a_8996_1500# VGND VGND sky130_fd_pr__nfet_01v8 ad=0.0588 pd=0.7 as=0.0588 ps=0.7 w=0.42 l=0.15
X19 VGND a_14175_n702# a_14109_n676# VGND sky130_fd_pr__nfet_01v8 ad=0.1449 pd=1.11 as=0.0693 ps=0.75 w=0.42 l=0.15
X20 a_13746_n524# digital_0._113_.Q a_13888_n676# VGND sky130_fd_pr__nfet_01v8 ad=0.09975 pd=0.895 as=0.0693 ps=0.75 w=0.42 l=0.15
X21 a_12849_1866# a_12225_1500# a_12741_1500# VDPWR sky130_fd_pr__pfet_01v8_hvt ad=0.1155 pd=0.97 as=0.07245 ps=0.765 w=0.42 l=0.15
X22 VDPWR a_5109_2348# a_5096_2044# VDPWR sky130_fd_pr__pfet_01v8_hvt ad=0.0819 pd=0.81 as=0.0567 ps=0.69 w=0.42 l=0.15
X23 a_27670_16564# a_27454_14644# VGND sky130_fd_pr__res_high_po w=0.36 l=7.36
X24 LELO_GR01_0.x8.x5.Q uo_out<0> LELO_GR01_0.x8.x8.D LELO_GR01_0.x8.x8.D sky130_fd_pr__pfet_01v8 ad=0.468 pd=2.84 as=0.468 ps=2.84 w=0.9 l=0.16
X25 a_7961_386# digital_0._115_.RESET_B VDPWR VDPWR sky130_fd_pr__pfet_01v8_hvt ad=0.0567 pd=0.69 as=0.0819 ps=0.81 w=0.42 l=0.15
X26 LELO_GR01_0.x7.x20.D LELO_GR01_0.x8.PWRUP_N_1V8 LELO_GR01_0.x7.x21.D VDPWR sky130_fd_pr__pfet_01v8_lvt ad=0.3168 pd=1.62 as=0.5088 ps=2.98 w=0.96 l=0.94
X27 VDPWR digital_0._080_.A2 a_5785_n426# VDPWR sky130_fd_pr__pfet_01v8_hvt ad=0.1575 pd=1.315 as=0.26 ps=2.52 w=1 l=0.15
X28 digital_0._105_.RESET_B digital_0.load_slew17.X VGND VGND sky130_fd_pr__nfet_01v8 ad=0.08775 pd=0.92 as=0.169 ps=1.82 w=0.65 l=0.15
X29 VDPWR VGND VDPWR VDPWR sky130_fd_pr__pfet_01v8_hvt ad=0.2262 pd=2.26 as=0 ps=0 w=0.87 l=0.59
X30 digital_0._109_.RESET_B digital_0._116_.Q VGND VGND sky130_fd_pr__nfet_01v8 ad=0.08775 pd=0.92 as=0.182 ps=1.86 w=0.65 l=0.15
X31 a_7961_386# a_7786_412# a_8140_412# VGND sky130_fd_pr__nfet_01v8 ad=0.1092 pd=1.36 as=0.06405 ps=0.725 w=0.42 l=0.15
X32 a_6263_2562# digital_0.hold28.A VDPWR VDPWR sky130_fd_pr__pfet_01v8_hvt ad=0.1176 pd=1.4 as=0.0693 ps=0.75 w=0.42 l=0.15
X33 a_10253_930# digital_0._113_.Q a_10839_1276# VGND sky130_fd_pr__nfet_01v8 ad=0.169 pd=1.82 as=0.08775 ps=0.92 w=0.65 l=0.15
X34 VGND a_10721_2348# a_10655_2422# VGND sky130_fd_pr__nfet_01v8 ad=0.12495 pd=1.015 as=0.0669 ps=0.75 w=0.42 l=0.15
X35 VGND VDPWR VGND VGND sky130_fd_pr__nfet_01v8 ad=0.143 pd=1.62 as=177.20654 ps=1.38017k w=0.55 l=0.59
X36 a_10514_11154# a_10730_9234# VGND sky130_fd_pr__res_high_po w=0.36 l=7.36
X37 a_25270_13064# a_25054_11144# VGND sky130_fd_pr__res_high_po w=0.36 l=7.36
X38 a_10243_2410# a_10199_2018# a_10077_2422# VGND sky130_fd_pr__nfet_01v8 ad=0.0441 pd=0.63 as=0.1401 ps=1.1 w=0.42 l=0.15
X39 a_5450_6824# a_5234_4904# VGND sky130_fd_pr__res_high_po w=0.36 l=7.36
X40 digital_0._113_.D a_11758_188# a_12116_n132# VDPWR sky130_fd_pr__pfet_01v8_hvt ad=0.135 pd=1.27 as=0.26 ps=2.52 w=1 l=0.15
X41 digital_0._119_.RESET_B digital_0.load_slew15.X VDPWR VDPWR sky130_fd_pr__pfet_01v8_hvt ad=0.135 pd=1.27 as=0.26 ps=2.52 w=1 l=0.15
X42 VGND a_4609_110# a_4570_n16# VGND sky130_fd_pr__nfet_01v8 ad=0.0567 pd=0.69 as=0.1092 ps=1.36 w=0.42 l=0.15
X43 a_6684_0# a_6962_n16# a_6918_n132# VDPWR sky130_fd_pr__pfet_01v8_hvt ad=0.0588 pd=0.7 as=0.0567 ps=0.69 w=0.42 l=0.15
X44 a_10795_3498# a_10751_3106# a_10629_3510# VGND sky130_fd_pr__nfet_01v8 ad=0.0441 pd=0.63 as=0.1401 ps=1.1 w=0.42 l=0.15
X45 a_11484_1500# digital_0._065_.A2_N VGND VGND sky130_fd_pr__nfet_01v8 ad=0.08937 pd=0.925 as=0.18525 ps=1.87 w=0.65 l=0.15
X46 a_9005_956# digital_0.load_slew15.A digital_0._114_.RESET_B VDPWR sky130_fd_pr__pfet_01v8_hvt ad=0.26 pd=2.52 as=0.135 ps=1.27 w=1 l=0.15
X47 VGND VDPWR VGND VGND sky130_fd_pr__nfet_01v8 ad=0.143 pd=1.62 as=0 ps=0 w=0.55 l=0.59
X48 digital_0._108_.Q a_7593_2348# VDPWR VDPWR sky130_fd_pr__pfet_01v8_hvt ad=0.135 pd=1.27 as=0.3012 ps=2.66 w=1 l=0.15
X49 VDPWR a_10199_n158# a_10089_n132# VDPWR sky130_fd_pr__pfet_01v8_hvt ad=0.07035 pd=0.755 as=0.1155 ps=0.97 w=0.42 l=0.15
X50 a_6209_386# digital_0.output6.A VGND VGND sky130_fd_pr__nfet_01v8 ad=0.1092 pd=1.36 as=0.0567 ps=0.69 w=0.42 l=0.15
X51 a_14727_1474# digital_0.hold28.A VDPWR VDPWR sky130_fd_pr__pfet_01v8_hvt ad=0.1176 pd=1.4 as=0.0693 ps=0.75 w=0.42 l=0.15
X52 digital_0._105_.RESET_B digital_0.load_slew17.X VDPWR VDPWR sky130_fd_pr__pfet_01v8_hvt ad=0.135 pd=1.27 as=0.26 ps=2.52 w=1 l=0.15
X53 LELO_GR01_0.x8.x1.x7.D LELO_GR01_0.PWRUP_1V8 VDPWR VDPWR sky130_fd_pr__pfet_01v8_lvt ad=0.3168 pd=1.62 as=0.5088 ps=2.98 w=0.96 l=0.94
X54 VGND VDPWR VGND VGND sky130_fd_pr__nfet_01v8 ad=0.143 pd=1.62 as=0 ps=0 w=0.55 l=0.59
X55 a_14686_246# a_13771_n126# a_14339_n158# VGND sky130_fd_pr__special_nfet_01v8 ad=0.0711 pd=0.755 as=0.0999 ps=0.985 w=0.36 l=0.15
X56 VGND a_7643_n702# a_7577_n676# VGND sky130_fd_pr__nfet_01v8 ad=0.1449 pd=1.11 as=0.0693 ps=0.75 w=0.42 l=0.15
X57 LELO_GR01_0.x7.x29.P a_19234_11144# VGND sky130_fd_pr__res_high_po w=0.36 l=7.36
X58 a_8684_6824# a_8900_4904# VGND sky130_fd_pr__res_high_po w=0.36 l=7.36
X59 digital_0._060_.B a_10253_930# VDPWR VDPWR sky130_fd_pr__pfet_01v8_hvt ad=0.135 pd=1.27 as=0.26 ps=2.52 w=1 l=0.15
X60 digital_0._112_.D digital_0._063_.B a_13513_956# VDPWR sky130_fd_pr__pfet_01v8_hvt ad=0.135 pd=1.27 as=0.135 ps=1.27 w=1 l=0.15
X61 a_7099_956# digital_0._115_.Q VDPWR VDPWR sky130_fd_pr__pfet_01v8_hvt ad=0.26 pd=2.52 as=0.135 ps=1.27 w=1 l=0.15
X62 a_12034_2404# digital_0._112_.Q a_11951_2146# VGND sky130_fd_pr__nfet_01v8 ad=0.0441 pd=0.63 as=0.1092 ps=1.36 w=0.42 l=0.15
X63 VDPWR digital_0._108_.Q a_5787_2146# VDPWR sky130_fd_pr__pfet_01v8_hvt ad=0.15075 pd=1.345 as=0.07438 ps=0.815 w=0.42 l=0.15
X64 a_4833_3436# digital_0._117_.RESET_B VDPWR VDPWR sky130_fd_pr__pfet_01v8_hvt ad=0.0567 pd=0.69 as=0.0819 ps=0.81 w=0.42 l=0.15
X65 digital_0._108_.RESET_B digital_0.load_slew15.A a_8837_2838# VDPWR sky130_fd_pr__pfet_01v8_hvt ad=0.135 pd=1.27 as=0.26 ps=2.52 w=1 l=0.15
R0 uio_oe<7> JNWTR_TIEL_CV_0.Y sky130_fd_pr__res_generic_m4 w=0.3 l=0.3
X66 VGND digital_0._067_.B digital_0._110_.D VGND sky130_fd_pr__nfet_01v8 ad=0.169 pd=1.82 as=0.08775 ps=0.92 w=0.65 l=0.15
X67 digital_0.clkload0.A a_11388_956# VDPWR VDPWR sky130_fd_pr__pfet_01v8_hvt ad=0.14 pd=1.28 as=0.14 ps=1.28 w=1 l=0.15
X68 digital_0.clkbuf_1_1__f_clk.A a_8996_1500# VDPWR VDPWR sky130_fd_pr__pfet_01v8_hvt ad=0.14 pd=1.28 as=0.14 ps=1.28 w=1 l=0.15
X69 a_11207_3510# a_10017_3138# a_11098_3510# VGND sky130_fd_pr__special_nfet_01v8 ad=0.0669 pd=0.75 as=0.0711 ps=0.755 w=0.36 l=0.15
X70 VGND digital_0._102_.RESET_B a_14291_3498# VGND sky130_fd_pr__nfet_01v8 ad=0.1346 pd=1.15 as=0.0441 ps=0.63 w=0.42 l=0.15
X71 a_14769_3436# a_14594_3510# a_14948_3498# VGND sky130_fd_pr__nfet_01v8 ad=0.1092 pd=1.36 as=0.06405 ps=0.725 w=0.42 l=0.15
X72 JNWTR_ORX1_CV_0.XA1.MP1.S JNWTR_ORX1_CV_0.A VDPWR VDPWR sky130_fd_pr__pfet_01v8 ad=0.288 pd=1.54 as=0.468 ps=2.84 w=0.9 l=0.16
X73 a_5595_1334# a_4405_962# a_5486_1334# VGND sky130_fd_pr__special_nfet_01v8 ad=0.0669 pd=0.75 as=0.0711 ps=0.755 w=0.36 l=0.15
X74 VDPWR VGND VDPWR VDPWR sky130_fd_pr__pfet_01v8_hvt ad=0.2262 pd=2.26 as=0 ps=0 w=0.87 l=0.59
X75 VDPWR VGND VDPWR VDPWR sky130_fd_pr__pfet_01v8_hvt ad=0.2262 pd=2.26 as=0 ps=0 w=0.87 l=0.59
X76 VDPWR a_13612_3650# uio_out<2> VDPWR sky130_fd_pr__pfet_01v8_hvt ad=0.2726 pd=1.61 as=0.495 ps=2.99 w=1 l=0.15
X77 VGND a_10495_n702# a_10429_n676# VGND sky130_fd_pr__nfet_01v8 ad=0.1449 pd=1.11 as=0.0693 ps=0.75 w=0.42 l=0.15
X78 a_4396_412# a_4118_412# a_4324_412# VGND sky130_fd_pr__nfet_01v8 ad=0.0441 pd=0.63 as=0.0441 ps=0.63 w=0.42 l=0.15
X79 VGND digital_0.load_slew15.A a_8085_1500# VGND sky130_fd_pr__nfet_01v8 ad=0.08775 pd=0.92 as=0.169 ps=1.82 w=0.65 l=0.15
X80 a_10629_3510# a_10183_3138# a_10533_3510# VGND sky130_fd_pr__special_nfet_01v8 ad=0.1401 pd=1.1 as=0.0594 ps=0.69 w=0.36 l=0.15
X81 digital_0._080_.A2 digital_0.input2.X VDPWR VDPWR sky130_fd_pr__pfet_01v8_hvt ad=0.135 pd=1.27 as=0.26 ps=2.52 w=1 l=0.15
X82 VGND a_10074_2562# digital_0._111_.D VGND sky130_fd_pr__nfet_01v8 ad=0.09862 pd=0.98 as=0.08775 ps=0.92 w=0.65 l=0.15
X83 LELO_GR01_0.x8.x5.XA5.A LELO_GR01_0.x8.x5.XA7.C LELO_GR01_0.x8.x5.XA4.MP1.S LELO_GR01_0.x8.x8.D sky130_fd_pr__pfet_01v8 ad=0.468 pd=2.84 as=0.288 ps=1.54 w=0.9 l=0.16
X84 a_9116_6824# a_8900_4904# VGND sky130_fd_pr__res_high_po w=0.36 l=7.36
X85 a_16872_16564# a_16656_14644# VGND sky130_fd_pr__res_high_po w=0.36 l=7.36
X86 VGND digital_0.clkload0.A a_13605_n126# VGND sky130_fd_pr__nfet_01v8 ad=0.0567 pd=0.69 as=0.1092 ps=1.36 w=0.42 l=0.15
X87 a_5017_1334# a_4571_962# a_4921_1334# VGND sky130_fd_pr__special_nfet_01v8 ad=0.1401 pd=1.1 as=0.0594 ps=0.69 w=0.36 l=0.15
X88 LELO_GR01_0.x8.x1.x7.D LELO_GR01_0.x8.x1.x7.D VDPWR VDPWR sky130_fd_pr__pfet_01v8_lvt ad=0.3168 pd=1.62 as=0.5088 ps=2.98 w=0.96 l=0.94
X89 a_12959_1742# a_12741_1500# VDPWR VDPWR sky130_fd_pr__pfet_01v8_hvt ad=0.12915 pd=1.185 as=0.2184 ps=2.2 w=0.84 l=0.15
X90 VGND digital_0.input1.X a_12225_1500# VGND sky130_fd_pr__nfet_01v8 ad=0.0567 pd=0.69 as=0.1092 ps=1.36 w=0.42 l=0.15
X91 LELO_GR01_0.x7.x28.e a_16214_11144# VGND sky130_fd_pr__res_high_po w=0.36 l=7.36
X92 LELO_GR01_0.x8.x1.x5.x8.G LELO_GR01_0.x8.x1.x5.x9<2>.G VGND VGND sky130_fd_pr__nfet_01v8_lvt ad=0.3168 pd=1.62 as=0.5088 ps=2.98 w=0.96 l=0.94
X93 VDPWR a_8996_1500# digital_0.clkbuf_1_1__f_clk.A VDPWR sky130_fd_pr__pfet_01v8_hvt ad=0.14 pd=1.28 as=0.14 ps=1.28 w=1 l=0.15
X94 LELO_GR01_0.x8.IBP_BG LELO_GR01_0.x7.xd1<4>.A VDPWR VDPWR sky130_fd_pr__pfet_01v8_lvt ad=0.3168 pd=1.62 as=0.5088 ps=2.98 w=0.96 l=0.94
X95 digital_0._113_.RESET_B digital_0.input3.X a_15537_n132# VDPWR sky130_fd_pr__pfet_01v8_hvt ad=0.135 pd=1.27 as=0.135 ps=1.27 w=1 l=0.15
X96 VGND a_11388_956# digital_0.clkload0.A VGND sky130_fd_pr__nfet_01v8 ad=0.0588 pd=0.7 as=0.0588 ps=0.7 w=0.42 l=0.15
X97 VDPWR VGND VDPWR VDPWR sky130_fd_pr__pfet_01v8_hvt ad=0.2262 pd=2.26 as=0 ps=0 w=0.87 l=0.59
X98 LELO_GR01_0.x7.x29.P a_23550_11144# VGND sky130_fd_pr__res_high_po w=0.36 l=7.36
X99 VDPWR digital_0._116_.Q a_9557_2838# VDPWR sky130_fd_pr__pfet_01v8_hvt ad=0.135 pd=1.27 as=0.28 ps=2.56 w=1 l=0.15
X100 VGND digital_0._100_.RESET_B a_4143_2588# VGND sky130_fd_pr__nfet_01v8 ad=0.12495 pd=1.015 as=0.06405 ps=0.725 w=0.42 l=0.15
X101 a_7155_930# digital_0._115_.Q VGND VGND sky130_fd_pr__nfet_01v8 ad=0.08775 pd=0.92 as=0.08775 ps=0.92 w=0.65 l=0.15
X102 VDPWR digital_0._116_.Q a_3471_1474# VDPWR sky130_fd_pr__pfet_01v8_hvt ad=0.1176 pd=1.4 as=0.0567 ps=0.69 w=0.42 l=0.15
X103 VDPWR a_6209_386# a_5951_386# VDPWR sky130_fd_pr__pfet_01v8_hvt ad=0.0567 pd=0.69 as=0.1092 ps=1.36 w=0.42 l=0.5
X104 digital_0.clkbuf_1_0__f_clk.X a_6315_1474# VGND VGND sky130_fd_pr__nfet_01v8 ad=0.0588 pd=0.7 as=0.0588 ps=0.7 w=0.42 l=0.15
X105 VDPWR a_4833_3436# a_4820_3132# VDPWR sky130_fd_pr__pfet_01v8_hvt ad=0.0819 pd=0.81 as=0.0567 ps=0.69 w=0.42 l=0.15
X106 VGND digital_0._112_.RESET_B a_13003_412# VGND sky130_fd_pr__nfet_01v8 ad=0.1346 pd=1.15 as=0.0441 ps=0.63 w=0.42 l=0.15
X107 a_10412_6824# a_10196_4904# VGND sky130_fd_pr__res_high_po w=0.36 l=7.36
X108 LELO_GR01_0.x8.x1.x5.IBN LELO_GR01_0.x8.VREF_BG LELO_GR01_0.x8.x7.D VGND sky130_fd_pr__nfet_01v8_lvt ad=0.5088 pd=2.98 as=0.3168 ps=1.62 w=0.96 l=0.94
X109 digital_0._063_.B digital_0._112_.Q a_11397_1750# VDPWR sky130_fd_pr__pfet_01v8_hvt ad=0.135 pd=1.27 as=0.135 ps=1.27 w=1 l=0.15
X110 a_8895_412# a_8729_412# VDPWR VDPWR sky130_fd_pr__pfet_01v8_hvt ad=0.1664 pd=1.8 as=0.0864 ps=0.91 w=0.64 l=0.15
X111 a_10986_3828# digital_0._111_.Q a_11128_3676# VGND sky130_fd_pr__nfet_01v8 ad=0.09975 pd=0.895 as=0.0693 ps=0.75 w=0.42 l=0.15
X112 VDPWR a_14762_2018# digital_0.load_slew17.X VDPWR sky130_fd_pr__pfet_01v8_hvt ad=0.149 pd=1.325 as=0.135 ps=1.27 w=1 l=0.15
X113 a_6906_3132# digital_0.output13.A VDPWR VDPWR sky130_fd_pr__pfet_01v8_hvt ad=0.275 pd=2.55 as=0.135 ps=1.27 w=1 l=0.15
X114 VGND VDPWR VGND VGND sky130_fd_pr__nfet_01v8 ad=0.143 pd=1.62 as=0 ps=0 w=0.55 l=0.59
X115 a_10721_2348# digital_0._111_.RESET_B VDPWR VDPWR sky130_fd_pr__pfet_01v8_hvt ad=0.0567 pd=0.69 as=0.0819 ps=0.81 w=0.42 l=0.15
X116 VDPWR a_14624_386# digital_0.input3.X VDPWR sky130_fd_pr__pfet_01v8_hvt ad=0.2726 pd=1.61 as=0.495 ps=2.99 w=1 l=0.15
X117 a_12863_2588# a_11673_2588# a_12754_2588# VGND sky130_fd_pr__special_nfet_01v8 ad=0.0669 pd=0.75 as=0.0711 ps=0.755 w=0.36 l=0.15
X118 JNWTR_TIEL_CV_0.Y JNWTR_TIEL_CV_0.MP0.G VGND VGND sky130_fd_pr__nfet_01v8 ad=0.468 pd=2.84 as=0.468 ps=2.84 w=0.9 l=0.16
X119 VDPWR a_11388_956# digital_0.clkload0.A VDPWR sky130_fd_pr__pfet_01v8_hvt ad=0.265 pd=2.53 as=0.14 ps=1.28 w=1 l=0.15
X120 digital_0.hold25.X a_5321_3676# VDPWR VDPWR sky130_fd_pr__pfet_01v8_hvt ad=0.26 pd=2.52 as=0.14075 ps=1.325 w=1 l=0.15
X121 LELO_GR01_0.x8.x1.x5.x9<2>.G LELO_GR01_0.x8.x1.x5.x8.G LELO_GR01_0.x8.x1.x5.x8.G VGND sky130_fd_pr__nfet_01v8_lvt ad=0.5088 pd=2.98 as=0.3168 ps=1.62 w=0.96 l=0.94
X122 digital_0._113_.RESET_B digital_0.input3.X VGND VGND sky130_fd_pr__nfet_01v8 ad=0.08775 pd=0.92 as=0.08775 ps=0.92 w=0.65 l=0.15
X123 a_6235_3106# digital_0.output13.A VGND VGND sky130_fd_pr__nfet_01v8 ad=0.08775 pd=0.92 as=0.08775 ps=0.92 w=0.65 l=0.15
X124 VDPWR a_11273_3436# digital_0.output8.A VDPWR sky130_fd_pr__pfet_01v8_hvt ad=0.26 pd=2.52 as=0.135 ps=1.27 w=1 l=0.15
X125 a_4567_234# a_4005_n158# VGND VGND sky130_fd_pr__nfet_01v8 ad=0.0669 pd=0.75 as=0.12495 ps=1.015 w=0.42 l=0.15
X126 VGND a_14871_n524# digital_0.hold27.X VGND sky130_fd_pr__nfet_01v8 ad=0.097 pd=0.975 as=0.169 ps=1.82 w=0.65 l=0.15
X127 a_6761_930# digital_0.hold28.A VGND VGND sky130_fd_pr__nfet_01v8 ad=0.1092 pd=1.36 as=0.0567 ps=0.69 w=0.42 l=0.15
X128 a_14137_3132# digital_0._102_.RESET_B VDPWR VDPWR sky130_fd_pr__pfet_01v8_hvt ad=0.1092 pd=1.36 as=0.07035 ps=0.755 w=0.42 l=0.15
X129 VDPWR LELO_GR01_0.x8.x1.x7.D LELO_GR01_0.x8.x7.D VDPWR sky130_fd_pr__pfet_01v8_lvt ad=0.5088 pd=2.98 as=0.3168 ps=1.62 w=0.96 l=0.94
X130 VDPWR a_12407_2830# a_12297_2954# VDPWR sky130_fd_pr__pfet_01v8_hvt ad=0.07035 pd=0.755 as=0.1155 ps=0.97 w=0.42 l=0.15
X131 VGND digital_0.load_slew15.X digital_0._118_.RESET_B VGND sky130_fd_pr__nfet_01v8 ad=0.169 pd=1.82 as=0.08775 ps=0.92 w=0.65 l=0.15
X132 a_7717_3926# digital_0.load_slew15.A digital_0._109_.RESET_B VDPWR sky130_fd_pr__pfet_01v8_hvt ad=0.26 pd=2.52 as=0.135 ps=1.27 w=1 l=0.15
X133 a_10514_11154# a_10298_9234# VGND sky130_fd_pr__res_high_po w=0.36 l=7.36
X134 a_9810_412# a_8895_412# a_9463_654# VGND sky130_fd_pr__special_nfet_01v8 ad=0.0711 pd=0.755 as=0.0999 ps=0.985 w=0.36 l=0.15
X135 LELO_GR01_0.x8.x1.x5.x6.N a_22292_9483# VGND sky130_fd_pr__res_high_po w=0.36 l=7.36
X136 VGND a_6315_1474# digital_0.clkbuf_1_0__f_clk.X VGND sky130_fd_pr__nfet_01v8 ad=0.0588 pd=0.7 as=0.0588 ps=0.7 w=0.42 l=0.15
X137 a_5018_6824# a_5234_4904# VGND sky130_fd_pr__res_high_po w=0.36 l=7.36
X138 VDPWR ui_in<0> a_8361_n132# VDPWR sky130_fd_pr__pfet_01v8_hvt ad=0.19265 pd=1.415 as=0.27 ps=2.54 w=1 l=0.15
X139 VDPWR VGND VDPWR VDPWR sky130_fd_pr__pfet_01v8_hvt ad=0.2262 pd=2.26 as=0 ps=0 w=0.87 l=0.59
X140 VGND digital_0.input2.X digital_0._080_.A2 VGND sky130_fd_pr__nfet_01v8 ad=0.169 pd=1.82 as=0.08775 ps=0.92 w=0.65 l=0.15
X141 VGND a_12718_3676# a_12829_3676# VGND sky130_fd_pr__nfet_01v8 ad=0.1856 pd=1.26 as=0.17225 ps=1.83 w=0.65 l=0.25
X142 a_11388_956# digital_0.clkbuf_1_1__f_clk.A VGND VGND sky130_fd_pr__nfet_01v8 ad=0.0588 pd=0.7 as=0.0588 ps=0.7 w=0.42 l=0.15
X143 digital_0._100_.RESET_B digital_0.load_slew15.X VDPWR VDPWR sky130_fd_pr__pfet_01v8_hvt ad=0.135 pd=1.27 as=0.26 ps=2.52 w=1 l=0.15
X144 digital_0.clkload0.A a_11388_956# VDPWR VDPWR sky130_fd_pr__pfet_01v8_hvt ad=0.14 pd=1.28 as=0.14 ps=1.28 w=1 l=0.15
X145 a_4581_2825# a_4425_2730# a_4726_2954# VDPWR sky130_fd_pr__pfet_01v8_hvt ad=0.07245 pd=0.765 as=0.1155 ps=0.97 w=0.42 l=0.15
X146 VDPWR digital_0._065_.A2_N a_10285_2910# VDPWR sky130_fd_pr__pfet_01v8_hvt ad=0.2272 pd=1.35 as=0.173 ps=1.4 w=0.64 l=0.15
X147 a_14781_956# digital_0._104_.RESET_B VDPWR VDPWR sky130_fd_pr__pfet_01v8_hvt ad=0.1092 pd=1.36 as=0.07035 ps=0.755 w=0.42 l=0.15
X148 VDPWR a_14871_n524# digital_0.hold27.X VDPWR sky130_fd_pr__pfet_01v8_hvt ad=0.14075 pd=1.325 as=0.26 ps=2.52 w=1 l=0.15
X149 a_18168_16564# a_17952_14644# VGND sky130_fd_pr__res_high_po w=0.36 l=7.36
X150 LELO_GR01_0.x8.x8.D VDPWR LELO_GR01_0.x8.x5.XA7.MP1.S LELO_GR01_0.x8.x8.D sky130_fd_pr__pfet_01v8 ad=0.288 pd=1.54 as=0.468 ps=2.84 w=0.9 l=0.16
X151 VGND a_6761_930# a_6503_930# VGND sky130_fd_pr__nfet_01v8 ad=0.0567 pd=0.69 as=0.1092 ps=1.36 w=0.42 l=0.5
X152 a_10986_3828# digital_0.hold20.X a_11128_4003# VDPWR sky130_fd_pr__pfet_01v8_hvt ad=0.1932 pd=1.34 as=0.07665 ps=0.785 w=0.42 l=0.15
X153 a_28934_13064# a_28718_11144# VGND sky130_fd_pr__res_high_po w=0.36 l=7.36
X154 a_11772_n702# a_11898_n518# VGND VGND sky130_fd_pr__nfet_01v8 ad=0.17225 pd=1.83 as=0.1856 ps=1.26 w=0.65 l=0.25
X155 VGND VDPWR VGND VGND sky130_fd_pr__nfet_01v8 ad=0.143 pd=1.62 as=0 ps=0 w=0.55 l=0.59
X156 VGND VGND LELO_GR01_0.x7.x15.I2 sky130_fd_pr__pnp_05v5_W3p40L3p40
**devattr s=462400,2720
X157 VGND VDPWR VGND VGND sky130_fd_pr__nfet_01v8 ad=0.143 pd=1.62 as=0 ps=0 w=0.55 l=0.59
X158 a_11128_4003# digital_0.hold28.A VDPWR VDPWR sky130_fd_pr__pfet_01v8_hvt ad=0.07665 pd=0.785 as=0.15835 ps=1.395 w=0.42 l=0.15
X159 VDPWR VGND VDPWR VDPWR sky130_fd_pr__pfet_01v8_hvt ad=0.2262 pd=2.26 as=0 ps=0 w=0.87 l=0.59
X160 VDPWR a_14686_246# a_14861_172# VDPWR sky130_fd_pr__pfet_01v8_hvt ad=0.1134 pd=1.38 as=0.0567 ps=0.69 w=0.42 l=0.15
X161 VDPWR a_3814_386# digital_0._116_.Q VDPWR sky130_fd_pr__pfet_01v8_hvt ad=0.135 pd=1.27 as=0.135 ps=1.27 w=1 l=0.15
X162 a_6293_2915# digital_0._108_.Q a_5834_2740# VDPWR sky130_fd_pr__pfet_01v8_hvt ad=0.0441 pd=0.63 as=0.1932 ps=1.34 w=0.42 l=0.15
X163 VGND digital_0.load_slew17.A digital_0._111_.RESET_B VGND sky130_fd_pr__nfet_01v8 ad=0.169 pd=1.82 as=0.08775 ps=0.92 w=0.65 l=0.15
X164 VDPWR digital_0.load_slew17.A digital_0._103_.RESET_B VDPWR sky130_fd_pr__pfet_01v8_hvt ad=0.26 pd=2.52 as=0.135 ps=1.27 w=1 l=0.15
X165 a_4826_1322# digital_0._118_.D VGND VGND sky130_fd_pr__nfet_01v8 ad=0.066 pd=0.745 as=0.2205 ps=1.89 w=0.42 l=0.15
X166 a_13934_3498# digital_0._102_.D VDPWR VDPWR sky130_fd_pr__pfet_01v8_hvt ad=0.0651 pd=0.73 as=0.1092 ps=1.36 w=0.42 l=0.15
X167 LELO_GR01_0.x7.x7.S LELO_GR01_0.x7.x6<3>.G LELO_GR01_0.x7.x6<3>.G VGND sky130_fd_pr__nfet_01v8_lvt ad=0.5088 pd=2.98 as=0.3168 ps=1.62 w=0.96 l=0.94
X168 VDPWR a_10721_2348# a_10708_2044# VDPWR sky130_fd_pr__pfet_01v8_hvt ad=0.0819 pd=0.81 as=0.0567 ps=0.69 w=0.42 l=0.15
X169 a_14891_930# a_14673_1334# VGND VGND sky130_fd_pr__nfet_01v8 ad=0.0999 pd=0.985 as=0.1346 ps=1.15 w=0.64 l=0.15
X170 digital_0._063_.B digital_0._069_.A a_11484_1500# VGND sky130_fd_pr__nfet_01v8 ad=0.091 pd=0.93 as=0.08937 ps=0.925 w=0.65 l=0.15
X171 a_5144_2954# a_4386_2856# a_4581_2825# VDPWR sky130_fd_pr__pfet_01v8_hvt ad=0.0651 pd=0.73 as=0.07245 ps=0.765 w=0.42 l=0.15
X172 VDPWR a_11673_412# digital_0.clkload0.X VDPWR sky130_fd_pr__pfet_01v8_hvt ad=0.3 pd=2.6 as=0.14 ps=1.28 w=1 l=0.15
X173 a_5056_n702# a_5182_n518# VGND VGND sky130_fd_pr__nfet_01v8 ad=0.17225 pd=1.83 as=0.1856 ps=1.26 w=0.65 l=0.25
X174 LELO_GR01_0.x7.x7.S LELO_GR01_0.x7.x7.G VGND VDPWR sky130_fd_pr__pfet_01v8_lvt ad=0.5088 pd=2.98 as=0.3168 ps=1.62 w=0.96 l=0.94
X175 digital_0._110_.D digital_0._067_.B a_11949_3132# VDPWR sky130_fd_pr__pfet_01v8_hvt ad=0.135 pd=1.27 as=0.135 ps=1.27 w=1 l=0.15
X176 VDPWR VGND VDPWR VDPWR sky130_fd_pr__pfet_01v8_hvt ad=0.2262 pd=2.26 as=0 ps=0 w=0.87 l=0.59
X177 a_13513_956# digital_0._063_.A VDPWR VDPWR sky130_fd_pr__pfet_01v8_hvt ad=0.135 pd=1.27 as=0.135 ps=1.27 w=1 l=0.15
X178 a_4201_3132# digital_0._117_.RESET_B VDPWR VDPWR sky130_fd_pr__pfet_01v8_hvt ad=0.1092 pd=1.36 as=0.07035 ps=0.755 w=0.42 l=0.15
X179 a_11361_n702# digital_0.output11.A VGND VGND sky130_fd_pr__nfet_01v8 ad=0.1092 pd=1.36 as=0.0567 ps=0.69 w=0.42 l=0.15
X180 VDPWR a_8996_1500# digital_0.clkbuf_1_1__f_clk.A VDPWR sky130_fd_pr__pfet_01v8_hvt ad=0.265 pd=2.53 as=0.14 ps=1.28 w=1 l=0.15
X181 VDPWR digital_0._116_.Q a_12977_2044# VDPWR sky130_fd_pr__pfet_01v8_hvt ad=0.135 pd=1.27 as=0.135 ps=1.27 w=1 l=0.15
X182 LELO_GR01_0.x8.x5.CK LELO_GR01_0.x8.x3.A VDPWR VDPWR sky130_fd_pr__pfet_01v8 ad=0.468 pd=2.84 as=0.468 ps=2.84 w=0.9 l=0.16
X183 digital_0.clkload0.X a_11673_412# VDPWR VDPWR sky130_fd_pr__pfet_01v8_hvt ad=0.14 pd=1.28 as=0.14 ps=1.28 w=1 l=0.15
X184 a_4910_n132# a_4696_n132# VDPWR VDPWR sky130_fd_pr__pfet_01v8_hvt ad=0.1155 pd=0.97 as=0.07035 ps=0.755 w=0.42 l=0.15
X185 VGND VDPWR VGND VGND sky130_fd_pr__nfet_01v8 ad=0.143 pd=1.62 as=0 ps=0 w=0.55 l=0.59
X186 a_26374_16564# a_26158_14644# VGND sky130_fd_pr__res_high_po w=0.36 l=7.36
X187 LELO_GR01_0.x7.xd1<4>.A LELO_GR01_0.x7.x15.I2 LELO_GR01_0.x7.x1.x5.IBN VGND sky130_fd_pr__nfet_01v8_lvt ad=0.3168 pd=1.62 as=0.5088 ps=2.98 w=0.96 l=0.94
X188 VDPWR a_15331_564# digital_0.hold23.X VDPWR sky130_fd_pr__pfet_01v8_hvt ad=0.14075 pd=1.325 as=0.26 ps=2.52 w=1 l=0.15
X189 a_13481_1474# digital_0._113_.RESET_B VDPWR VDPWR sky130_fd_pr__pfet_01v8_hvt ad=0.0567 pd=0.69 as=0.0819 ps=0.81 w=0.42 l=0.15
X190 digital_0._118_.D a_3471_1474# VGND VGND sky130_fd_pr__nfet_01v8 ad=0.12675 pd=1.04 as=0.247 ps=2.06 w=0.65 l=0.15
X191 a_11951_2146# digital_0._069_.A VDPWR VDPWR sky130_fd_pr__pfet_01v8_hvt ad=0.07438 pd=0.815 as=0.0567 ps=0.69 w=0.42 l=0.15
X192 VGND digital_0._067_.A digital_0._110_.D VGND sky130_fd_pr__nfet_01v8 ad=0.08775 pd=0.92 as=0.08775 ps=0.92 w=0.65 l=0.15
X193 VGND VDPWR VGND VGND sky130_fd_pr__nfet_01v8 ad=0.143 pd=1.62 as=0 ps=0 w=0.55 l=0.59
X194 a_22698_16564# a_22914_14644# VGND sky130_fd_pr__res_high_po w=0.36 l=7.36
X195 a_15413_1260# a_15238_1334# a_15592_1322# VGND sky130_fd_pr__nfet_01v8 ad=0.1092 pd=1.36 as=0.06405 ps=0.725 w=0.42 l=0.15
X196 a_17304_16564# a_17520_14644# VGND sky130_fd_pr__res_high_po w=0.36 l=7.36
X197 LELO_GR01_0.x8.x5.XA6.A LELO_GR01_0.x8.x5.XA5.A VGND VGND sky130_fd_pr__nfet_01v8 ad=0.468 pd=2.84 as=0.468 ps=2.84 w=0.9 l=0.16
X198 a_4581_2825# a_4386_2856# a_4891_2588# VGND sky130_fd_pr__special_nfet_01v8 ad=0.0594 pd=0.69 as=0.1401 ps=1.1 w=0.36 l=0.15
X199 digital_0.output4.A a_4005_n158# VGND VGND sky130_fd_pr__nfet_01v8 ad=0.08775 pd=0.92 as=0.169 ps=1.82 w=0.65 l=0.15
X200 VGND digital_0.load_slew17.X digital_0._112_.RESET_B VGND sky130_fd_pr__nfet_01v8 ad=0.169 pd=1.82 as=0.08775 ps=0.92 w=0.65 l=0.15
X201 a_10285_2910# digital_0._065_.A2_N a_10284_2588# VGND sky130_fd_pr__nfet_01v8 ad=0.1092 pd=1.36 as=0.06615 ps=0.735 w=0.42 l=0.15
X202 a_11372_412# digital_0._065_.A2_N a_11276_412# VGND sky130_fd_pr__nfet_01v8 ad=0.0798 pd=0.8 as=0.0693 ps=0.75 w=0.42 l=0.15
X203 a_14762_2018# digital_0.load_slew17.A VDPWR VDPWR sky130_fd_pr__pfet_01v8_hvt ad=0.1664 pd=1.8 as=0.149 ps=1.325 w=0.64 l=0.15
X204 a_12849_778# digital_0._112_.RESET_B VDPWR VDPWR sky130_fd_pr__pfet_01v8_hvt ad=0.1092 pd=1.36 as=0.07035 ps=0.755 w=0.42 l=0.15
X205 VDPWR a_11835_3828# digital_0.hold20.X VDPWR sky130_fd_pr__pfet_01v8_hvt ad=0.14075 pd=1.325 as=0.26 ps=2.52 w=1 l=0.15
X206 VDPWR digital_0._107_.D a_7720_n132# VDPWR sky130_fd_pr__pfet_01v8_hvt ad=0.1092 pd=1.36 as=0.0651 ps=0.73 w=0.42 l=0.15
X207 VGND a_11361_n702# a_11103_n702# VGND sky130_fd_pr__nfet_01v8 ad=0.0567 pd=0.69 as=0.1092 ps=1.36 w=0.42 l=0.5
X208 VDPWR a_11951_2146# digital_0._063_.A VDPWR sky130_fd_pr__pfet_01v8_hvt ad=0.26 pd=2.52 as=0.135 ps=1.27 w=1 l=0.15
X209 LELO_GR01_0.x7.x1.x5.x8.G LELO_GR01_0.x7.x1.x5.x9<2>.G VGND VGND sky130_fd_pr__nfet_01v8_lvt ad=0.3168 pd=1.62 as=0.5088 ps=2.98 w=0.96 l=0.94
X210 VGND digital_0.load_slew17.A digital_0._110_.RESET_B VGND sky130_fd_pr__nfet_01v8 ad=0.08775 pd=0.92 as=0.08775 ps=0.92 w=0.65 l=0.15
X211 VGND a_6687_n676# a_6793_n676# VGND sky130_fd_pr__nfet_01v8 ad=0.097 pd=0.975 as=0.1092 ps=1.36 w=0.42 l=0.5
X212 VDPWR LELO_GR01_0.x7.xd1<4>.A LELO_GR01_0.x7.x15.I2 VDPWR sky130_fd_pr__pfet_01v8_lvt ad=0.5088 pd=2.98 as=0.3168 ps=1.62 w=0.96 l=0.94
X213 VGND digital_0.load_slew17.X digital_0._106_.RESET_B VGND sky130_fd_pr__nfet_01v8 ad=0.169 pd=1.82 as=0.08775 ps=0.92 w=0.65 l=0.15
X214 a_4108_2840# a_4425_2730# a_4383_2588# VGND sky130_fd_pr__special_nfet_01v8 ad=0.0711 pd=0.755 as=0.0669 ps=0.75 w=0.36 l=0.15
X215 VDPWR a_11673_412# digital_0.clkload0.X VDPWR sky130_fd_pr__pfet_01v8_hvt ad=0.14 pd=1.28 as=0.14 ps=1.28 w=1 l=0.15
X216 digital_0.input2.X a_8689_n132# VDPWR VDPWR sky130_fd_pr__pfet_01v8_hvt ad=0.495 pd=2.99 as=0.2726 ps=1.61 w=1 l=0.15
X217 a_4586_6824# a_4802_4904# VGND sky130_fd_pr__res_high_po w=0.36 l=7.36
X218 a_12517_2044# digital_0._110_.Q VDPWR VDPWR sky130_fd_pr__pfet_01v8_hvt ad=0.28 pd=2.56 as=0.135 ps=1.27 w=1 l=0.15
X219 a_15537_n426# digital_0.load_slew17.X digital_0._112_.RESET_B VDPWR sky130_fd_pr__pfet_01v8_hvt ad=0.26 pd=2.52 as=0.135 ps=1.27 w=1 l=0.15
X220 VGND a_13481_386# a_13415_412# VGND sky130_fd_pr__nfet_01v8 ad=0.12495 pd=1.015 as=0.0669 ps=0.75 w=0.42 l=0.15
X221 a_11276_412# digital_0._057_.D VGND VGND sky130_fd_pr__nfet_01v8 ad=0.0693 pd=0.75 as=0.17515 ps=1.265 w=0.42 l=0.15
X222 VDPWR a_9463_654# a_9353_778# VDPWR sky130_fd_pr__pfet_01v8_hvt ad=0.07035 pd=0.755 as=0.1155 ps=0.97 w=0.42 l=0.15
X223 VDPWR a_11431_2382# digital_0._065_.A2_N VDPWR sky130_fd_pr__pfet_01v8_hvt ad=0.38 pd=2.76 as=0.195 ps=1.39 w=1 l=0.15
X224 LELO_GR01_0.x8.x1.x5.x9<2>.G LELO_GR01_0.x8.x1.x5.x8.G LELO_GR01_0.x8.x1.x5.x6.N LELO_GR01_0.x8.x1.x5.x6.N sky130_fd_pr__pfet_01v8_lvt ad=0.3168 pd=1.62 as=0.5088 ps=2.98 w=0.96 l=0.94
X225 VGND VGND LELO_GR01_0.x7.x28.e sky130_fd_pr__pnp_05v5_W3p40L3p40
**devattr s=462400,2720
X226 a_6397_n158# a_6684_0# VDPWR VDPWR sky130_fd_pr__pfet_01v8_hvt ad=0.0567 pd=0.69 as=0.1134 ps=1.38 w=0.42 l=0.15
X227 VDPWR a_9985_386# digital_0._114_.Q VDPWR sky130_fd_pr__pfet_01v8_hvt ad=0.26 pd=2.52 as=0.135 ps=1.27 w=1 l=0.15
X228 VDPWR digital_0.load_slew17.A digital_0._104_.RESET_B VDPWR sky130_fd_pr__pfet_01v8_hvt ad=0.26 pd=2.52 as=0.135 ps=1.27 w=1 l=0.15
X229 a_5159_1474# digital_0.hold28.A VGND VGND sky130_fd_pr__nfet_01v8 ad=0.1092 pd=1.36 as=0.1449 ps=1.11 w=0.42 l=0.15
X230 a_12646_1500# digital_0._113_.D VGND VGND sky130_fd_pr__nfet_01v8 ad=0.066 pd=0.745 as=0.2205 ps=1.89 w=0.42 l=0.15
X231 a_13110_3498# digital_0._110_.Q a_12889_3171# VGND sky130_fd_pr__nfet_01v8 ad=0.0693 pd=0.75 as=0.09975 ps=0.895 w=0.42 l=0.15
X232 VDPWR digital_0._116_.Q a_15537_n132# VDPWR sky130_fd_pr__pfet_01v8_hvt ad=0.135 pd=1.27 as=0.28 ps=2.56 w=1 l=0.15
X233 a_28070_13064# a_27854_11144# VGND sky130_fd_pr__res_high_po w=0.36 l=7.36
X234 digital_0._067_.B digital_0._110_.Q VGND VGND sky130_fd_pr__nfet_01v8 ad=0.08775 pd=0.92 as=0.08775 ps=0.92 w=0.65 l=0.15
X235 a_15040_234# digital_0._105_.RESET_B VGND VGND sky130_fd_pr__nfet_01v8 ad=0.06405 pd=0.725 as=0.12495 ps=1.015 w=0.42 l=0.15
X236 digital_0.clkbuf_1_1__f_clk.A a_8996_1500# VDPWR VDPWR sky130_fd_pr__pfet_01v8_hvt ad=0.14 pd=1.28 as=0.14 ps=1.28 w=1 l=0.15
X237 VGND VDPWR VGND VGND sky130_fd_pr__nfet_01v8 ad=0.143 pd=1.62 as=0 ps=0 w=0.55 l=0.59
X238 a_14624_386# a_14750_570# VGND VGND sky130_fd_pr__nfet_01v8 ad=0.17225 pd=1.83 as=0.1856 ps=1.26 w=0.65 l=0.25
X239 digital_0.clkload0.A a_11388_956# VGND VGND sky130_fd_pr__nfet_01v8 ad=0.0588 pd=0.7 as=0.0588 ps=0.7 w=0.42 l=0.15
X240 LELO_GR01_0.PWRUP_1V8 JNWTR_ORX1_CV_0.XA2.A VGND VGND sky130_fd_pr__nfet_01v8 ad=0.468 pd=2.84 as=0.468 ps=2.84 w=0.9 l=0.16
X241 VGND digital_0.clkload0.A a_14157_962# VGND sky130_fd_pr__nfet_01v8 ad=0.0567 pd=0.69 as=0.1092 ps=1.36 w=0.42 l=0.15
X242 VGND VDPWR VGND VGND sky130_fd_pr__nfet_01v8 ad=0.143 pd=1.62 as=0 ps=0 w=0.55 l=0.59
X243 a_3492_n702# a_3618_n518# VGND VGND sky130_fd_pr__nfet_01v8 ad=0.17225 pd=1.83 as=0.1856 ps=1.26 w=0.65 l=0.25
X244 digital_0._114_.RESET_B digital_0.load_slew15.A a_9005_956# VDPWR sky130_fd_pr__pfet_01v8_hvt ad=0.135 pd=1.27 as=0.135 ps=1.27 w=1 l=0.15
X245 a_9631_2050# a_9465_2050# VGND VGND sky130_fd_pr__nfet_01v8 ad=0.1092 pd=1.36 as=0.0567 ps=0.69 w=0.42 l=0.15
X246 a_11107_2562# digital_0._110_.Q a_11353_2616# VGND sky130_fd_pr__nfet_01v8 ad=0.1176 pd=1.4 as=0.0567 ps=0.69 w=0.42 l=0.15
X247 VGND VGND VGND VGND sky130_fd_pr__nfet_01v8 ad=0.468 pd=2.84 as=0 ps=0 w=0.9 l=0.16
X248 VDPWR digital_0.input1.X a_8729_412# VDPWR sky130_fd_pr__pfet_01v8_hvt ad=0.0864 pd=0.91 as=0.1664 ps=1.8 w=0.64 l=0.15
X249 VGND VDPWR VGND VGND sky130_fd_pr__nfet_01v8 ad=0.143 pd=1.62 as=0 ps=0 w=0.55 l=0.59
X250 VDPWR a_13481_1474# a_13468_1866# VDPWR sky130_fd_pr__pfet_01v8_hvt ad=0.0819 pd=0.81 as=0.0567 ps=0.69 w=0.42 l=0.15
X251 a_7055_2588# a_6889_2588# VDPWR VDPWR sky130_fd_pr__pfet_01v8_hvt ad=0.1664 pd=1.8 as=0.0864 ps=0.91 w=0.64 l=0.15
X252 a_6684_0# a_7001_110# a_6959_234# VGND sky130_fd_pr__special_nfet_01v8 ad=0.0711 pd=0.755 as=0.0669 ps=0.75 w=0.36 l=0.15
X253 a_14990_386# JNWTR_IVX1_CV_0.Y VDPWR VDPWR sky130_fd_pr__pfet_01v8_hvt ad=0.27 pd=2.54 as=0.19265 ps=1.415 w=1 l=0.15
X254 a_5003_234# digital_0._119_.RESET_B VGND VGND sky130_fd_pr__nfet_01v8 ad=0.0441 pd=0.63 as=0.1346 ps=1.15 w=0.42 l=0.15
X255 LELO_GR01_0.x7.xd1<4>.A LELO_GR01_0.x7.x18.D LELO_GR01_0.x7.x6<3>.G VGND sky130_fd_pr__nfet_01v8_lvt ad=0.3168 pd=1.62 as=0.5088 ps=2.98 w=0.96 l=0.94
X256 a_6906_3132# digital_0._108_.Q a_6235_3106# VDPWR sky130_fd_pr__pfet_01v8_hvt ad=0.135 pd=1.27 as=0.135 ps=1.27 w=1 l=0.15
X257 a_6687_n676# a_6451_n676# VGND VGND sky130_fd_pr__nfet_01v8 ad=0.1092 pd=1.36 as=0.0567 ps=0.69 w=0.42 l=0.5
X258 VGND a_8085_1500# digital_0.load_slew15.X VGND sky130_fd_pr__nfet_01v8 ad=0.169 pd=1.82 as=0.08775 ps=0.92 w=0.65 l=0.15
X259 LELO_GR01_0.x7.xd1<4>.A LELO_GR01_0.PWRUP_1V8 VDPWR VDPWR sky130_fd_pr__pfet_01v8_lvt ad=0.3168 pd=1.62 as=0.5088 ps=2.98 w=0.96 l=0.94
X260 a_5018_6824# a_4802_4904# VGND sky130_fd_pr__res_high_po w=0.36 l=7.36
X261 VGND digital_0.clkload0.A a_11673_412# VGND sky130_fd_pr__nfet_01v8 ad=0.07035 pd=0.755 as=0.1113 ps=1.37 w=0.42 l=0.15
X262 LELO_GR01_0.x7.x10.P a_23778_14644# VGND sky130_fd_pr__res_high_po w=0.36 l=7.36
X263 LELO_GR01_0.x7.x1.x5.x9<2>.G LELO_GR01_0.x8.PWRUP_N_1V8 VGND VGND sky130_fd_pr__nfet_01v8_lvt ad=0.3168 pd=1.62 as=0.5088 ps=2.98 w=0.96 l=0.94
X264 a_14871_n524# a_14967_n702# VDPWR VDPWR sky130_fd_pr__pfet_01v8_hvt ad=0.1092 pd=1.36 as=0.14075 ps=1.325 w=0.42 l=0.5
X265 a_4610_386# a_4530_626# a_5014_412# VGND sky130_fd_pr__special_nfet_01v8 ad=0.072 pd=0.76 as=0.06705 ps=0.75 w=0.36 l=0.15
X266 VDPWR a_11107_2562# digital_0._067_.A VDPWR sky130_fd_pr__pfet_01v8_hvt ad=0.16655 pd=1.39 as=0.195 ps=1.39 w=1 l=0.15
X267 a_6179_3132# digital_0.output13.A VDPWR VDPWR sky130_fd_pr__pfet_01v8_hvt ad=0.26 pd=2.52 as=0.135 ps=1.27 w=1 l=0.15
X268 a_3492_3650# a_3618_3834# VDPWR VDPWR sky130_fd_pr__pfet_01v8_hvt ad=0.2173 pd=2.17 as=0.2726 ps=1.61 w=0.82 l=0.25
X269 a_7667_2588# a_7623_2830# a_7501_2588# VGND sky130_fd_pr__nfet_01v8 ad=0.0441 pd=0.63 as=0.1401 ps=1.1 w=0.42 l=0.15
X270 VDPWR digital_0.clkbuf_1_1__f_clk.A a_11388_956# VDPWR sky130_fd_pr__pfet_01v8_hvt ad=0.14 pd=1.28 as=0.14 ps=1.28 w=1 l=0.15
X271 a_7580_11154# a_7796_9234# VGND sky130_fd_pr__res_high_po w=0.36 l=7.36
X272 VGND digital_0.output9.A a_15445_2044# VGND sky130_fd_pr__nfet_01v8 ad=0.1228 pd=1.065 as=0.1134 ps=1.38 w=0.42 l=0.15
X273 a_3982_386# digital_0._116_.SET_B VDPWR VDPWR sky130_fd_pr__pfet_01v8_hvt ad=0.1092 pd=1.36 as=0.12075 ps=1.165 w=0.42 l=0.15
X274 VGND a_14727_1474# a_14661_1500# VGND sky130_fd_pr__nfet_01v8 ad=0.1449 pd=1.11 as=0.0693 ps=0.75 w=0.42 l=0.15
X275 a_15685_386# digital_0.output9.A VGND VGND sky130_fd_pr__nfet_01v8 ad=0.1092 pd=1.36 as=0.0567 ps=0.69 w=0.42 l=0.15
X276 VGND a_10721_172# digital_0.output11.A VGND sky130_fd_pr__nfet_01v8 ad=0.169 pd=1.82 as=0.08775 ps=0.92 w=0.65 l=0.15
X277 digital_0.hold26.X a_6793_n676# VGND VGND sky130_fd_pr__nfet_01v8 ad=0.169 pd=1.82 as=0.097 ps=0.975 w=0.65 l=0.15
X278 VDPWR a_5139_930# a_5029_956# VDPWR sky130_fd_pr__pfet_01v8_hvt ad=0.07035 pd=0.755 as=0.1155 ps=0.97 w=0.42 l=0.15
X279 LELO_GR01_0.x8.IBP_BG LELO_GR01_0.x8.PWRUP_N_1V8 VGND VGND sky130_fd_pr__nfet_01v8_lvt ad=0.3168 pd=1.62 as=0.5088 ps=2.98 w=0.96 l=0.94
X280 a_21834_16564# a_22050_14644# VGND sky130_fd_pr__res_high_po w=0.36 l=7.36
X281 VGND digital_0.load_slew15.A digital_0._108_.RESET_B VGND sky130_fd_pr__nfet_01v8 ad=0.08775 pd=0.92 as=0.08775 ps=0.92 w=0.65 l=0.15
X282 VGND digital_0.output13.A a_6455_3452# VGND sky130_fd_pr__nfet_01v8 ad=0.08775 pd=0.92 as=0.08775 ps=0.92 w=0.65 l=0.15
X283 VDPWR a_8996_1500# digital_0.clkbuf_1_1__f_clk.A VDPWR sky130_fd_pr__pfet_01v8_hvt ad=0.14 pd=1.28 as=0.14 ps=1.28 w=1 l=0.15
X284 uo_out<0> LELO_GR01_0.x8.x5.XA7.C LELO_GR01_0.x8.x5.XA7.MP1.S VGND sky130_fd_pr__nfet_01v8 ad=0.468 pd=2.84 as=0.288 ps=1.54 w=0.9 l=0.16
X285 LELO_GR01_0.x8.x1.x5.x8.S LELO_GR01_0.x8.x1.x5.x8.G LELO_GR01_0.x8.x1.x5.x8.G LELO_GR01_0.x8.x1.x5.x8.S sky130_fd_pr__pfet_01v8_lvt ad=0.5088 pd=2.98 as=0.3168 ps=1.62 w=0.96 l=0.94
X286 LELO_GR01_0.x8.IBP_BG VGND sky130_fd_pr__cap_mim_m3_1 l=5 w=5
X287 a_6209_386# digital_0.output6.A VDPWR VDPWR sky130_fd_pr__pfet_01v8_hvt ad=0.1092 pd=1.36 as=0.0567 ps=0.69 w=0.42 l=0.15
X288 a_7593_2348# digital_0._108_.RESET_B VDPWR VDPWR sky130_fd_pr__pfet_01v8_hvt ad=0.0567 pd=0.69 as=0.0819 ps=0.81 w=0.42 l=0.15
X289 a_6503_2050# a_6337_2050# VDPWR VDPWR sky130_fd_pr__pfet_01v8_hvt ad=0.1664 pd=1.8 as=0.0864 ps=0.91 w=0.64 l=0.15
X290 digital_0._065_.A2_N a_11431_2382# VDPWR VDPWR sky130_fd_pr__pfet_01v8_hvt ad=0.195 pd=1.39 as=0.16655 ps=1.39 w=1 l=0.15
X291 VGND digital_0.input1.X a_11673_2588# VGND sky130_fd_pr__nfet_01v8 ad=0.0567 pd=0.69 as=0.1092 ps=1.36 w=0.42 l=0.15
X292 VDPWR VGND VDPWR VDPWR sky130_fd_pr__pfet_01v8_hvt ad=0.2262 pd=2.26 as=0 ps=0 w=0.87 l=0.59
X293 a_4921_1334# a_4571_962# a_4826_1322# VDPWR sky130_fd_pr__pfet_01v8_hvt ad=0.07245 pd=0.765 as=0.0651 ps=0.73 w=0.42 l=0.15
X294 a_11517_2382# digital_0._111_.Q a_11431_2382# VGND sky130_fd_pr__nfet_01v8 ad=0.0567 pd=0.69 as=0.1176 ps=1.4 w=0.42 l=0.15
X295 a_10571_2588# a_10285_2910# a_10074_2562# VGND sky130_fd_pr__nfet_01v8 ad=0.0567 pd=0.69 as=0.1092 ps=1.36 w=0.42 l=0.15
X296 digital_0.hold26.X a_6793_n676# VDPWR VDPWR sky130_fd_pr__pfet_01v8_hvt ad=0.26 pd=2.52 as=0.14075 ps=1.325 w=1 l=0.15
X297 a_9564_930# a_9690_1194# VGND VGND sky130_fd_pr__nfet_01v8 ad=0.17225 pd=1.83 as=0.1856 ps=1.26 w=0.65 l=0.25
X298 VGND digital_0._103_.RESET_B a_10795_3498# VGND sky130_fd_pr__nfet_01v8 ad=0.1346 pd=1.15 as=0.0441 ps=0.63 w=0.42 l=0.15
X299 LELO_GR01_0.x8.x1.x5.x9<2>.G LELO_GR01_0.x8.PWRUP_N_1V8 VGND VGND sky130_fd_pr__nfet_01v8_lvt ad=0.3168 pd=1.62 as=0.5088 ps=2.98 w=0.96 l=0.94
X300 LELO_GR01_0.x7.x6<3>.G LELO_GR01_0.x7.x6<3>.G LELO_GR01_0.x7.x7.S VGND sky130_fd_pr__nfet_01v8_lvt ad=0.3168 pd=1.62 as=0.5088 ps=2.98 w=0.96 l=0.94
X301 a_8552_18000# a_10472_17784# VGND sky130_fd_pr__res_high_po w=0.36 l=7.36
X302 VDPWR a_3858_n702# a_3618_n518# VDPWR sky130_fd_pr__pfet_01v8_hvt ad=0.19265 pd=1.415 as=0.2173 ps=2.17 w=0.82 l=0.25
X303 LELO_GR01_0.x7.x1.x5.x8.S LELO_GR01_0.x7.x1.x5.x8.G LELO_GR01_0.x7.x1.x5.x8.G LELO_GR01_0.x7.x1.x5.x8.S sky130_fd_pr__pfet_01v8_lvt ad=0.5088 pd=2.98 as=0.3168 ps=1.62 w=0.96 l=0.94
X304 VGND a_5215_3676# a_5321_3676# VGND sky130_fd_pr__nfet_01v8 ad=0.097 pd=0.975 as=0.1092 ps=1.36 w=0.42 l=0.5
X305 a_13415_412# a_12225_412# a_13306_412# VGND sky130_fd_pr__special_nfet_01v8 ad=0.0669 pd=0.75 as=0.0711 ps=0.755 w=0.36 l=0.15
X306 VGND LELO_GR01_0.x8.PWRUP_N_1V8 LELO_GR01_0.x8.x7.D VGND sky130_fd_pr__nfet_01v8_lvt ad=0.5088 pd=2.98 as=0.3168 ps=1.62 w=0.96 l=0.94
X307 a_4819_2588# digital_0._100_.RESET_B VGND VGND sky130_fd_pr__nfet_01v8 ad=0.0441 pd=0.63 as=0.1346 ps=1.15 w=0.42 l=0.15
X308 a_8996_1500# clk VDPWR VDPWR sky130_fd_pr__pfet_01v8_hvt ad=0.14 pd=1.28 as=0.265 ps=2.53 w=1 l=0.15
X309 VGND digital_0._116_.Q digital_0._111_.RESET_B VGND sky130_fd_pr__nfet_01v8 ad=0.08775 pd=0.92 as=0.08775 ps=0.92 w=0.65 l=0.15
X310 LELO_GR01_0.x7.x26.P a_26350_11144# VGND sky130_fd_pr__res_high_po w=0.36 l=7.36
X311 VGND a_15225_n702# a_14967_n702# VGND sky130_fd_pr__nfet_01v8 ad=0.0567 pd=0.69 as=0.1092 ps=1.36 w=0.42 l=0.5
X312 VGND a_15662_2044# a_15773_2044# VGND sky130_fd_pr__nfet_01v8 ad=0.1856 pd=1.26 as=0.17225 ps=1.83 w=0.65 l=0.25
X313 a_26806_16564# a_27022_14644# VGND sky130_fd_pr__res_high_po w=0.36 l=7.36
X314 a_10839_1276# digital_0._112_.Q a_10723_1276# VGND sky130_fd_pr__nfet_01v8 ad=0.08775 pd=0.92 as=0.13975 ps=1.08 w=0.65 l=0.15
X315 VGND a_13481_1474# digital_0._113_.Q VGND sky130_fd_pr__nfet_01v8 ad=0.169 pd=1.82 as=0.08775 ps=0.92 w=0.65 l=0.15
X316 digital_0._060_.A_N a_10997_386# VGND VGND sky130_fd_pr__nfet_01v8 ad=0.10725 pd=0.98 as=0.195 ps=1.9 w=0.65 l=0.15
X317 VDPWR a_11388_956# digital_0.clkload0.A VDPWR sky130_fd_pr__pfet_01v8_hvt ad=0.14 pd=1.28 as=0.14 ps=1.28 w=1 l=0.15
X318 LELO_GR01_0.x7.x3.P a_7796_9234# VGND sky130_fd_pr__res_high_po w=0.36 l=7.36
X319 digital_0._067_.A a_11107_2562# VDPWR VDPWR sky130_fd_pr__pfet_01v8_hvt ad=0.195 pd=1.39 as=0.38 ps=2.76 w=1 l=0.15
X320 a_5215_3676# a_4979_3676# VDPWR VDPWR sky130_fd_pr__pfet_01v8_hvt ad=0.1092 pd=1.36 as=0.0567 ps=0.69 w=0.42 l=0.5
X321 VGND a_10721_172# a_10655_246# VGND sky130_fd_pr__nfet_01v8 ad=0.12495 pd=1.015 as=0.0669 ps=0.75 w=0.42 l=0.15
X322 a_11655_1500# digital_0._069_.A digital_0._063_.B VGND sky130_fd_pr__nfet_01v8 ad=0.06825 pd=0.86 as=0.091 ps=0.93 w=0.65 l=0.15
X323 VDPWR LELO_GR01_0.PWRUP_1V8 LELO_GR01_0.x7.x1.x7.D VDPWR sky130_fd_pr__pfet_01v8_lvt ad=0.5088 pd=2.98 as=0.3168 ps=1.62 w=0.96 l=0.94
X324 a_11007_n524# a_11103_n702# VDPWR VDPWR sky130_fd_pr__pfet_01v8_hvt ad=0.1092 pd=1.36 as=0.14075 ps=1.325 w=0.42 l=0.5
X325 VDPWR a_7961_386# digital_0._115_.Q VDPWR sky130_fd_pr__pfet_01v8_hvt ad=0.26 pd=2.52 as=0.135 ps=1.27 w=1 l=0.15
X326 a_7088_n132# a_7001_110# a_6684_0# VDPWR sky130_fd_pr__pfet_01v8_hvt ad=0.12915 pd=1.185 as=0.0588 ps=0.7 w=0.42 l=0.15
X327 VDPWR a_9930_930# a_9690_1194# VDPWR sky130_fd_pr__pfet_01v8_hvt ad=0.19265 pd=1.415 as=0.2173 ps=2.17 w=0.82 l=0.25
X328 a_12391_412# a_12225_412# VGND VGND sky130_fd_pr__nfet_01v8 ad=0.1092 pd=1.36 as=0.0567 ps=0.69 w=0.42 l=0.15
X329 VDPWR digital_0._065_.A2_N a_10555_956# VDPWR sky130_fd_pr__pfet_01v8_hvt ad=0.135 pd=1.27 as=0.135 ps=1.27 w=1 l=0.15
X330 digital_0._111_.D a_10074_2562# VDPWR VDPWR sky130_fd_pr__pfet_01v8_hvt ad=0.135 pd=1.27 as=0.285 ps=2.57 w=1 l=0.15
X331 a_7513_2954# digital_0._109_.RESET_B VDPWR VDPWR sky130_fd_pr__pfet_01v8_hvt ad=0.1092 pd=1.36 as=0.07035 ps=0.755 w=0.42 l=0.15
X332 uo_out<0> LELO_GR01_0.x8.x5.XA7.CN LELO_GR01_0.x8.x5.XA6.MN1.S VGND sky130_fd_pr__nfet_01v8 ad=0.468 pd=2.84 as=0.288 ps=1.54 w=0.9 l=0.16
X333 a_5139_930# a_4921_1334# VDPWR VDPWR sky130_fd_pr__pfet_01v8_hvt ad=0.12915 pd=1.185 as=0.2184 ps=2.2 w=0.84 l=0.15
X334 VGND digital_0._116_.Q digital_0._115_.RESET_B VGND sky130_fd_pr__nfet_01v8 ad=0.08775 pd=0.92 as=0.08775 ps=0.92 w=0.65 l=0.15
X335 VGND digital_0._116_.Q digital_0._113_.RESET_B VGND sky130_fd_pr__nfet_01v8 ad=0.08775 pd=0.92 as=0.08775 ps=0.92 w=0.65 l=0.15
X336 VGND digital_0.load_slew15.X digital_0._101_.RESET_B VGND sky130_fd_pr__nfet_01v8 ad=0.169 pd=1.82 as=0.08775 ps=0.92 w=0.65 l=0.15
X337 a_5288_2410# digital_0._101_.RESET_B VGND VGND sky130_fd_pr__nfet_01v8 ad=0.06405 pd=0.725 as=0.12495 ps=1.015 w=0.42 l=0.15
X338 VDPWR a_7593_2348# a_7580_2044# VDPWR sky130_fd_pr__pfet_01v8_hvt ad=0.0819 pd=0.81 as=0.0567 ps=0.69 w=0.42 l=0.15
X339 VDPWR a_4228_3650# uo_out<1> VDPWR sky130_fd_pr__pfet_01v8_hvt ad=0.2726 pd=1.61 as=0.495 ps=2.99 w=1 l=0.15
X340 VDPWR a_4610_386# a_4668_778# VDPWR sky130_fd_pr__pfet_01v8_hvt ad=0.0567 pd=0.69 as=0.0441 ps=0.63 w=0.42 l=0.15
X341 a_8145_2562# digital_0._109_.RESET_B VDPWR VDPWR sky130_fd_pr__pfet_01v8_hvt ad=0.0567 pd=0.69 as=0.0819 ps=0.81 w=0.42 l=0.15
R1 uio_oe<0> JNWTR_TIEL_CV_0.Y sky130_fd_pr__res_generic_m4 w=0.3 l=0.3
X342 uio_out<4> a_15773_2044# VGND VGND sky130_fd_pr__nfet_01v8 ad=0.2079 pd=1.83 as=0.1856 ps=1.26 w=0.42 l=0.15
X343 a_14756_3132# a_13679_3138# a_14594_3510# VDPWR sky130_fd_pr__pfet_01v8_hvt ad=0.0567 pd=0.69 as=0.0588 ps=0.7 w=0.42 l=0.15
X344 VGND digital_0._116_.Q digital_0._112_.RESET_B VGND sky130_fd_pr__nfet_01v8 ad=0.08775 pd=0.92 as=0.08775 ps=0.92 w=0.65 l=0.15
X345 VGND a_3821_2562# digital_0.output5.A VGND sky130_fd_pr__nfet_01v8 ad=0.2087 pd=2.02 as=0.08775 ps=0.92 w=0.65 l=0.15
X346 LELO_GR01_0.x7.x7.S LELO_GR01_0.x7.x6<3>.G LELO_GR01_0.x7.x6<3>.G VGND sky130_fd_pr__nfet_01v8_lvt ad=0.5088 pd=2.98 as=0.3168 ps=1.62 w=0.96 l=0.94
X347 a_20372_9699# a_22292_9483# VGND sky130_fd_pr__res_high_po w=0.36 l=7.36
X348 VDPWR a_6397_n158# digital_0.output12.A VDPWR sky130_fd_pr__pfet_01v8_hvt ad=0.3012 pd=2.66 as=0.135 ps=1.27 w=1 l=0.15
X349 VDPWR a_7157_n158# a_7088_n132# VDPWR sky130_fd_pr__pfet_01v8_hvt ad=0.2184 pd=2.2 as=0.12915 ps=1.185 w=0.84 l=0.15
X350 VGND LELO_GR01_0.x7.x1.x5.x9<2>.G LELO_GR01_0.x7.x1.x5.x9<2>.G VGND sky130_fd_pr__nfet_01v8_lvt ad=0.5088 pd=2.98 as=0.3168 ps=1.62 w=0.96 l=0.94
X351 digital_0._102_.RESET_B digital_0.load_slew17.A VGND VGND sky130_fd_pr__nfet_01v8 ad=0.08775 pd=0.92 as=0.169 ps=1.82 w=0.65 l=0.15
X352 a_12741_1500# a_12225_1500# a_12646_1500# VGND sky130_fd_pr__special_nfet_01v8 ad=0.0594 pd=0.69 as=0.066 ps=0.745 w=0.36 l=0.15
X353 a_13679_3138# a_13513_3138# VDPWR VDPWR sky130_fd_pr__pfet_01v8_hvt ad=0.1664 pd=1.8 as=0.0864 ps=0.91 w=0.64 l=0.15
X354 VGND a_7155_930# digital_0._115_.D VGND sky130_fd_pr__nfet_01v8 ad=0.169 pd=1.82 as=0.08775 ps=0.92 w=0.65 l=0.15
X355 digital_0._106_.RESET_B digital_0.load_slew17.X VGND VGND sky130_fd_pr__nfet_01v8 ad=0.08775 pd=0.92 as=0.169 ps=1.82 w=0.65 l=0.15
X356 VDPWR a_12754_2588# a_12929_2562# VDPWR sky130_fd_pr__pfet_01v8_hvt ad=0.1134 pd=1.38 as=0.0567 ps=0.69 w=0.42 l=0.15
X357 VDPWR a_14861_172# a_14848_n132# VDPWR sky130_fd_pr__pfet_01v8_hvt ad=0.0819 pd=0.81 as=0.0567 ps=0.69 w=0.42 l=0.15
X358 VGND VDPWR VGND VGND sky130_fd_pr__nfet_01v8 ad=0.143 pd=1.62 as=0 ps=0 w=0.55 l=0.59
X359 a_14319_3828# a_14415_3650# VGND VGND sky130_fd_pr__nfet_01v8 ad=0.1092 pd=1.36 as=0.097 ps=0.975 w=0.42 l=0.5
X360 a_10641_3132# digital_0._103_.RESET_B VDPWR VDPWR sky130_fd_pr__pfet_01v8_hvt ad=0.1092 pd=1.36 as=0.07035 ps=0.755 w=0.42 l=0.15
X361 VGND digital_0._113_.Q a_11758_188# VGND sky130_fd_pr__nfet_01v8 ad=0.08775 pd=0.92 as=0.08775 ps=0.92 w=0.65 l=0.15
X362 VDPWR a_12959_654# a_12849_778# VDPWR sky130_fd_pr__pfet_01v8_hvt ad=0.07035 pd=0.755 as=0.1155 ps=0.97 w=0.42 l=0.15
X363 a_12517_2044# digital_0._069_.A digital_0._067_.B VDPWR sky130_fd_pr__pfet_01v8_hvt ad=0.135 pd=1.27 as=0.135 ps=1.27 w=1 l=0.15
X364 digital_0._114_.Q a_9985_386# VDPWR VDPWR sky130_fd_pr__pfet_01v8_hvt ad=0.135 pd=1.27 as=0.3012 ps=2.66 w=1 l=0.15
X365 a_15537_n426# digital_0._116_.Q VDPWR VDPWR sky130_fd_pr__pfet_01v8_hvt ad=0.135 pd=1.27 as=0.135 ps=1.27 w=1 l=0.15
X366 a_12959_1742# a_12741_1500# VGND VGND sky130_fd_pr__nfet_01v8 ad=0.0999 pd=0.985 as=0.1346 ps=1.15 w=0.64 l=0.15
X367 a_13746_n524# digital_0.hold27.X a_13888_n349# VDPWR sky130_fd_pr__pfet_01v8_hvt ad=0.1932 pd=1.34 as=0.07665 ps=0.785 w=0.42 l=0.15
X368 a_14781_956# a_14157_962# a_14673_1334# VDPWR sky130_fd_pr__pfet_01v8_hvt ad=0.1155 pd=0.97 as=0.07245 ps=0.765 w=0.42 l=0.15
X369 LELO_GR01_0.x7.x20.D LELO_GR01_0.x8.PWRUP_N_1V8 LELO_GR01_0.x7.x19.D VDPWR sky130_fd_pr__pfet_01v8_lvt ad=0.5088 pd=2.98 as=0.3168 ps=1.62 w=0.96 l=0.94
X370 VGND digital_0.load_slew15.X digital_0._100_.RESET_B VGND sky130_fd_pr__nfet_01v8 ad=0.169 pd=1.82 as=0.08775 ps=0.92 w=0.65 l=0.15
X371 a_9151_n702# a_9417_n702# a_9363_n676# VGND sky130_fd_pr__nfet_01v8 ad=0.1092 pd=1.36 as=0.0567 ps=0.69 w=0.42 l=0.15
X372 a_13612_3650# a_13738_3834# VDPWR VDPWR sky130_fd_pr__pfet_01v8_hvt ad=0.2173 pd=2.17 as=0.2726 ps=1.61 w=0.82 l=0.25
X373 VGND a_5159_1474# a_5093_1500# VGND sky130_fd_pr__nfet_01v8 ad=0.1449 pd=1.11 as=0.0693 ps=0.75 w=0.42 l=0.15
X374 LELO_GR01_0.x7.x7.S LELO_GR01_0.x7.x6<3>.G LELO_GR01_0.x7.x6<3>.G VGND sky130_fd_pr__nfet_01v8_lvt ad=0.5088 pd=2.98 as=0.3168 ps=1.62 w=0.96 l=0.94
X375 LELO_GR01_0.x7.x29.N a_20744_11144# VGND sky130_fd_pr__res_high_po w=0.36 l=7.36
X376 VDPWR VGND VDPWR VDPWR sky130_fd_pr__pfet_01v8_hvt ad=0.2262 pd=2.26 as=0 ps=0 w=0.87 l=0.59
X377 a_21402_16564# a_21618_14644# VGND sky130_fd_pr__res_high_po w=0.36 l=7.36
X378 a_4696_n132# a_4609_110# a_4292_0# VDPWR sky130_fd_pr__pfet_01v8_hvt ad=0.12915 pd=1.185 as=0.0588 ps=0.7 w=0.42 l=0.15
X379 a_4730_1652# digital_0._109_.Q a_4872_1500# VGND sky130_fd_pr__nfet_01v8 ad=0.09975 pd=0.895 as=0.0693 ps=0.75 w=0.42 l=0.15
X380 VGND digital_0.hold28.A a_12635_3171# VGND sky130_fd_pr__nfet_01v8 ad=0.1449 pd=1.11 as=0.1092 ps=1.36 w=0.42 l=0.15
R2 uio_oe<5> JNWTR_TIEL_CV_0.Y sky130_fd_pr__res_generic_m4 w=0.3 l=0.3
X381 digital_0._067_.B digital_0._069_.A VGND VGND sky130_fd_pr__nfet_01v8 ad=0.08775 pd=0.92 as=0.169 ps=1.82 w=0.65 l=0.15
X382 a_12094_2588# digital_0._110_.D VDPWR VDPWR sky130_fd_pr__pfet_01v8_hvt ad=0.0651 pd=0.73 as=0.1092 ps=1.36 w=0.42 l=0.15
X383 VGND VDPWR VGND VGND sky130_fd_pr__nfet_01v8 ad=0.143 pd=1.62 as=0 ps=0 w=0.55 l=0.59
X384 VGND LELO_GR01_0.x7.x1.x5.x9<2>.G LELO_GR01_0.x7.x1.x5.IBN VGND sky130_fd_pr__nfet_01v8_lvt ad=0.5088 pd=2.98 as=0.3168 ps=1.62 w=0.96 l=0.94
X385 VGND a_6235_3106# digital_0._108_.D VGND sky130_fd_pr__nfet_01v8 ad=0.169 pd=1.82 as=0.08775 ps=0.92 w=0.65 l=0.15
X386 a_10555_956# digital_0._113_.Q VDPWR VDPWR sky130_fd_pr__pfet_01v8_hvt ad=0.26 pd=2.52 as=0.135 ps=1.27 w=1 l=0.15
X387 LELO_GR01_0.x7.x10.P a_16224_14644# VGND sky130_fd_pr__res_high_po w=0.36 l=7.36
X388 a_9005_956# digital_0._116_.Q VDPWR VDPWR sky130_fd_pr__pfet_01v8_hvt ad=0.135 pd=1.27 as=0.135 ps=1.27 w=1 l=0.15
X389 a_6235_3106# digital_0._108_.Q a_6906_3132# VDPWR sky130_fd_pr__pfet_01v8_hvt ad=0.135 pd=1.27 as=0.26 ps=2.52 w=1 l=0.15
X390 a_7221_412# a_6871_412# a_7126_412# VDPWR sky130_fd_pr__pfet_01v8_hvt ad=0.07245 pd=0.765 as=0.0651 ps=0.73 w=0.42 l=0.15
X391 VDPWR VGND VDPWR VDPWR sky130_fd_pr__pfet_01v8_hvt ad=0.2262 pd=2.26 as=0 ps=0 w=0.87 l=0.59
X392 a_6853_2422# a_6337_2050# a_6758_2410# VGND sky130_fd_pr__special_nfet_01v8 ad=0.0594 pd=0.69 as=0.066 ps=0.745 w=0.36 l=0.15
X393 VGND a_11388_956# digital_0.clkload0.A VGND sky130_fd_pr__nfet_01v8 ad=0.0588 pd=0.7 as=0.0588 ps=0.7 w=0.42 l=0.15
X394 digital_0.clkbuf_1_1__f_clk.A a_8996_1500# VGND VGND sky130_fd_pr__nfet_01v8 ad=0.0588 pd=0.7 as=0.05775 ps=0.695 w=0.42 l=0.15
X395 a_11273_3436# digital_0._103_.RESET_B VDPWR VDPWR sky130_fd_pr__pfet_01v8_hvt ad=0.0567 pd=0.69 as=0.0819 ps=0.81 w=0.42 l=0.15
X396 a_14339_n158# a_14121_246# VGND VGND sky130_fd_pr__nfet_01v8 ad=0.0999 pd=0.985 as=0.1346 ps=1.15 w=0.64 l=0.15
X397 a_4342_2954# a_3821_2562# VDPWR VDPWR sky130_fd_pr__pfet_01v8_hvt ad=0.0567 pd=0.69 as=0.0819 ps=0.81 w=0.42 l=0.15
X398 VDPWR a_4015_1652# digital_0.hold19.X VDPWR sky130_fd_pr__pfet_01v8_hvt ad=0.14075 pd=1.325 as=0.26 ps=2.52 w=1 l=0.15
X399 digital_0.clkbuf_1_0__f_clk.X a_6315_1474# VDPWR VDPWR sky130_fd_pr__pfet_01v8_hvt ad=0.14 pd=1.28 as=0.14 ps=1.28 w=1 l=0.15
X400 VDPWR a_7071_2018# a_6961_2044# VDPWR sky130_fd_pr__pfet_01v8_hvt ad=0.07035 pd=0.755 as=0.1155 ps=0.97 w=0.42 l=0.15
X401 VDPWR digital_0._063_.A a_13513_956# VDPWR sky130_fd_pr__pfet_01v8_hvt ad=0.135 pd=1.27 as=0.28 ps=2.56 w=1 l=0.15
X402 VGND digital_0._110_.RESET_B a_12451_2588# VGND sky130_fd_pr__nfet_01v8 ad=0.1346 pd=1.15 as=0.0441 ps=0.63 w=0.42 l=0.15
X403 a_12929_2562# a_12754_2588# a_13108_2588# VGND sky130_fd_pr__nfet_01v8 ad=0.1092 pd=1.36 as=0.06405 ps=0.725 w=0.42 l=0.15
X404 a_11839_2588# a_11673_2588# VDPWR VDPWR sky130_fd_pr__pfet_01v8_hvt ad=0.1664 pd=1.8 as=0.0864 ps=0.91 w=0.64 l=0.15
X405 a_22902_13064# a_23118_11144# VGND sky130_fd_pr__res_high_po w=0.36 l=7.36
X406 a_7405_2588# a_6889_2588# a_7310_2588# VGND sky130_fd_pr__special_nfet_01v8 ad=0.0594 pd=0.69 as=0.066 ps=0.745 w=0.36 l=0.15
X407 a_12407_2830# a_12189_2588# VDPWR VDPWR sky130_fd_pr__pfet_01v8_hvt ad=0.12915 pd=1.185 as=0.2184 ps=2.2 w=0.84 l=0.15
X408 VDPWR VGND VDPWR VDPWR sky130_fd_pr__pfet_01v8_hvt ad=0.2262 pd=2.26 as=0 ps=0 w=0.87 l=0.59
X409 a_4324_412# digital_0._116_.SET_B VGND VGND sky130_fd_pr__nfet_01v8 ad=0.0441 pd=0.63 as=0.1137 ps=1.01 w=0.42 l=0.15
X410 VDPWR a_8145_2562# a_8132_2954# VDPWR sky130_fd_pr__pfet_01v8_hvt ad=0.0819 pd=0.81 as=0.0567 ps=0.69 w=0.42 l=0.15
X411 a_11397_1750# digital_0._065_.A2_N VDPWR VDPWR sky130_fd_pr__pfet_01v8_hvt ad=0.135 pd=1.27 as=0.135 ps=1.27 w=1 l=0.15
X412 VDPWR a_4765_n158# a_4696_n132# VDPWR sky130_fd_pr__pfet_01v8_hvt ad=0.2184 pd=2.2 as=0.12915 ps=1.185 w=0.84 l=0.15
X413 VGND digital_0._116_.SET_B a_4828_412# VGND sky130_fd_pr__nfet_01v8 ad=0.0882 pd=0.84 as=0.0441 ps=0.63 w=0.42 l=0.15
X414 VDPWR a_8578_n132# a_8689_n132# VDPWR sky130_fd_pr__pfet_01v8_hvt ad=0.2726 pd=1.61 as=0.2173 ps=2.17 w=0.82 l=0.25
X415 a_10721_172# digital_0._106_.RESET_B VDPWR VDPWR sky130_fd_pr__pfet_01v8_hvt ad=0.0567 pd=0.69 as=0.0819 ps=0.81 w=0.42 l=0.15
X416 VDPWR VGND VDPWR VDPWR sky130_fd_pr__pfet_01v8_hvt ad=0.2262 pd=2.26 as=0 ps=0 w=0.87 l=0.59
X417 VGND VDPWR VGND VGND sky130_fd_pr__nfet_01v8 ad=0.143 pd=1.62 as=0 ps=0 w=0.55 l=0.59
R3 uio_oe<1> JNWTR_TIEL_CV_0.Y sky130_fd_pr__res_generic_m4 w=0.3 l=0.3
X418 a_15238_1334# a_14157_962# a_14891_930# VDPWR sky130_fd_pr__pfet_01v8_hvt ad=0.0588 pd=0.7 as=0.12915 ps=1.185 w=0.42 l=0.15
X419 a_5974_n676# digital_0._116_.Q a_5868_n676# VGND sky130_fd_pr__nfet_01v8 ad=0.1625 pd=1.15 as=0.1235 ps=1.03 w=0.65 l=0.15
X420 LELO_GR01_0.x7.x24.D LELO_GR01_0.x8.PWRUP_N_1V8 LELO_GR01_0.x7.x23.D VDPWR sky130_fd_pr__pfet_01v8_lvt ad=0.5088 pd=2.98 as=0.3168 ps=1.62 w=0.96 l=0.94
X421 a_7181_3926# digital_0._069_.B digital_0._109_.D VDPWR sky130_fd_pr__pfet_01v8_hvt ad=0.135 pd=1.27 as=0.135 ps=1.27 w=1 l=0.15
X422 a_14109_n676# digital_0.hold27.X a_13746_n524# VGND sky130_fd_pr__nfet_01v8 ad=0.0693 pd=0.75 as=0.09975 ps=0.895 w=0.42 l=0.15
X423 VDPWR a_4581_2825# a_4512_2954# VDPWR sky130_fd_pr__pfet_01v8_hvt ad=0.2184 pd=2.2 as=0.12915 ps=1.185 w=0.84 l=0.15
X424 LELO_GR01_0.x8.x1.x5.IBN LELO_GR01_0.x8.IBP_BG LELO_GR01_0.x8.x1.x7.D VGND sky130_fd_pr__nfet_01v8_lvt ad=0.5088 pd=2.98 as=0.3168 ps=1.62 w=0.96 l=0.94
X425 VDPWR a_4833_3436# digital_0.hold28.A VDPWR sky130_fd_pr__pfet_01v8_hvt ad=0.26 pd=2.52 as=0.135 ps=1.27 w=1 l=0.15
X426 a_4594_3650# digital_0.output4.A VDPWR VDPWR sky130_fd_pr__pfet_01v8_hvt ad=0.27 pd=2.54 as=0.19265 ps=1.415 w=1 l=0.15
X427 VGND a_13481_386# digital_0._112_.Q VGND sky130_fd_pr__nfet_01v8 ad=0.169 pd=1.82 as=0.08775 ps=0.92 w=0.65 l=0.15
X428 a_13888_n676# digital_0.hold28.A VGND VGND sky130_fd_pr__nfet_01v8 ad=0.0693 pd=0.75 as=0.11285 ps=1.045 w=0.42 l=0.15
X429 VDPWR LELO_GR01_0.x8.PWRUP_N_1V8 LELO_GR01_0.x8.x8.D VDPWR sky130_fd_pr__pfet_01v8_lvt ad=0.5088 pd=2.98 as=0.3168 ps=1.62 w=0.96 l=0.94
X430 a_10077_246# a_9631_n126# a_9981_246# VGND sky130_fd_pr__special_nfet_01v8 ad=0.1401 pd=1.1 as=0.0594 ps=0.69 w=0.36 l=0.15
X431 digital_0.output10.A a_14861_172# VGND VGND sky130_fd_pr__nfet_01v8 ad=0.08775 pd=0.92 as=0.2087 ps=2.02 w=0.65 l=0.15
X432 digital_0._111_.RESET_B digital_0.load_slew17.A a_9557_2838# VDPWR sky130_fd_pr__pfet_01v8_hvt ad=0.135 pd=1.27 as=0.135 ps=1.27 w=1 l=0.15
X433 LELO_GR01_0.x7.x21.D LELO_GR01_0.x8.PWRUP_N_1V8 LELO_GR01_0.x7.x22.D VDPWR sky130_fd_pr__pfet_01v8_lvt ad=0.3168 pd=1.62 as=0.5088 ps=2.98 w=0.96 l=0.94
X434 VGND a_10986_3828# digital_0._103_.D VGND sky130_fd_pr__nfet_01v8 ad=0.11285 pd=1.045 as=0.169 ps=1.82 w=0.65 l=0.15
X435 VDPWR digital_0.hold28.A a_12635_3171# VDPWR sky130_fd_pr__pfet_01v8_hvt ad=0.0693 pd=0.75 as=0.1176 ps=1.4 w=0.42 l=0.15
X436 VGND digital_0._108_.Q a_5942_2404# VGND sky130_fd_pr__nfet_01v8 ad=0.1304 pd=1.105 as=0.05355 ps=0.675 w=0.42 l=0.15
X437 VDPWR a_12189_3650# a_11931_3650# VDPWR sky130_fd_pr__pfet_01v8_hvt ad=0.0567 pd=0.69 as=0.1092 ps=1.36 w=0.42 l=0.5
X438 VGND VDPWR VGND VGND sky130_fd_pr__nfet_01v8 ad=0.143 pd=1.62 as=0 ps=0 w=0.55 l=0.59
X439 VDPWR a_3492_3650# uio_out<0> VDPWR sky130_fd_pr__pfet_01v8_hvt ad=0.2726 pd=1.61 as=0.495 ps=2.99 w=1 l=0.15
X440 VDPWR a_6263_2562# a_6293_2915# VDPWR sky130_fd_pr__pfet_01v8_hvt ad=0.0693 pd=0.75 as=0.0441 ps=0.63 w=0.42 l=0.15
X441 VGND digital_0.clkload0.A a_13513_3138# VGND sky130_fd_pr__nfet_01v8 ad=0.0567 pd=0.69 as=0.1092 ps=1.36 w=0.42 l=0.15
X442 VDPWR digital_0.load_slew15.X digital_0._116_.SET_B VDPWR sky130_fd_pr__pfet_01v8_hvt ad=0.26 pd=2.52 as=0.135 ps=1.27 w=1 l=0.15
X443 VDPWR LELO_GR01_0.x7.xd1<4>.A sky130_fd_pr__cap_mim_m3_1 l=5 w=5
X444 a_12189_3650# digital_0.output8.A VGND VGND sky130_fd_pr__nfet_01v8 ad=0.1092 pd=1.36 as=0.0567 ps=0.69 w=0.42 l=0.15
X445 LELO_GR01_0.x7.x15.I2 LELO_GR01_0.x7.xd1<4>.A VDPWR VDPWR sky130_fd_pr__pfet_01v8_lvt ad=0.3168 pd=1.62 as=0.5088 ps=2.98 w=0.96 l=0.94
X446 a_22698_16564# a_22482_14644# VGND sky130_fd_pr__res_high_po w=0.36 l=7.36
X447 VGND VDPWR VGND VGND sky130_fd_pr__nfet_01v8 ad=0.143 pd=1.62 as=0 ps=0 w=0.55 l=0.59
X448 VDPWR a_14727_1474# a_14757_1827# VDPWR sky130_fd_pr__pfet_01v8_hvt ad=0.0693 pd=0.75 as=0.0441 ps=0.63 w=0.42 l=0.15
X449 VGND a_8996_1500# digital_0.clkbuf_1_1__f_clk.A VGND sky130_fd_pr__nfet_01v8 ad=0.0588 pd=0.7 as=0.0588 ps=0.7 w=0.42 l=0.15
X450 digital_0._113_.Q a_13481_1474# VGND VGND sky130_fd_pr__nfet_01v8 ad=0.08775 pd=0.92 as=0.2087 ps=2.02 w=0.65 l=0.15
X451 a_13306_1500# a_12391_1500# a_12959_1742# VGND sky130_fd_pr__special_nfet_01v8 ad=0.0711 pd=0.755 as=0.0999 ps=0.985 w=0.36 l=0.15
X452 a_4005_n158# a_4292_0# VDPWR VDPWR sky130_fd_pr__pfet_01v8_hvt ad=0.0567 pd=0.69 as=0.1134 ps=1.38 w=0.42 l=0.15
X453 a_9341_412# a_8895_412# a_9245_412# VGND sky130_fd_pr__special_nfet_01v8 ad=0.1401 pd=1.1 as=0.0594 ps=0.69 w=0.36 l=0.15
X454 VGND LELO_GR01_0.x8.x1.x5.x9<2>.G LELO_GR01_0.x8.x1.x5.IBN VGND sky130_fd_pr__nfet_01v8_lvt ad=0.5088 pd=2.98 as=0.3168 ps=1.62 w=0.96 l=0.94
X455 a_4587_2018# a_4369_2422# VDPWR VDPWR sky130_fd_pr__pfet_01v8_hvt ad=0.12915 pd=1.185 as=0.2184 ps=2.2 w=0.84 l=0.15
X456 VDPWR a_11273_3436# a_11260_3132# VDPWR sky130_fd_pr__pfet_01v8_hvt ad=0.0819 pd=0.81 as=0.0567 ps=0.69 w=0.42 l=0.15
X457 VDPWR digital_0._100_.RESET_B a_3821_2562# VDPWR sky130_fd_pr__pfet_01v8_hvt ad=0.0819 pd=0.81 as=0.0567 ps=0.69 w=0.42 l=0.15
X458 digital_0.output6.A a_5109_2348# VDPWR VDPWR sky130_fd_pr__pfet_01v8_hvt ad=0.135 pd=1.27 as=0.3012 ps=2.66 w=1 l=0.15
X459 a_15331_564# a_15427_386# VGND VGND sky130_fd_pr__nfet_01v8 ad=0.1092 pd=1.36 as=0.097 ps=0.975 w=0.42 l=0.5
X460 a_7577_n676# digital_0.hold26.X a_7214_n524# VGND sky130_fd_pr__nfet_01v8 ad=0.0693 pd=0.75 as=0.09975 ps=0.895 w=0.42 l=0.15
X461 VDPWR a_12626_n676# a_12737_n676# VDPWR sky130_fd_pr__pfet_01v8_hvt ad=0.2726 pd=1.61 as=0.2173 ps=2.17 w=0.82 l=0.25
X462 digital_0._101_.RESET_B digital_0.load_slew15.X VDPWR VDPWR sky130_fd_pr__pfet_01v8_hvt ad=0.135 pd=1.27 as=0.26 ps=2.52 w=1 l=0.15
X463 VDPWR a_10721_172# a_10708_n132# VDPWR sky130_fd_pr__pfet_01v8_hvt ad=0.0819 pd=0.81 as=0.0567 ps=0.69 w=0.42 l=0.15
X464 a_10555_956# digital_0._114_.Q a_10253_930# VDPWR sky130_fd_pr__pfet_01v8_hvt ad=0.135 pd=1.27 as=0.26 ps=2.52 w=1 l=0.15
X465 a_12741_1500# a_12391_1500# a_12646_1500# VDPWR sky130_fd_pr__pfet_01v8_hvt ad=0.07245 pd=0.765 as=0.0651 ps=0.73 w=0.42 l=0.15
X466 a_4143_2588# a_4108_2840# a_3821_2562# VGND sky130_fd_pr__nfet_01v8 ad=0.06405 pd=0.725 as=0.1092 ps=1.36 w=0.42 l=0.15
X467 a_14247_3106# a_14029_3510# VGND VGND sky130_fd_pr__nfet_01v8 ad=0.0999 pd=0.985 as=0.1346 ps=1.15 w=0.64 l=0.15
X468 a_7826_956# digital_0._060_.A_N a_7155_930# VDPWR sky130_fd_pr__pfet_01v8_hvt ad=0.135 pd=1.27 as=0.135 ps=1.27 w=1 l=0.15
X469 VGND a_14298_1652# digital_0._104_.D VGND sky130_fd_pr__nfet_01v8 ad=0.11285 pd=1.045 as=0.169 ps=1.82 w=0.65 l=0.15
X470 a_9245_412# a_8729_412# a_9150_412# VGND sky130_fd_pr__special_nfet_01v8 ad=0.0594 pd=0.69 as=0.066 ps=0.745 w=0.36 l=0.15
X471 a_9631_n126# a_9465_n126# VGND VGND sky130_fd_pr__nfet_01v8 ad=0.1092 pd=1.36 as=0.0567 ps=0.69 w=0.42 l=0.15
X472 LELO_GR01_0.x8.IBP_BG LELO_GR01_0.x8.x5.CK VGND VGND sky130_fd_pr__nfet_01v8_lvt ad=0.3168 pd=1.62 as=0.5088 ps=2.98 w=0.96 l=0.94
X473 VGND rst_n sky130_fd_pr__diode_pw2nd_05v5 perim=1.8e+06 area=2.025e+11
X474 digital_0._113_.RESET_B digital_0._116_.Q VGND VGND sky130_fd_pr__nfet_01v8 ad=0.08775 pd=0.92 as=0.182 ps=1.86 w=0.65 l=0.15
X475 a_6263_2562# digital_0.hold28.A VGND VGND sky130_fd_pr__nfet_01v8 ad=0.1092 pd=1.36 as=0.1449 ps=1.11 w=0.42 l=0.15
X476 LELO_GR01_0.x7.x6<3>.G LELO_GR01_0.x7.x18.D LELO_GR01_0.x7.xd1<4>.A VGND sky130_fd_pr__nfet_01v8_lvt ad=0.5088 pd=2.98 as=0.3168 ps=1.62 w=0.96 l=0.94
X477 a_4934_2422# a_3853_2050# a_4587_2018# VDPWR sky130_fd_pr__pfet_01v8_hvt ad=0.0588 pd=0.7 as=0.12915 ps=1.185 w=0.42 l=0.15
X478 a_10997_386# digital_0._057_.D VDPWR VDPWR sky130_fd_pr__pfet_01v8_hvt ad=0.0588 pd=0.7 as=0.27995 ps=1.615 w=0.42 l=0.15
X479 VDPWR VGND VDPWR VDPWR sky130_fd_pr__pfet_01v8_hvt ad=0.2262 pd=2.26 as=0 ps=0 w=0.87 l=0.59
X480 digital_0.load_slew15.X a_8085_1500# VDPWR VDPWR sky130_fd_pr__pfet_01v8_hvt ad=0.135 pd=1.27 as=0.135 ps=1.27 w=1 l=0.15
X481 a_3492_3650# a_3618_3834# VGND VGND sky130_fd_pr__nfet_01v8 ad=0.17225 pd=1.83 as=0.1856 ps=1.26 w=0.65 l=0.25
X482 a_7418_2422# a_6503_2050# a_7071_2018# VGND sky130_fd_pr__special_nfet_01v8 ad=0.0711 pd=0.755 as=0.0999 ps=0.985 w=0.36 l=0.15
X483 a_10429_n676# digital_0.hold21.X a_10066_n524# VGND sky130_fd_pr__nfet_01v8 ad=0.0693 pd=0.75 as=0.09975 ps=0.895 w=0.42 l=0.15
X484 digital_0.clkbuf_1_1__f_clk.A a_8996_1500# VGND VGND sky130_fd_pr__nfet_01v8 ad=0.0588 pd=0.7 as=0.0588 ps=0.7 w=0.42 l=0.15
X485 VDPWR a_10721_2348# digital_0._111_.Q VDPWR sky130_fd_pr__pfet_01v8_hvt ad=0.26 pd=2.52 as=0.135 ps=1.27 w=1 l=0.15
X486 VGND digital_0.clkbuf_1_0__f_clk.X a_3577_3138# VGND sky130_fd_pr__nfet_01v8 ad=0.0567 pd=0.69 as=0.1092 ps=1.36 w=0.42 l=0.15
X487 a_18600_16564# a_18816_14644# VGND sky130_fd_pr__res_high_po w=0.36 l=7.36
X488 digital_0.output11.A a_10721_172# VGND VGND sky130_fd_pr__nfet_01v8 ad=0.08775 pd=0.92 as=0.2087 ps=2.02 w=0.65 l=0.15
X489 digital_0.clkbuf_1_0__f_clk.X a_6315_1474# VDPWR VDPWR sky130_fd_pr__pfet_01v8_hvt ad=0.14 pd=1.28 as=0.1375 ps=1.275 w=1 l=0.15
X490 VGND digital_0.output4.A a_4243_n676# VGND sky130_fd_pr__nfet_01v8 ad=0.0567 pd=0.69 as=0.1092 ps=1.36 w=0.42 l=0.15
X491 a_9151_n702# digital_0._060_.B VDPWR VDPWR sky130_fd_pr__pfet_01v8_hvt ad=0.0609 pd=0.71 as=0.22895 ps=1.745 w=0.42 l=0.15
X492 a_3814_386# a_3982_386# VGND VGND sky130_fd_pr__nfet_01v8 ad=0.169 pd=1.82 as=0.08775 ps=0.92 w=0.65 l=0.15
X493 VDPWR LELO_GR01_0.x8.PWRUP_N_1V8 LELO_GR01_0.x8.x1.x5.x8.S VDPWR sky130_fd_pr__pfet_01v8_lvt ad=0.5088 pd=2.98 as=0.3168 ps=1.62 w=0.96 l=0.94
X494 digital_0.hold18.X a_4585_n676# VGND VGND sky130_fd_pr__nfet_01v8 ad=0.169 pd=1.82 as=0.097 ps=0.975 w=0.65 l=0.15
X495 a_7720_n132# a_7001_110# a_7157_n158# VGND sky130_fd_pr__special_nfet_01v8 ad=0.066 pd=0.745 as=0.0594 ps=0.69 w=0.36 l=0.15
X496 a_14861_172# a_14686_246# a_15040_234# VGND sky130_fd_pr__nfet_01v8 ad=0.1092 pd=1.36 as=0.06405 ps=0.725 w=0.42 l=0.15
X497 VGND VDPWR VGND VGND sky130_fd_pr__nfet_01v8 ad=0.143 pd=1.62 as=0 ps=0 w=0.55 l=0.59
X498 VGND a_5661_1260# digital_0.output13.A VGND sky130_fd_pr__nfet_01v8 ad=0.169 pd=1.82 as=0.08775 ps=0.92 w=0.65 l=0.15
X499 VDPWR LELO_GR01_0.x7.xd1<4>.A LELO_GR01_0.x7.x15.I2 VDPWR sky130_fd_pr__pfet_01v8_lvt ad=0.5088 pd=2.98 as=0.3168 ps=1.62 w=0.96 l=0.94
X500 VDPWR a_5855_564# digital_0.hold22.X VDPWR sky130_fd_pr__pfet_01v8_hvt ad=0.14075 pd=1.325 as=0.26 ps=2.52 w=1 l=0.15
X501 a_9886_234# digital_0._106_.D VGND VGND sky130_fd_pr__nfet_01v8 ad=0.066 pd=0.745 as=0.2205 ps=1.89 w=0.42 l=0.15
X502 VGND digital_0.output11.A a_12409_n676# VGND sky130_fd_pr__nfet_01v8 ad=0.1228 pd=1.065 as=0.1134 ps=1.38 w=0.42 l=0.15
X503 digital_0._111_.Q a_10721_2348# VGND VGND sky130_fd_pr__nfet_01v8 ad=0.08775 pd=0.92 as=0.2087 ps=2.02 w=0.65 l=0.15
X504 a_10533_3510# a_10017_3138# a_10438_3498# VGND sky130_fd_pr__special_nfet_01v8 ad=0.0594 pd=0.69 as=0.066 ps=0.745 w=0.36 l=0.15
X505 digital_0._069_.B digital_0._109_.Q VGND VGND sky130_fd_pr__nfet_01v8 ad=0.08775 pd=0.92 as=0.10725 ps=0.98 w=0.65 l=0.15
X506 LELO_GR01_0.x8.x8.D LELO_GR01_0.x8.x8.D LELO_GR01_0.x8.x8.D LELO_GR01_0.x8.x8.D sky130_fd_pr__pfet_01v8 ad=0.468 pd=2.84 as=5.8896 ps=34.72 w=0.9 l=0.16
X507 digital_0.clkload0.A a_11388_956# VGND VGND sky130_fd_pr__nfet_01v8 ad=0.0588 pd=0.7 as=0.0588 ps=0.7 w=0.42 l=0.15
X508 digital_0._114_.D a_9151_n702# VGND VGND sky130_fd_pr__nfet_01v8 ad=0.08775 pd=0.92 as=0.1755 ps=1.84 w=0.65 l=0.15
X509 VGND a_5787_2146# digital_0._069_.A VGND sky130_fd_pr__nfet_01v8 ad=0.17875 pd=1.85 as=0.08775 ps=0.92 w=0.65 l=0.15
X510 a_3858_3650# digital_0.output5.A VDPWR VDPWR sky130_fd_pr__pfet_01v8_hvt ad=0.27 pd=2.54 as=0.19265 ps=1.415 w=1 l=0.15
X511 a_3982_386# a_4530_626# a_4488_778# VDPWR sky130_fd_pr__pfet_01v8_hvt ad=0.0819 pd=0.81 as=0.0441 ps=0.63 w=0.42 l=0.15
X512 a_23334_13064# a_23550_11144# VGND sky130_fd_pr__res_high_po w=0.36 l=7.36
X513 digital_0._108_.D a_6235_3106# a_6179_3132# VDPWR sky130_fd_pr__pfet_01v8_hvt ad=0.135 pd=1.27 as=0.28 ps=2.56 w=1 l=0.15
X514 VGND digital_0._114_.RESET_B a_9507_412# VGND sky130_fd_pr__nfet_01v8 ad=0.1346 pd=1.15 as=0.0441 ps=0.63 w=0.42 l=0.15
X515 a_8552_18000# a_10472_18216# VGND sky130_fd_pr__res_high_po w=0.36 l=7.36
X516 a_11445_4003# digital_0._111_.Q a_10986_3828# VDPWR sky130_fd_pr__pfet_01v8_hvt ad=0.0441 pd=0.63 as=0.1932 ps=1.34 w=0.42 l=0.15
X517 digital_0.hold18.X a_4585_n676# VDPWR VDPWR sky130_fd_pr__pfet_01v8_hvt ad=0.26 pd=2.52 as=0.14075 ps=1.325 w=1 l=0.15
X518 VDPWR VGND VDPWR VDPWR sky130_fd_pr__pfet_01v8_hvt ad=0.2262 pd=2.26 as=0 ps=0 w=0.87 l=0.59
X519 a_7221_412# a_6705_412# a_7126_412# VGND sky130_fd_pr__special_nfet_01v8 ad=0.0594 pd=0.69 as=0.066 ps=0.745 w=0.36 l=0.15
X520 a_3858_930# digital_0.output6.A VDPWR VDPWR sky130_fd_pr__pfet_01v8_hvt ad=0.27 pd=2.54 as=0.19265 ps=1.415 w=1 l=0.15
X521 VGND VDPWR VGND VGND sky130_fd_pr__nfet_01v8 ad=0.143 pd=1.62 as=0 ps=0 w=0.55 l=0.59
X522 VDPWR VGND VDPWR VDPWR sky130_fd_pr__pfet_01v8_hvt ad=0.2262 pd=2.26 as=0 ps=0 w=0.87 l=0.59
X523 a_15685_386# digital_0.output9.A VDPWR VDPWR sky130_fd_pr__pfet_01v8_hvt ad=0.1092 pd=1.36 as=0.0567 ps=0.69 w=0.42 l=0.15
X524 a_11128_3676# digital_0.hold28.A VGND VGND sky130_fd_pr__nfet_01v8 ad=0.0693 pd=0.75 as=0.11285 ps=1.045 w=0.42 l=0.15
X525 VDPWR digital_0.output11.A a_12409_n676# VDPWR sky130_fd_pr__pfet_01v8_hvt ad=0.19265 pd=1.415 as=0.27 ps=2.54 w=1 l=0.15
X526 VDPWR digital_0._116_.Q a_9005_956# VDPWR sky130_fd_pr__pfet_01v8_hvt ad=0.135 pd=1.27 as=0.28 ps=2.56 w=1 l=0.15
X527 LELO_GR01_0.x7.x11.N a_29150_11144# VGND sky130_fd_pr__res_high_po w=0.36 l=7.36
X528 a_10243_234# a_10199_n158# a_10077_246# VGND sky130_fd_pr__nfet_01v8 ad=0.0441 pd=0.63 as=0.1401 ps=1.1 w=0.42 l=0.15
X529 a_4311_3106# a_4093_3510# VGND VGND sky130_fd_pr__nfet_01v8 ad=0.0999 pd=0.985 as=0.1346 ps=1.15 w=0.64 l=0.15
X530 digital_0._114_.D a_9151_n702# VDPWR VDPWR sky130_fd_pr__pfet_01v8_hvt ad=0.135 pd=1.27 as=0.26 ps=2.52 w=1 l=0.15
X531 a_7948_778# a_6871_412# a_7786_412# VDPWR sky130_fd_pr__pfet_01v8_hvt ad=0.0567 pd=0.69 as=0.0588 ps=0.7 w=0.42 l=0.15
X532 VDPWR VGND VDPWR VDPWR sky130_fd_pr__pfet_01v8_hvt ad=0.2262 pd=2.26 as=0 ps=0 w=0.87 l=0.59
X533 VGND digital_0._109_.RESET_B a_7667_2588# VGND sky130_fd_pr__nfet_01v8 ad=0.1346 pd=1.15 as=0.0441 ps=0.63 w=0.42 l=0.15
X534 a_6503_2050# a_6337_2050# VGND VGND sky130_fd_pr__nfet_01v8 ad=0.1092 pd=1.36 as=0.0567 ps=0.69 w=0.42 l=0.15
X535 a_10183_3138# a_10017_3138# VGND VGND sky130_fd_pr__nfet_01v8 ad=0.1092 pd=1.36 as=0.0567 ps=0.69 w=0.42 l=0.15
X536 digital_0._103_.RESET_B digital_0.load_slew17.A VGND VGND sky130_fd_pr__nfet_01v8 ad=0.08775 pd=0.92 as=0.169 ps=1.82 w=0.65 l=0.15
X537 a_12741_412# a_12225_412# a_12646_412# VGND sky130_fd_pr__special_nfet_01v8 ad=0.0594 pd=0.69 as=0.066 ps=0.745 w=0.36 l=0.15
X538 VGND VDPWR VGND VGND sky130_fd_pr__nfet_01v8 ad=0.143 pd=1.62 as=0 ps=0 w=0.55 l=0.59
X539 VGND VDPWR VGND VGND sky130_fd_pr__nfet_01v8 ad=0.143 pd=1.62 as=0 ps=0 w=0.55 l=0.59
X540 a_9353_778# digital_0._114_.RESET_B VDPWR VDPWR sky130_fd_pr__pfet_01v8_hvt ad=0.1092 pd=1.36 as=0.07035 ps=0.755 w=0.42 l=0.15
X541 VDPWR digital_0._116_.Q a_8837_2838# VDPWR sky130_fd_pr__pfet_01v8_hvt ad=0.135 pd=1.27 as=0.135 ps=1.27 w=1 l=0.15
X542 a_14795_246# a_13605_n126# a_14686_246# VGND sky130_fd_pr__special_nfet_01v8 ad=0.0669 pd=0.75 as=0.0711 ps=0.755 w=0.36 l=0.15
X543 VGND digital_0.input1.X a_12225_412# VGND sky130_fd_pr__nfet_01v8 ad=0.0567 pd=0.69 as=0.1092 ps=1.36 w=0.42 l=0.15
X544 VGND digital_0._116_.Q digital_0._110_.RESET_B VGND sky130_fd_pr__nfet_01v8 ad=0.182 pd=1.86 as=0.08775 ps=0.92 w=0.65 l=0.15
X545 VDPWR a_6315_1474# digital_0.clkbuf_1_0__f_clk.X VDPWR sky130_fd_pr__pfet_01v8_hvt ad=0.14 pd=1.28 as=0.14 ps=1.28 w=1 l=0.15
X546 VDPWR a_4005_n158# digital_0.output4.A VDPWR sky130_fd_pr__pfet_01v8_hvt ad=0.3012 pd=2.66 as=0.135 ps=1.27 w=1 l=0.15
X547 VGND a_15413_1260# digital_0.output9.A VGND sky130_fd_pr__nfet_01v8 ad=0.169 pd=1.82 as=0.08775 ps=0.92 w=0.65 l=0.15
X548 LELO_GR01_0.x8.x1.x5.IBN LELO_GR01_0.x8.x1.x5.x9<2>.G VGND VGND sky130_fd_pr__nfet_01v8_lvt ad=0.3168 pd=1.62 as=0.5088 ps=2.98 w=0.96 l=0.94
X549 a_7214_n524# digital_0.hold26.X a_7356_n349# VDPWR sky130_fd_pr__pfet_01v8_hvt ad=0.1932 pd=1.34 as=0.07665 ps=0.785 w=0.42 l=0.15
X550 a_4438_386# digital_0.clkbuf_1_0__f_clk.X VDPWR VDPWR sky130_fd_pr__pfet_01v8_hvt ad=0.1664 pd=1.8 as=0.0864 ps=0.91 w=0.64 l=0.15
X551 VDPWR a_5661_1260# digital_0.output13.A VDPWR sky130_fd_pr__pfet_01v8_hvt ad=0.26 pd=2.52 as=0.135 ps=1.27 w=1 l=0.15
X552 LELO_GR01_0.x8.x5.XA7.MP1.S LELO_GR01_0.x8.x5.Q LELO_GR01_0.x8.x5.XA7.MN0.S VGND sky130_fd_pr__nfet_01v8 ad=0.288 pd=1.54 as=0.288 ps=1.54 w=0.9 l=0.16
X553 digital_0._112_.Q a_13481_386# VDPWR VDPWR sky130_fd_pr__pfet_01v8_hvt ad=0.135 pd=1.27 as=0.3012 ps=2.66 w=1 l=0.15
X554 a_6853_2422# a_6503_2050# a_6758_2410# VDPWR sky130_fd_pr__pfet_01v8_hvt ad=0.07245 pd=0.765 as=0.0651 ps=0.73 w=0.42 l=0.15
X555 a_10089_2044# a_9465_2050# a_9981_2422# VDPWR sky130_fd_pr__pfet_01v8_hvt ad=0.1155 pd=0.97 as=0.07245 ps=0.765 w=0.42 l=0.15
X556 a_23130_16564# a_23346_14644# VGND sky130_fd_pr__res_high_po w=0.36 l=7.36
X557 VGND VDPWR VGND VGND sky130_fd_pr__nfet_01v8 ad=0.143 pd=1.62 as=0 ps=0 w=0.55 l=0.59
X558 VDPWR a_5159_1474# a_5189_1827# VDPWR sky130_fd_pr__pfet_01v8_hvt ad=0.0693 pd=0.75 as=0.0441 ps=0.63 w=0.42 l=0.15
X559 digital_0.clkload0.X a_11673_412# VGND VGND sky130_fd_pr__nfet_01v8 ad=0.0588 pd=0.7 as=0.07035 ps=0.755 w=0.42 l=0.15
X560 a_11431_2382# digital_0._111_.Q VDPWR VDPWR sky130_fd_pr__pfet_01v8_hvt ad=0.0567 pd=0.69 as=0.1176 ps=1.4 w=0.42 l=0.15
X561 a_7317_412# a_6871_412# a_7221_412# VGND sky130_fd_pr__special_nfet_01v8 ad=0.1401 pd=1.1 as=0.0594 ps=0.69 w=0.36 l=0.15
X562 a_12391_1500# a_12225_1500# VDPWR VDPWR sky130_fd_pr__pfet_01v8_hvt ad=0.1664 pd=1.8 as=0.0864 ps=0.91 w=0.64 l=0.15
X563 VDPWR a_4934_2422# a_5109_2348# VDPWR sky130_fd_pr__pfet_01v8_hvt ad=0.1134 pd=1.38 as=0.0567 ps=0.69 w=0.42 l=0.15
X564 a_15592_1322# digital_0._104_.RESET_B VGND VGND sky130_fd_pr__nfet_01v8 ad=0.06405 pd=0.725 as=0.12495 ps=1.015 w=0.42 l=0.15
X565 a_9981_2422# a_9465_2050# a_9886_2410# VGND sky130_fd_pr__special_nfet_01v8 ad=0.0594 pd=0.69 as=0.066 ps=0.745 w=0.36 l=0.15
X566 a_5976_2915# digital_0.hold28.A VDPWR VDPWR sky130_fd_pr__pfet_01v8_hvt ad=0.07665 pd=0.785 as=0.15835 ps=1.395 w=0.42 l=0.15
X567 VDPWR a_5834_2740# digital_0._100_.D VDPWR sky130_fd_pr__pfet_01v8_hvt ad=0.15835 pd=1.395 as=0.26 ps=2.52 w=1 l=0.15
X568 uio_out<6> a_12737_n676# VGND VGND sky130_fd_pr__nfet_01v8 ad=0.2079 pd=1.83 as=0.1856 ps=1.26 w=0.42 l=0.15
X569 digital_0._114_.RESET_B digital_0.load_slew15.A VGND VGND sky130_fd_pr__nfet_01v8 ad=0.08775 pd=0.92 as=0.08775 ps=0.92 w=0.65 l=0.15
X570 a_12407_2830# a_12189_2588# VGND VGND sky130_fd_pr__nfet_01v8 ad=0.0999 pd=0.985 as=0.1346 ps=1.15 w=0.64 l=0.15
X571 a_6761_930# digital_0.hold28.A VDPWR VDPWR sky130_fd_pr__pfet_01v8_hvt ad=0.1092 pd=1.36 as=0.0567 ps=0.69 w=0.42 l=0.15
X572 a_13934_3498# digital_0._102_.D VGND VGND sky130_fd_pr__nfet_01v8 ad=0.066 pd=0.745 as=0.2205 ps=1.89 w=0.42 l=0.15
X573 a_7356_n349# digital_0.hold28.A VDPWR VDPWR sky130_fd_pr__pfet_01v8_hvt ad=0.07665 pd=0.785 as=0.15835 ps=1.395 w=0.42 l=0.15
X574 LELO_GR01_0.x8.x5.XA3.MP1.S uo_out<0> LELO_GR01_0.x8.x8.D LELO_GR01_0.x8.x8.D sky130_fd_pr__pfet_01v8 ad=0.288 pd=1.54 as=0.468 ps=2.84 w=0.9 l=0.16
X575 a_11758_188# digital_0._113_.Q VGND VGND sky130_fd_pr__nfet_01v8 ad=0.08775 pd=0.92 as=0.17875 ps=1.85 w=0.65 l=0.15
X576 VDPWR a_11388_956# digital_0.clkload0.A VDPWR sky130_fd_pr__pfet_01v8_hvt ad=0.14 pd=1.28 as=0.14 ps=1.28 w=1 l=0.15
X577 digital_0._117_.RESET_B digital_0.load_slew15.X VDPWR VDPWR sky130_fd_pr__pfet_01v8_hvt ad=0.135 pd=1.27 as=0.26 ps=2.52 w=1 l=0.15
X578 digital_0.clkbuf_1_0__f_clk.X a_6315_1474# VDPWR VDPWR sky130_fd_pr__pfet_01v8_hvt ad=0.14 pd=1.28 as=0.14 ps=1.28 w=1 l=0.15
X579 VGND VDPWR VGND VGND sky130_fd_pr__nfet_01v8 ad=0.143 pd=1.62 as=0 ps=0 w=0.55 l=0.59
X580 VDPWR LELO_GR01_0.x7.xd1<4>.A LELO_GR01_0.x7.x15.I2 VDPWR sky130_fd_pr__pfet_01v8_lvt ad=0.5088 pd=2.98 as=0.3168 ps=1.62 w=0.96 l=0.94
X581 VGND a_3982_386# a_4118_412# VGND sky130_fd_pr__nfet_01v8 ad=0.1137 pd=1.01 as=0.1404 ps=1.6 w=0.54 l=0.15
X582 a_6961_2044# a_6337_2050# a_6853_2422# VDPWR sky130_fd_pr__pfet_01v8_hvt ad=0.1155 pd=0.97 as=0.07245 ps=0.765 w=0.42 l=0.15
X583 JNWTR_IVX1_CV_0.Y rst_n VGND VGND sky130_fd_pr__nfet_01v8 ad=0.468 pd=2.84 as=0.468 ps=2.84 w=0.9 l=0.16
X584 VGND VGND LELO_GR01_0.x7.x15.I1 sky130_fd_pr__pnp_05v5_W3p40L3p40
**devattr s=462400,2720
X585 a_5029_956# digital_0._118_.RESET_B VDPWR VDPWR sky130_fd_pr__pfet_01v8_hvt ad=0.1092 pd=1.36 as=0.07035 ps=0.755 w=0.42 l=0.15
X586 a_12837_412# a_12391_412# a_12741_412# VGND sky130_fd_pr__special_nfet_01v8 ad=0.1401 pd=1.1 as=0.0594 ps=0.69 w=0.36 l=0.15
X587 a_12959_654# a_12741_412# VDPWR VDPWR sky130_fd_pr__pfet_01v8_hvt ad=0.12915 pd=1.185 as=0.2184 ps=2.2 w=0.84 l=0.15
X588 VDPWR LELO_GR01_0.x7.x1.x7.D LELO_GR01_0.x7.x1.x7.D VDPWR sky130_fd_pr__pfet_01v8_lvt ad=0.5088 pd=2.98 as=0.3168 ps=1.62 w=0.96 l=0.94
X589 a_12903_206# digital_0._114_.Q VDPWR VDPWR sky130_fd_pr__pfet_01v8_hvt ad=0.0567 pd=0.69 as=0.1176 ps=1.4 w=0.42 l=0.15
X590 VGND digital_0._117_.RESET_B a_4355_3498# VGND sky130_fd_pr__nfet_01v8 ad=0.1346 pd=1.15 as=0.0441 ps=0.63 w=0.42 l=0.15
X591 VGND digital_0.load_slew15.X digital_0._119_.RESET_B VGND sky130_fd_pr__nfet_01v8 ad=0.169 pd=1.82 as=0.08775 ps=0.92 w=0.65 l=0.15
X592 a_10199_2018# a_9981_2422# VGND VGND sky130_fd_pr__nfet_01v8 ad=0.0999 pd=0.985 as=0.1346 ps=1.15 w=0.64 l=0.15
X593 VDPWR VGND VDPWR VDPWR sky130_fd_pr__pfet_01v8_hvt ad=0.2262 pd=2.26 as=0 ps=0 w=0.87 l=0.59
X594 VGND VDPWR VGND VGND sky130_fd_pr__nfet_01v8 ad=0.143 pd=1.62 as=0 ps=0 w=0.55 l=0.59
X595 a_11098_3510# a_10183_3138# a_10751_3106# VGND sky130_fd_pr__special_nfet_01v8 ad=0.0711 pd=0.755 as=0.0999 ps=0.985 w=0.36 l=0.15
X596 a_4274_2410# digital_0._101_.D VDPWR VDPWR sky130_fd_pr__pfet_01v8_hvt ad=0.0651 pd=0.73 as=0.1092 ps=1.36 w=0.42 l=0.15
X597 a_13612_3650# a_13738_3834# VGND VGND sky130_fd_pr__nfet_01v8 ad=0.17225 pd=1.83 as=0.1856 ps=1.26 w=0.65 l=0.25
X598 uio_out<3> a_12829_3676# VGND VGND sky130_fd_pr__nfet_01v8 ad=0.2079 pd=1.83 as=0.1856 ps=1.26 w=0.42 l=0.15
X599 a_10546_246# a_9631_n126# a_10199_n158# VGND sky130_fd_pr__special_nfet_01v8 ad=0.0711 pd=0.755 as=0.0999 ps=0.985 w=0.36 l=0.15
X600 digital_0.clkbuf_1_1__f_clk.A a_8996_1500# VGND VGND sky130_fd_pr__nfet_01v8 ad=0.0588 pd=0.7 as=0.0588 ps=0.7 w=0.42 l=0.15
X601 VDPWR a_9564_930# digital_0.load_slew15.A VDPWR sky130_fd_pr__pfet_01v8_hvt ad=0.2726 pd=1.61 as=0.495 ps=2.99 w=1 l=0.15
X602 a_28102_16564# a_28318_14644# VGND sky130_fd_pr__res_high_po w=0.36 l=7.36
X603 digital_0._069_.A a_5787_2146# VDPWR VDPWR sky130_fd_pr__pfet_01v8_hvt ad=0.135 pd=1.27 as=0.15075 ps=1.345 w=1 l=0.15
X604 LELO_GR01_0.x7.x30.N LELO_GR01_0.x8.PWRUP_N_1V8 LELO_GR01_0.x7.x25.D VDPWR sky130_fd_pr__pfet_01v8_lvt ad=0.5088 pd=2.98 as=0.3168 ps=1.62 w=0.96 l=0.94
X605 a_14727_1474# digital_0.hold28.A VGND VGND sky130_fd_pr__nfet_01v8 ad=0.1092 pd=1.36 as=0.1449 ps=1.11 w=0.42 l=0.15
X606 VDPWR VGND VDPWR VDPWR sky130_fd_pr__pfet_01v8_hvt ad=0.2262 pd=2.26 as=0 ps=0 w=0.87 l=0.59
X607 uio_out<6> a_12737_n676# VDPWR VDPWR sky130_fd_pr__pfet_01v8_hvt ad=0.495 pd=2.99 as=0.2726 ps=1.61 w=1 l=0.15
X608 LELO_GR01_0.x8.PWRUP_N_1V8 LELO_GR01_0.PWRUP_1V8 VGND VGND sky130_fd_pr__nfet_01v8 ad=0.468 pd=2.84 as=0.468 ps=2.84 w=0.9 l=0.16
X609 VDPWR VGND VDPWR VDPWR sky130_fd_pr__pfet_01v8_hvt ad=0.2262 pd=2.26 as=0 ps=0 w=0.87 l=0.59
X610 VGND a_3858_n702# a_3618_n518# VGND sky130_fd_pr__nfet_01v8 ad=0.1228 pd=1.065 as=0.17225 ps=1.83 w=0.65 l=0.25
X611 VGND digital_0._114_.Q a_10253_930# VGND sky130_fd_pr__nfet_01v8 ad=0.08775 pd=0.92 as=0.169 ps=1.82 w=0.65 l=0.15
X612 VDPWR digital_0.clkload0.A a_10017_3138# VDPWR sky130_fd_pr__pfet_01v8_hvt ad=0.0864 pd=0.91 as=0.1664 ps=1.8 w=0.64 l=0.15
X613 a_5486_1334# a_4571_962# a_5139_930# VGND sky130_fd_pr__special_nfet_01v8 ad=0.0711 pd=0.755 as=0.0999 ps=0.985 w=0.36 l=0.15
X614 LELO_GR01_0.x7.x1.x5.IBN LELO_GR01_0.x7.x15.I2 LELO_GR01_0.x7.xd1<4>.A VGND sky130_fd_pr__nfet_01v8_lvt ad=0.5088 pd=2.98 as=0.3168 ps=1.62 w=0.96 l=0.94
X615 VDPWR a_8145_2562# digital_0._109_.Q VDPWR sky130_fd_pr__pfet_01v8_hvt ad=0.26 pd=2.52 as=0.135 ps=1.27 w=1 l=0.15
X616 digital_0.output5.A a_3821_2562# VDPWR VDPWR sky130_fd_pr__pfet_01v8_hvt ad=0.135 pd=1.27 as=0.26 ps=2.52 w=1 l=0.15
X617 VDPWR LELO_GR01_0.x8.PWRUP_N_1V8 LELO_GR01_0.x7.x1.x5.x8.S VDPWR sky130_fd_pr__pfet_01v8_lvt ad=0.5088 pd=2.98 as=0.3168 ps=1.62 w=0.96 l=0.94
X618 a_10208_n349# digital_0.hold28.A VDPWR VDPWR sky130_fd_pr__pfet_01v8_hvt ad=0.07665 pd=0.785 as=0.15835 ps=1.395 w=0.42 l=0.15
X619 VGND VDPWR VGND VGND sky130_fd_pr__nfet_01v8 ad=0.143 pd=1.62 as=0 ps=0 w=0.55 l=0.59
X620 VDPWR a_15413_1260# digital_0.output9.A VDPWR sky130_fd_pr__pfet_01v8_hvt ad=0.26 pd=2.52 as=0.135 ps=1.27 w=1 l=0.15
X621 digital_0.load_slew17.X a_14762_2018# VGND VGND sky130_fd_pr__nfet_01v8 ad=0.08775 pd=0.92 as=0.17225 ps=1.83 w=0.65 l=0.15
X622 LELO_GR01_0.x7.x28.e a_17724_11144# VGND sky130_fd_pr__res_high_po w=0.36 l=7.36
X623 a_10721_2348# a_10546_2422# a_10900_2410# VGND sky130_fd_pr__nfet_01v8 ad=0.1092 pd=1.36 as=0.06405 ps=0.725 w=0.42 l=0.15
X624 JNWTR_TIEL_CV_0.MP0.G JNWTR_TIEL_CV_0.MP0.G VDPWR VDPWR sky130_fd_pr__pfet_01v8 ad=0.468 pd=2.84 as=0.468 ps=2.84 w=0.9 l=0.16
X625 VGND a_6263_2562# a_6197_2588# VGND sky130_fd_pr__nfet_01v8 ad=0.1449 pd=1.11 as=0.0693 ps=0.75 w=0.42 l=0.15
X626 VDPWR digital_0.load_slew17.A digital_0._102_.RESET_B VDPWR sky130_fd_pr__pfet_01v8_hvt ad=0.26 pd=2.52 as=0.135 ps=1.27 w=1 l=0.15
X627 VDPWR a_6315_1474# digital_0.clkbuf_1_0__f_clk.X VDPWR sky130_fd_pr__pfet_01v8_hvt ad=0.14 pd=1.28 as=0.14 ps=1.28 w=1 l=0.15
X628 a_7405_2588# a_7055_2588# a_7310_2588# VDPWR sky130_fd_pr__pfet_01v8_hvt ad=0.07245 pd=0.765 as=0.0651 ps=0.73 w=0.42 l=0.15
X629 VDPWR a_3858_3650# a_3618_3834# VDPWR sky130_fd_pr__pfet_01v8_hvt ad=0.19265 pd=1.415 as=0.2173 ps=2.17 w=0.82 l=0.25
X630 a_8578_n676# a_8361_n676# VDPWR VDPWR sky130_fd_pr__pfet_01v8_hvt ad=0.2173 pd=2.17 as=0.19265 ps=1.415 w=0.82 l=0.25
X631 LELO_GR01_0.x8.x5.XA1.MN1.S LELO_GR01_0.x8.x5.CK VGND VGND sky130_fd_pr__nfet_01v8 ad=0.288 pd=1.54 as=0.468 ps=2.84 w=0.9 l=0.16
X632 a_8684_6824# a_8468_4904# VGND sky130_fd_pr__res_high_po w=0.36 l=7.36
X633 a_7349_3132# digital_0._108_.Q VDPWR VDPWR sky130_fd_pr__pfet_01v8_hvt ad=0.135 pd=1.27 as=0.135 ps=1.27 w=1 l=0.15
X634 VDPWR LELO_GR01_0.x7.x1.x7.D LELO_GR01_0.x7.xd1<4>.A VDPWR sky130_fd_pr__pfet_01v8_lvt ad=0.5088 pd=2.98 as=0.3168 ps=1.62 w=0.96 l=0.94
X635 digital_0.output8.A a_11273_3436# VGND VGND sky130_fd_pr__nfet_01v8 ad=0.08775 pd=0.92 as=0.2087 ps=2.02 w=0.65 l=0.15
X636 LELO_GR01_0.x8.x8.D VDPWR LELO_GR01_0.x8.x5.XA7.C LELO_GR01_0.x8.x8.D sky130_fd_pr__pfet_01v8 ad=0.468 pd=2.84 as=0.288 ps=1.54 w=0.9 l=0.16
X637 VGND a_8996_1500# digital_0.clkbuf_1_1__f_clk.A VGND sky130_fd_pr__nfet_01v8 ad=0.0588 pd=0.7 as=0.0588 ps=0.7 w=0.42 l=0.15
X638 VGND a_9985_386# a_9919_412# VGND sky130_fd_pr__nfet_01v8 ad=0.12495 pd=1.015 as=0.0669 ps=0.75 w=0.42 l=0.15
X639 digital_0.load_slew15.X a_8085_1500# VDPWR VDPWR sky130_fd_pr__pfet_01v8_hvt ad=0.135 pd=1.27 as=0.135 ps=1.27 w=1 l=0.15
X640 VGND digital_0._116_.Q digital_0._109_.RESET_B VGND sky130_fd_pr__nfet_01v8 ad=0.08775 pd=0.92 as=0.08775 ps=0.92 w=0.65 l=0.15
X641 LELO_GR01_0.x7.x31.N a_6098_4904# VGND sky130_fd_pr__res_high_po w=0.36 l=7.36
X642 VDPWR digital_0.clkbuf_1_1__f_clk.A a_6315_1474# VDPWR sky130_fd_pr__pfet_01v8_hvt ad=0.265 pd=2.53 as=0.14 ps=1.28 w=1 l=0.15
X643 a_6871_412# a_6705_412# VDPWR VDPWR sky130_fd_pr__pfet_01v8_hvt ad=0.1664 pd=1.8 as=0.0864 ps=0.91 w=0.64 l=0.15
X644 VGND VDPWR VGND VGND sky130_fd_pr__nfet_01v8 ad=0.143 pd=1.62 as=0 ps=0 w=0.55 l=0.59
X645 a_7607_3452# digital_0.output13.A digital_0._069_.B VGND sky130_fd_pr__nfet_01v8 ad=0.06825 pd=0.86 as=0.091 ps=0.93 w=0.65 l=0.15
X646 digital_0._109_.D digital_0._069_.A VGND VGND sky130_fd_pr__nfet_01v8 ad=0.08775 pd=0.92 as=0.08775 ps=0.92 w=0.65 l=0.15
X647 VGND digital_0._063_.B digital_0._112_.D VGND sky130_fd_pr__nfet_01v8 ad=0.169 pd=1.82 as=0.08775 ps=0.92 w=0.65 l=0.15
X648 a_7513_2954# a_6889_2588# a_7405_2588# VDPWR sky130_fd_pr__pfet_01v8_hvt ad=0.1155 pd=0.97 as=0.07245 ps=0.765 w=0.42 l=0.15
X649 a_12989_206# digital_0._114_.Q a_12903_206# VGND sky130_fd_pr__nfet_01v8 ad=0.0567 pd=0.69 as=0.1176 ps=1.4 w=0.42 l=0.15
X650 a_12959_654# a_12741_412# VGND VGND sky130_fd_pr__nfet_01v8 ad=0.0999 pd=0.985 as=0.1346 ps=1.15 w=0.64 l=0.15
X651 digital_0._063_.B digital_0._112_.Q VGND VGND sky130_fd_pr__nfet_01v8 ad=0.08775 pd=0.92 as=0.10725 ps=0.98 w=0.65 l=0.15
X652 VDPWR digital_0.load_slew15.X digital_0._119_.RESET_B VDPWR sky130_fd_pr__pfet_01v8_hvt ad=0.26 pd=2.52 as=0.135 ps=1.27 w=1 l=0.15
X653 VGND a_11388_956# digital_0.clkload0.A VGND sky130_fd_pr__nfet_01v8 ad=0.05775 pd=0.695 as=0.0588 ps=0.7 w=0.42 l=0.15
X654 a_12754_2588# a_11839_2588# a_12407_2830# VGND sky130_fd_pr__special_nfet_01v8 ad=0.0711 pd=0.755 as=0.0999 ps=0.985 w=0.36 l=0.15
X655 a_4571_962# a_4405_962# VGND VGND sky130_fd_pr__nfet_01v8 ad=0.1092 pd=1.36 as=0.0567 ps=0.69 w=0.42 l=0.15
X656 VDPWR a_7593_2348# digital_0._108_.Q VDPWR sky130_fd_pr__pfet_01v8_hvt ad=0.26 pd=2.52 as=0.135 ps=1.27 w=1 l=0.15
X657 VGND a_4610_386# a_4568_412# VGND sky130_fd_pr__nfet_01v8 ad=0.1092 pd=1.36 as=0.0441 ps=0.63 w=0.42 l=0.15
X658 VGND VDPWR VGND VGND sky130_fd_pr__nfet_01v8 ad=0.143 pd=1.62 as=0 ps=0 w=0.55 l=0.59
X659 VGND a_14624_386# digital_0.input3.X VGND sky130_fd_pr__nfet_01v8 ad=0.1856 pd=1.26 as=0.2079 ps=1.83 w=0.42 l=0.15
X660 a_14247_3106# a_14029_3510# VDPWR VDPWR sky130_fd_pr__pfet_01v8_hvt ad=0.12915 pd=1.185 as=0.2184 ps=2.2 w=0.84 l=0.15
X661 digital_0.output7.A a_14769_3436# VDPWR VDPWR sky130_fd_pr__pfet_01v8_hvt ad=0.135 pd=1.27 as=0.3012 ps=2.66 w=1 l=0.15
X662 VGND a_7593_2348# a_7527_2422# VGND sky130_fd_pr__nfet_01v8 ad=0.12495 pd=1.015 as=0.0669 ps=0.75 w=0.42 l=0.15
X663 VGND a_11273_3436# a_11207_3510# VGND sky130_fd_pr__nfet_01v8 ad=0.12495 pd=1.015 as=0.0669 ps=0.75 w=0.42 l=0.15
X664 a_7115_2410# a_7071_2018# a_6949_2422# VGND sky130_fd_pr__nfet_01v8 ad=0.0441 pd=0.63 as=0.1401 ps=1.1 w=0.42 l=0.15
X665 a_9564_930# a_9690_1194# VDPWR VDPWR sky130_fd_pr__pfet_01v8_hvt ad=0.2173 pd=2.17 as=0.2726 ps=1.61 w=0.82 l=0.25
X666 LELO_GR01_0.x7.x6<3>.G LELO_GR01_0.x7.x18.D LELO_GR01_0.x7.xd1<4>.A VGND sky130_fd_pr__nfet_01v8_lvt ad=0.5088 pd=2.98 as=0.3168 ps=1.62 w=0.96 l=0.94
X667 a_10533_3510# a_10183_3138# a_10438_3498# VDPWR sky130_fd_pr__pfet_01v8_hvt ad=0.07245 pd=0.765 as=0.0651 ps=0.73 w=0.42 l=0.15
X668 VDPWR VGND VDPWR VDPWR sky130_fd_pr__pfet_01v8_hvt ad=0.2262 pd=2.26 as=0 ps=0 w=0.87 l=0.59
X669 a_20372_9699# a_22292_9915# VGND sky130_fd_pr__res_high_po w=0.36 l=7.36
X670 LELO_GR01_0.x7.x11.P a_20754_14644# VGND sky130_fd_pr__res_high_po w=0.36 l=7.36
X671 VDPWR a_4425_2730# a_4386_2856# VDPWR sky130_fd_pr__pfet_01v8_hvt ad=0.0864 pd=0.91 as=0.1664 ps=1.8 w=0.64 l=0.15
X672 a_6719_234# a_6684_0# a_6397_n158# VGND sky130_fd_pr__nfet_01v8 ad=0.06405 pd=0.725 as=0.1092 ps=1.36 w=0.42 l=0.15
X673 a_7099_956# a_7155_930# digital_0._115_.D VDPWR sky130_fd_pr__pfet_01v8_hvt ad=0.26 pd=2.52 as=0.135 ps=1.27 w=1 l=0.15
X674 a_14578_1322# digital_0._104_.D VDPWR VDPWR sky130_fd_pr__pfet_01v8_hvt ad=0.0651 pd=0.73 as=0.1092 ps=1.36 w=0.42 l=0.15
X675 a_14323_962# a_14157_962# VDPWR VDPWR sky130_fd_pr__pfet_01v8_hvt ad=0.1664 pd=1.8 as=0.0864 ps=0.91 w=0.64 l=0.15
X676 a_7214_n524# digital_0._115_.Q a_7356_n676# VGND sky130_fd_pr__nfet_01v8 ad=0.09975 pd=0.895 as=0.0693 ps=0.75 w=0.42 l=0.15
X677 a_14594_3510# a_13513_3138# a_14247_3106# VDPWR sky130_fd_pr__pfet_01v8_hvt ad=0.0588 pd=0.7 as=0.12915 ps=1.185 w=0.42 l=0.15
X678 a_5855_564# a_5951_386# VGND VGND sky130_fd_pr__nfet_01v8 ad=0.1092 pd=1.36 as=0.097 ps=0.975 w=0.42 l=0.5
X679 a_7155_930# digital_0._060_.A_N a_7826_956# VDPWR sky130_fd_pr__pfet_01v8_hvt ad=0.135 pd=1.27 as=0.26 ps=2.52 w=1 l=0.15
X680 VDPWR VGND VDPWR VDPWR sky130_fd_pr__pfet_01v8_hvt ad=0.2262 pd=2.26 as=0 ps=0 w=0.87 l=0.59
X681 a_9930_930# digital_0.load_slew17.X VDPWR VDPWR sky130_fd_pr__pfet_01v8_hvt ad=0.27 pd=2.54 as=0.19265 ps=1.415 w=1 l=0.15
X682 VGND digital_0.clkload0.A a_9465_n126# VGND sky130_fd_pr__nfet_01v8 ad=0.0567 pd=0.69 as=0.1092 ps=1.36 w=0.42 l=0.15
X683 VGND digital_0.load_slew15.X digital_0._116_.SET_B VGND sky130_fd_pr__nfet_01v8 ad=0.169 pd=1.82 as=0.08775 ps=0.92 w=0.65 l=0.15
X684 digital_0.clkload0.A a_11388_956# VGND VGND sky130_fd_pr__nfet_01v8 ad=0.0588 pd=0.7 as=0.0588 ps=0.7 w=0.42 l=0.15
X685 a_9980_6824# a_10196_4904# VGND sky130_fd_pr__res_high_po w=0.36 l=7.36
X686 a_13003_1500# a_12959_1742# a_12837_1500# VGND sky130_fd_pr__nfet_01v8 ad=0.0441 pd=0.63 as=0.1401 ps=1.1 w=0.42 l=0.15
X687 LELO_GR01_0.x7.x29.N a_22254_11144# VGND sky130_fd_pr__res_high_po w=0.36 l=7.36
X688 a_10641_3132# a_10017_3138# a_10533_3510# VDPWR sky130_fd_pr__pfet_01v8_hvt ad=0.1155 pd=0.97 as=0.07245 ps=0.765 w=0.42 l=0.15
X689 a_4730_1652# digital_0.hold22.X a_4872_1827# VDPWR sky130_fd_pr__pfet_01v8_hvt ad=0.1932 pd=1.34 as=0.07665 ps=0.785 w=0.42 l=0.15
X690 VGND LELO_GR01_0.x8.x1.x5.x9<2>.G LELO_GR01_0.x8.x1.x5.IBN VGND sky130_fd_pr__nfet_01v8_lvt ad=0.5088 pd=2.98 as=0.3168 ps=1.62 w=0.96 l=0.94
X691 a_5218_778# a_4530_626# a_4610_386# VDPWR sky130_fd_pr__pfet_01v8_hvt ad=0.12495 pd=1.175 as=0.0567 ps=0.69 w=0.42 l=0.15
X692 VDPWR a_4438_386# a_4530_626# VDPWR sky130_fd_pr__pfet_01v8_hvt ad=0.0864 pd=0.91 as=0.1664 ps=1.8 w=0.64 l=0.15
X693 a_11388_956# digital_0.clkbuf_1_1__f_clk.A VDPWR VDPWR sky130_fd_pr__pfet_01v8_hvt ad=0.14 pd=1.28 as=0.265 ps=2.53 w=1 l=0.15
X694 a_15331_564# a_15427_386# VDPWR VDPWR sky130_fd_pr__pfet_01v8_hvt ad=0.1092 pd=1.36 as=0.14075 ps=1.325 w=0.42 l=0.5
X695 a_9150_412# digital_0._114_.D VGND VGND sky130_fd_pr__nfet_01v8 ad=0.066 pd=0.745 as=0.2205 ps=1.89 w=0.42 l=0.15
X696 a_5014_412# a_4746_412# VGND VGND sky130_fd_pr__nfet_01v8 ad=0.06705 pd=0.75 as=0.0882 ps=0.84 w=0.42 l=0.15
X697 VGND a_3814_386# digital_0._116_.Q VGND sky130_fd_pr__nfet_01v8 ad=0.08775 pd=0.92 as=0.08775 ps=0.92 w=0.65 l=0.15
X698 a_15662_2044# a_15445_2044# VDPWR VDPWR sky130_fd_pr__pfet_01v8_hvt ad=0.2173 pd=2.17 as=0.19265 ps=1.415 w=0.82 l=0.25
X699 a_10751_3106# a_10533_3510# VGND VGND sky130_fd_pr__nfet_01v8 ad=0.0999 pd=0.985 as=0.1346 ps=1.15 w=0.64 l=0.15
X700 a_4019_2050# a_3853_2050# VDPWR VDPWR sky130_fd_pr__pfet_01v8_hvt ad=0.1664 pd=1.8 as=0.0864 ps=0.91 w=0.64 l=0.15
X701 VGND VDPWR VGND VGND sky130_fd_pr__nfet_01v8 ad=0.143 pd=1.62 as=0 ps=0 w=0.55 l=0.59
X702 a_11107_2562# digital_0._069_.A VDPWR VDPWR sky130_fd_pr__pfet_01v8_hvt ad=0.0567 pd=0.69 as=0.16655 ps=1.39 w=0.42 l=0.15
X703 a_25510_16564# a_25726_14644# VGND sky130_fd_pr__res_high_po w=0.36 l=7.36
X704 a_10066_n524# digital_0._114_.Q a_10208_n676# VGND sky130_fd_pr__nfet_01v8 ad=0.09975 pd=0.895 as=0.0693 ps=0.75 w=0.42 l=0.15
X705 a_9919_412# a_8729_412# a_9810_412# VGND sky130_fd_pr__special_nfet_01v8 ad=0.0669 pd=0.75 as=0.0711 ps=0.755 w=0.36 l=0.15
X706 LELO_GR01_0.x8.x5.XA4.MP1.S LELO_GR01_0.x8.x5.XA6.A LELO_GR01_0.x8.x8.D LELO_GR01_0.x8.x8.D sky130_fd_pr__pfet_01v8 ad=0.288 pd=1.54 as=0.468 ps=2.84 w=0.9 l=0.16
X707 a_4311_3106# a_4093_3510# VDPWR VDPWR sky130_fd_pr__pfet_01v8_hvt ad=0.12915 pd=1.185 as=0.2184 ps=2.2 w=0.84 l=0.15
X708 a_4872_1827# digital_0.hold28.A VDPWR VDPWR sky130_fd_pr__pfet_01v8_hvt ad=0.07665 pd=0.785 as=0.15835 ps=1.395 w=0.42 l=0.15
X709 a_15537_n132# digital_0.input3.X digital_0._113_.RESET_B VDPWR sky130_fd_pr__pfet_01v8_hvt ad=0.26 pd=2.52 as=0.135 ps=1.27 w=1 l=0.15
X710 VGND LELO_GR01_0.x8.x1.x5.x9<2>.G LELO_GR01_0.x8.x1.x5.x9<2>.G VGND sky130_fd_pr__nfet_01v8_lvt ad=0.5088 pd=2.98 as=0.3168 ps=1.62 w=0.96 l=0.94
X711 a_4292_0# a_4570_n16# a_4526_n132# VDPWR sky130_fd_pr__pfet_01v8_hvt ad=0.0588 pd=0.7 as=0.0567 ps=0.69 w=0.42 l=0.15
X712 VGND digital_0._060_.A_N a_7155_930# VGND sky130_fd_pr__nfet_01v8 ad=0.08775 pd=0.92 as=0.08775 ps=0.92 w=0.65 l=0.15
X713 VDPWR a_5422_n702# a_5182_n518# VDPWR sky130_fd_pr__pfet_01v8_hvt ad=0.19265 pd=1.415 as=0.2173 ps=2.17 w=0.82 l=0.25
X714 a_7001_110# digital_0.clkload0.A VDPWR VDPWR sky130_fd_pr__pfet_01v8_hvt ad=0.1664 pd=1.8 as=0.0864 ps=0.91 w=0.64 l=0.15
X715 a_10082_11154# a_10298_9234# VGND sky130_fd_pr__res_high_po w=0.36 l=7.36
X716 a_26134_13064# a_26350_11144# VGND sky130_fd_pr__res_high_po w=0.36 l=7.36
X717 digital_0.clkload0.A a_11388_956# VDPWR VDPWR sky130_fd_pr__pfet_01v8_hvt ad=0.14 pd=1.28 as=0.14 ps=1.28 w=1 l=0.15
X718 a_10089_2044# digital_0._111_.RESET_B VDPWR VDPWR sky130_fd_pr__pfet_01v8_hvt ad=0.1092 pd=1.36 as=0.07035 ps=0.755 w=0.42 l=0.15
X719 VGND VDPWR VGND VGND sky130_fd_pr__nfet_01v8 ad=0.143 pd=1.62 as=0 ps=0 w=0.55 l=0.59
X720 VGND VDPWR VGND VGND sky130_fd_pr__nfet_01v8 ad=0.143 pd=1.62 as=0 ps=0 w=0.55 l=0.59
X721 VDPWR a_15413_1260# a_15400_956# VDPWR sky130_fd_pr__pfet_01v8_hvt ad=0.0819 pd=0.81 as=0.0567 ps=0.69 w=0.42 l=0.15
X722 digital_0._119_.RESET_B digital_0.load_slew15.X VGND VGND sky130_fd_pr__nfet_01v8 ad=0.08775 pd=0.92 as=0.169 ps=1.82 w=0.65 l=0.15
X723 VGND a_8996_1500# digital_0.clkbuf_1_1__f_clk.A VGND sky130_fd_pr__nfet_01v8 ad=0.1113 pd=1.37 as=0.0588 ps=0.7 w=0.42 l=0.15
X724 LELO_GR01_0.x7.x1.x5.x6.N LELO_GR01_0.x7.x1.x5.x8.G LELO_GR01_0.x7.x1.x5.x9<2>.G LELO_GR01_0.x7.x1.x5.x6.N sky130_fd_pr__pfet_01v8_lvt ad=0.5088 pd=2.98 as=0.3168 ps=1.62 w=0.96 l=0.94
X725 a_11397_1750# digital_0._112_.Q digital_0._063_.B VDPWR sky130_fd_pr__pfet_01v8_hvt ad=0.36 pd=2.72 as=0.135 ps=1.27 w=1 l=0.15
X726 VDPWR a_6315_1474# digital_0.clkbuf_1_0__f_clk.X VDPWR sky130_fd_pr__pfet_01v8_hvt ad=0.14 pd=1.28 as=0.14 ps=1.28 w=1 l=0.15
X727 digital_0._104_.RESET_B digital_0.load_slew17.A VGND VGND sky130_fd_pr__nfet_01v8 ad=0.08775 pd=0.92 as=0.169 ps=1.82 w=0.65 l=0.15
X728 a_11361_n702# digital_0.output11.A VDPWR VDPWR sky130_fd_pr__pfet_01v8_hvt ad=0.1092 pd=1.36 as=0.0567 ps=0.69 w=0.42 l=0.15
X729 VDPWR a_10546_2422# a_10721_2348# VDPWR sky130_fd_pr__pfet_01v8_hvt ad=0.1134 pd=1.38 as=0.0567 ps=0.69 w=0.42 l=0.15
X730 VDPWR a_13978_3650# a_13738_3834# VDPWR sky130_fd_pr__pfet_01v8_hvt ad=0.19265 pd=1.415 as=0.2173 ps=2.17 w=0.82 l=0.25
X731 VGND a_15331_564# digital_0.hold23.X VGND sky130_fd_pr__nfet_01v8 ad=0.097 pd=0.975 as=0.169 ps=1.82 w=0.65 l=0.15
X732 a_8895_412# a_8729_412# VGND VGND sky130_fd_pr__nfet_01v8 ad=0.1092 pd=1.36 as=0.0567 ps=0.69 w=0.42 l=0.15
X733 a_4658_3510# a_3577_3138# a_4311_3106# VDPWR sky130_fd_pr__pfet_01v8_hvt ad=0.0588 pd=0.7 as=0.12915 ps=1.185 w=0.42 l=0.15
X734 VDPWR VGND VDPWR VDPWR sky130_fd_pr__pfet_01v8_hvt ad=0.2262 pd=2.26 as=0 ps=0 w=0.87 l=0.59
X735 LELO_GR01_0.PWRUP_1V8 JNWTR_ORX1_CV_0.XA2.A VDPWR VDPWR sky130_fd_pr__pfet_01v8 ad=0.468 pd=2.84 as=0.468 ps=2.84 w=0.9 l=0.16
X736 a_8252_6824# a_8468_4904# VGND sky130_fd_pr__res_high_po w=0.36 l=7.36
X737 a_7181_3926# digital_0._069_.A VDPWR VDPWR sky130_fd_pr__pfet_01v8_hvt ad=0.28 pd=2.56 as=0.135 ps=1.27 w=1 l=0.15
X738 a_7786_412# a_6871_412# a_7439_654# VGND sky130_fd_pr__special_nfet_01v8 ad=0.0711 pd=0.755 as=0.0999 ps=0.985 w=0.36 l=0.15
X739 VDPWR digital_0._115_.Q a_7099_956# VDPWR sky130_fd_pr__pfet_01v8_hvt ad=0.135 pd=1.27 as=0.135 ps=1.27 w=1 l=0.15
X740 a_9981_2422# a_9631_2050# a_9886_2410# VDPWR sky130_fd_pr__pfet_01v8_hvt ad=0.07245 pd=0.765 as=0.0651 ps=0.73 w=0.42 l=0.15
X741 a_4668_778# a_4438_386# a_3982_386# VDPWR sky130_fd_pr__pfet_01v8_hvt ad=0.0441 pd=0.63 as=0.0819 ps=0.81 w=0.42 l=0.15
X742 VDPWR VDPWR VDPWR VDPWR sky130_fd_pr__pfet_01v8 ad=0.468 pd=2.84 as=0 ps=0 w=0.9 l=0.16
X743 digital_0.output9.A a_15413_1260# VDPWR VDPWR sky130_fd_pr__pfet_01v8_hvt ad=0.135 pd=1.27 as=0.3012 ps=2.66 w=1 l=0.15
X744 a_15268_1474# a_15394_1658# VDPWR VDPWR sky130_fd_pr__pfet_01v8_hvt ad=0.2173 pd=2.17 as=0.2726 ps=1.61 w=0.82 l=0.25
X745 digital_0._109_.RESET_B digital_0.load_slew15.A a_7717_3926# VDPWR sky130_fd_pr__pfet_01v8_hvt ad=0.135 pd=1.27 as=0.135 ps=1.27 w=1 l=0.15
X746 VDPWR a_5215_3676# a_5321_3676# VDPWR sky130_fd_pr__pfet_01v8_hvt ad=0.14075 pd=1.325 as=0.1092 ps=1.36 w=0.42 l=0.5
X747 a_7088_n132# a_6962_n16# a_6684_0# VGND sky130_fd_pr__special_nfet_01v8 ad=0.0999 pd=0.985 as=0.0711 ps=0.755 w=0.36 l=0.15
X748 VDPWR VGND VDPWR VDPWR sky130_fd_pr__pfet_01v8_hvt ad=0.2262 pd=2.26 as=0 ps=0 w=0.87 l=0.59
X749 LELO_GR01_0.x7.x6<3>.G LELO_GR01_0.x7.x18.D LELO_GR01_0.x7.xd1<4>.A VGND sky130_fd_pr__nfet_01v8_lvt ad=0.5088 pd=2.98 as=0.3168 ps=1.62 w=0.96 l=0.94
X750 a_15225_n702# digital_0.output10.A VGND VGND sky130_fd_pr__nfet_01v8 ad=0.1092 pd=1.36 as=0.0567 ps=0.69 w=0.42 l=0.15
X751 a_8996_1500# clk VDPWR VDPWR sky130_fd_pr__pfet_01v8_hvt ad=0.14 pd=1.28 as=0.14 ps=1.28 w=1 l=0.15
X752 a_5785_1750# digital_0.load_slew17.X digital_0._115_.RESET_B VDPWR sky130_fd_pr__pfet_01v8_hvt ad=0.26 pd=2.52 as=0.135 ps=1.27 w=1 l=0.15
X753 VDPWR VGND VDPWR VDPWR sky130_fd_pr__pfet_01v8_hvt ad=0.2262 pd=2.26 as=0 ps=0 w=0.87 l=0.59
X754 VDPWR a_15238_1334# a_15413_1260# VDPWR sky130_fd_pr__pfet_01v8_hvt ad=0.1134 pd=1.38 as=0.0567 ps=0.69 w=0.42 l=0.15
X755 a_6407_1188# a_6503_930# VDPWR VDPWR sky130_fd_pr__pfet_01v8_hvt ad=0.1092 pd=1.36 as=0.14075 ps=1.325 w=0.42 l=0.5
X756 VDPWR a_11361_n702# a_11103_n702# VDPWR sky130_fd_pr__pfet_01v8_hvt ad=0.0567 pd=0.69 as=0.1092 ps=1.36 w=0.42 l=0.5
X757 VGND digital_0._116_.D a_5218_778# VGND sky130_fd_pr__nfet_01v8 ad=0.1664 pd=1.8 as=0.0935 ps=0.965 w=0.64 l=0.15
X758 VGND digital_0._111_.RESET_B a_10243_2410# VGND sky130_fd_pr__nfet_01v8 ad=0.1346 pd=1.15 as=0.0441 ps=0.63 w=0.42 l=0.15
X759 VDPWR digital_0.output8.A a_12501_3676# VDPWR sky130_fd_pr__pfet_01v8_hvt ad=0.19265 pd=1.415 as=0.27 ps=2.54 w=1 l=0.15
X760 VGND a_12626_n676# a_12737_n676# VGND sky130_fd_pr__nfet_01v8 ad=0.1856 pd=1.26 as=0.17225 ps=1.83 w=0.65 l=0.25
X761 a_15347_1334# a_14157_962# a_15238_1334# VGND sky130_fd_pr__special_nfet_01v8 ad=0.0669 pd=0.75 as=0.0711 ps=0.755 w=0.36 l=0.15
X762 digital_0._110_.Q a_12929_2562# VDPWR VDPWR sky130_fd_pr__pfet_01v8_hvt ad=0.135 pd=1.27 as=0.3012 ps=2.66 w=1 l=0.15
X763 a_7310_2588# digital_0._109_.D VGND VGND sky130_fd_pr__nfet_01v8 ad=0.066 pd=0.745 as=0.2205 ps=1.89 w=0.42 l=0.15
X764 VDPWR a_11388_956# digital_0.clkload0.A VDPWR sky130_fd_pr__pfet_01v8_hvt ad=0.14 pd=1.28 as=0.14 ps=1.28 w=1 l=0.15
X765 VDPWR digital_0.input1.X a_9465_2050# VDPWR sky130_fd_pr__pfet_01v8_hvt ad=0.0864 pd=0.91 as=0.1664 ps=1.8 w=0.64 l=0.15
X766 VDPWR a_6687_n676# a_6793_n676# VDPWR sky130_fd_pr__pfet_01v8_hvt ad=0.14075 pd=1.325 as=0.1092 ps=1.36 w=0.42 l=0.5
X767 VDPWR VGND VDPWR VDPWR sky130_fd_pr__pfet_01v8_hvt ad=0.2262 pd=2.26 as=0 ps=0 w=0.87 l=0.59
X768 a_12285_2588# a_11839_2588# a_12189_2588# VGND sky130_fd_pr__special_nfet_01v8 ad=0.1401 pd=1.1 as=0.0594 ps=0.69 w=0.36 l=0.15
X769 VGND digital_0._116_.Q digital_0._108_.RESET_B VGND sky130_fd_pr__nfet_01v8 ad=0.182 pd=1.86 as=0.08775 ps=0.92 w=0.65 l=0.15
X770 a_7055_2588# a_6889_2588# VGND VGND sky130_fd_pr__nfet_01v8 ad=0.1092 pd=1.36 as=0.0567 ps=0.69 w=0.42 l=0.15
X771 VDPWR VGND VDPWR VDPWR sky130_fd_pr__pfet_01v8_hvt ad=0.2262 pd=2.26 as=0 ps=0 w=0.87 l=0.59
X772 a_11673_n132# digital_0._113_.Q VDPWR VDPWR sky130_fd_pr__pfet_01v8_hvt ad=0.135 pd=1.27 as=0.135 ps=1.27 w=1 l=0.15
X773 digital_0.clkbuf_1_0__f_clk.X a_6315_1474# VDPWR VDPWR sky130_fd_pr__pfet_01v8_hvt ad=0.14 pd=1.28 as=0.14 ps=1.28 w=1 l=0.15
X774 a_13108_2588# digital_0._110_.RESET_B VGND VGND sky130_fd_pr__nfet_01v8 ad=0.06405 pd=0.725 as=0.12495 ps=1.015 w=0.42 l=0.15
X775 a_4609_110# digital_0.clkbuf_1_0__f_clk.X VDPWR VDPWR sky130_fd_pr__pfet_01v8_hvt ad=0.1664 pd=1.8 as=0.0864 ps=0.91 w=0.64 l=0.15
X776 a_14673_3650# digital_0.output7.A VGND VGND sky130_fd_pr__nfet_01v8 ad=0.1092 pd=1.36 as=0.0567 ps=0.69 w=0.42 l=0.15
X777 a_5096_2044# a_4019_2050# a_4934_2422# VDPWR sky130_fd_pr__pfet_01v8_hvt ad=0.0567 pd=0.69 as=0.0588 ps=0.7 w=0.42 l=0.15
X778 VGND VDPWR VGND VGND sky130_fd_pr__nfet_01v8 ad=0.143 pd=1.62 as=0 ps=0 w=0.55 l=0.59
X779 VGND a_9985_386# digital_0._114_.Q VGND sky130_fd_pr__nfet_01v8 ad=0.169 pd=1.82 as=0.08775 ps=0.92 w=0.65 l=0.15
X780 a_10900_234# digital_0._106_.RESET_B VGND VGND sky130_fd_pr__nfet_01v8 ad=0.06405 pd=0.725 as=0.12495 ps=1.015 w=0.42 l=0.15
X781 VGND VDPWR VGND VGND sky130_fd_pr__nfet_01v8 ad=0.143 pd=1.62 as=0 ps=0 w=0.55 l=0.59
X782 a_17736_16564# a_17952_14644# VGND sky130_fd_pr__res_high_po w=0.36 l=7.36
X783 VDPWR a_10721_172# digital_0.output11.A VDPWR sky130_fd_pr__pfet_01v8_hvt ad=0.26 pd=2.52 as=0.135 ps=1.27 w=1 l=0.15
X784 VGND VDPWR VGND VGND sky130_fd_pr__nfet_01v8 ad=0.143 pd=1.62 as=0 ps=0 w=0.55 l=0.59
X785 VDPWR a_14594_3510# a_14769_3436# VDPWR sky130_fd_pr__pfet_01v8_hvt ad=0.1134 pd=1.38 as=0.0567 ps=0.69 w=0.42 l=0.15
X786 a_14769_1334# a_14323_962# a_14673_1334# VGND sky130_fd_pr__special_nfet_01v8 ad=0.1401 pd=1.1 as=0.0594 ps=0.69 w=0.36 l=0.15
X787 VGND a_5661_1260# a_5595_1334# VGND sky130_fd_pr__nfet_01v8 ad=0.12495 pd=1.015 as=0.0669 ps=0.75 w=0.42 l=0.15
X788 VGND VDPWR VGND VGND sky130_fd_pr__nfet_01v8 ad=0.143 pd=1.62 as=0 ps=0 w=0.55 l=0.59
X789 a_13978_3650# digital_0.output7.A VDPWR VDPWR sky130_fd_pr__pfet_01v8_hvt ad=0.27 pd=2.54 as=0.19265 ps=1.415 w=1 l=0.15
X790 digital_0.clkbuf_1_1__f_clk.A a_8996_1500# VGND VGND sky130_fd_pr__nfet_01v8 ad=0.0588 pd=0.7 as=0.0588 ps=0.7 w=0.42 l=0.15
X791 VGND a_14319_3828# digital_0.hold24.X VGND sky130_fd_pr__nfet_01v8 ad=0.097 pd=0.975 as=0.169 ps=1.82 w=0.65 l=0.15
X792 VGND digital_0.hold18.X a_5974_n676# VGND sky130_fd_pr__nfet_01v8 ad=0.1105 pd=0.99 as=0.1625 ps=1.15 w=0.65 l=0.15
X793 a_7593_2348# a_7418_2422# a_7772_2410# VGND sky130_fd_pr__nfet_01v8 ad=0.1092 pd=1.36 as=0.06405 ps=0.725 w=0.42 l=0.15
X794 digital_0._116_.Q a_3814_386# VDPWR VDPWR sky130_fd_pr__pfet_01v8_hvt ad=0.135 pd=1.27 as=0.26 ps=2.52 w=1 l=0.15
X795 a_11273_3436# a_11098_3510# a_11452_3498# VGND sky130_fd_pr__nfet_01v8 ad=0.1092 pd=1.36 as=0.06405 ps=0.725 w=0.42 l=0.15
X796 a_5183_1322# a_5139_930# a_5017_1334# VGND sky130_fd_pr__nfet_01v8 ad=0.0441 pd=0.63 as=0.1401 ps=1.1 w=0.42 l=0.15
X797 a_12106_2404# digital_0._069_.A a_12034_2404# VGND sky130_fd_pr__nfet_01v8 ad=0.05355 pd=0.675 as=0.0441 ps=0.63 w=0.42 l=0.15
X798 VDPWR VGND VDPWR VDPWR sky130_fd_pr__pfet_01v8_hvt ad=0.2262 pd=2.26 as=0 ps=0 w=0.87 l=0.59
X799 digital_0._109_.D digital_0._069_.B VGND VGND sky130_fd_pr__nfet_01v8 ad=0.08775 pd=0.92 as=0.169 ps=1.82 w=0.65 l=0.15
X800 VGND digital_0._063_.A digital_0._112_.D VGND sky130_fd_pr__nfet_01v8 ad=0.08775 pd=0.92 as=0.08775 ps=0.92 w=0.65 l=0.15
X801 a_4093_3510# a_3577_3138# a_3998_3498# VGND sky130_fd_pr__special_nfet_01v8 ad=0.0594 pd=0.69 as=0.066 ps=0.745 w=0.36 l=0.15
X802 digital_0.output13.A a_5661_1260# VGND VGND sky130_fd_pr__nfet_01v8 ad=0.08775 pd=0.92 as=0.2087 ps=2.02 w=0.65 l=0.15
X803 a_21402_16564# a_21186_14644# VGND sky130_fd_pr__res_high_po w=0.36 l=7.36
X804 VGND digital_0.load_slew15.X digital_0._117_.RESET_B VGND sky130_fd_pr__nfet_01v8 ad=0.169 pd=1.82 as=0.08775 ps=0.92 w=0.65 l=0.15
X805 a_6918_n132# a_6397_n158# VDPWR VDPWR sky130_fd_pr__pfet_01v8_hvt ad=0.0567 pd=0.69 as=0.0819 ps=0.81 w=0.42 l=0.15
X806 VGND a_14673_3650# a_14415_3650# VGND sky130_fd_pr__nfet_01v8 ad=0.0567 pd=0.69 as=0.1092 ps=1.36 w=0.42 l=0.5
X807 a_14990_386# JNWTR_IVX1_CV_0.Y VGND VGND sky130_fd_pr__nfet_01v8 ad=0.1134 pd=1.38 as=0.1228 ps=1.065 w=0.42 l=0.15
X808 VGND VDPWR VGND VGND sky130_fd_pr__nfet_01v8 ad=0.143 pd=1.62 as=0 ps=0 w=0.55 l=0.59
X809 a_12849_1866# digital_0._113_.RESET_B VDPWR VDPWR sky130_fd_pr__pfet_01v8_hvt ad=0.1092 pd=1.36 as=0.07035 ps=0.755 w=0.42 l=0.15
X810 a_11949_3132# digital_0._067_.B digital_0._110_.D VDPWR sky130_fd_pr__pfet_01v8_hvt ad=0.26 pd=2.52 as=0.135 ps=1.27 w=1 l=0.15
X811 VDPWR VGND VDPWR VDPWR sky130_fd_pr__pfet_01v8_hvt ad=0.2262 pd=2.26 as=0 ps=0 w=0.87 l=0.59
X812 LELO_GR01_0.x7.x15.I2 LELO_GR01_0.x7.xd1<4>.A VDPWR VDPWR sky130_fd_pr__pfet_01v8_lvt ad=0.3168 pd=1.62 as=0.5088 ps=2.98 w=0.96 l=0.94
X813 a_6687_n676# a_6451_n676# VDPWR VDPWR sky130_fd_pr__pfet_01v8_hvt ad=0.1092 pd=1.36 as=0.0567 ps=0.69 w=0.42 l=0.5
X814 VDPWR VGND VDPWR VDPWR sky130_fd_pr__pfet_01v8_hvt ad=0.2262 pd=2.26 as=0 ps=0 w=0.87 l=0.59
X815 a_4586_6824# a_4370_4904# VGND sky130_fd_pr__res_high_po w=0.36 l=7.36
X816 VDPWR VGND VDPWR VDPWR sky130_fd_pr__pfet_01v8_hvt ad=0.2262 pd=2.26 as=0 ps=0 w=0.87 l=0.59
X817 a_4327_234# a_4292_0# a_4005_n158# VGND sky130_fd_pr__nfet_01v8 ad=0.06405 pd=0.725 as=0.1092 ps=1.36 w=0.42 l=0.15
X818 a_4828_412# a_4610_386# a_4746_412# VGND sky130_fd_pr__nfet_01v8 ad=0.0441 pd=0.63 as=0.1092 ps=1.36 w=0.42 l=0.15
X819 VGND a_5109_2348# digital_0.output6.A VGND sky130_fd_pr__nfet_01v8 ad=0.169 pd=1.82 as=0.08775 ps=0.92 w=0.65 l=0.15
X820 a_4726_2954# a_4512_2954# VDPWR VDPWR sky130_fd_pr__pfet_01v8_hvt ad=0.1155 pd=0.97 as=0.07035 ps=0.755 w=0.42 l=0.15
X821 LELO_GR01_0.x7.x15.I2 LELO_GR01_0.x7.xd1<4>.A VDPWR VDPWR sky130_fd_pr__pfet_01v8_lvt ad=0.3168 pd=1.62 as=0.5088 ps=2.98 w=0.96 l=0.94
X822 VDPWR a_4587_2018# a_4477_2044# VDPWR sky130_fd_pr__pfet_01v8_hvt ad=0.07035 pd=0.755 as=0.1155 ps=0.97 w=0.42 l=0.15
X823 a_5012_3498# digital_0._117_.RESET_B VGND VGND sky130_fd_pr__nfet_01v8 ad=0.06405 pd=0.725 as=0.12495 ps=1.015 w=0.42 l=0.15
X824 a_14319_3828# a_14415_3650# VDPWR VDPWR sky130_fd_pr__pfet_01v8_hvt ad=0.1092 pd=1.36 as=0.14075 ps=1.325 w=0.42 l=0.5
X825 VDPWR a_13306_1500# a_13481_1474# VDPWR sky130_fd_pr__pfet_01v8_hvt ad=0.1134 pd=1.38 as=0.0567 ps=0.69 w=0.42 l=0.15
X826 digital_0._115_.D a_7155_930# a_7099_956# VDPWR sky130_fd_pr__pfet_01v8_hvt ad=0.135 pd=1.27 as=0.28 ps=2.56 w=1 l=0.15
X827 VGND LELO_GR01_0.x7.xd1<4>.A LELO_GR01_0.x7.x18.D VGND sky130_fd_pr__nfet_01v8_lvt ad=0.5088 pd=2.98 as=0.3168 ps=1.62 w=0.96 l=0.94
X828 VGND a_8996_1500# digital_0.clkbuf_1_1__f_clk.A VGND sky130_fd_pr__nfet_01v8 ad=0.0588 pd=0.7 as=0.0588 ps=0.7 w=0.42 l=0.15
X829 a_25702_13064# a_25918_11144# VGND sky130_fd_pr__res_high_po w=0.36 l=7.36
X830 a_7126_412# digital_0._115_.D VGND VGND sky130_fd_pr__nfet_01v8 ad=0.066 pd=0.745 as=0.2205 ps=1.89 w=0.42 l=0.15
X831 VDPWR VGND VDPWR VDPWR sky130_fd_pr__pfet_01v8_hvt ad=0.2262 pd=2.26 as=0 ps=0 w=0.87 l=0.59
X832 VDPWR digital_0.clkbuf_1_1__f_clk.A a_6315_1474# VDPWR sky130_fd_pr__pfet_01v8_hvt ad=0.14 pd=1.28 as=0.14 ps=1.28 w=1 l=0.15
X833 VGND VDPWR VGND VGND sky130_fd_pr__nfet_01v8 ad=0.143 pd=1.62 as=0 ps=0 w=0.55 l=0.59
X834 digital_0._106_.RESET_B digital_0.load_slew17.X VDPWR VDPWR sky130_fd_pr__pfet_01v8_hvt ad=0.135 pd=1.27 as=0.26 ps=2.52 w=1 l=0.15
X835 a_9353_778# a_8729_412# a_9245_412# VDPWR sky130_fd_pr__pfet_01v8_hvt ad=0.1155 pd=0.97 as=0.07245 ps=0.765 w=0.42 l=0.15
X836 VDPWR a_7439_654# a_7329_778# VDPWR sky130_fd_pr__pfet_01v8_hvt ad=0.07035 pd=0.755 as=0.1155 ps=0.97 w=0.42 l=0.15
X837 a_12646_1500# digital_0._113_.D VDPWR VDPWR sky130_fd_pr__pfet_01v8_hvt ad=0.0651 pd=0.73 as=0.1092 ps=1.36 w=0.42 l=0.15
X838 a_9507_412# a_9463_654# a_9341_412# VGND sky130_fd_pr__nfet_01v8 ad=0.0441 pd=0.63 as=0.1401 ps=1.1 w=0.42 l=0.15
X839 VGND a_11388_956# digital_0.clkload0.A VGND sky130_fd_pr__nfet_01v8 ad=0.0588 pd=0.7 as=0.0588 ps=0.7 w=0.42 l=0.15
X840 LELO_GR01_0.x7.x6<3>.G LELO_GR01_0.x7.x18.D LELO_GR01_0.x7.xd1<4>.A VGND sky130_fd_pr__nfet_01v8_lvt ad=0.5088 pd=2.98 as=0.3168 ps=1.62 w=0.96 l=0.94
X841 VGND a_3858_3650# a_3618_3834# VGND sky130_fd_pr__nfet_01v8 ad=0.1228 pd=1.065 as=0.17225 ps=1.83 w=0.65 l=0.25
X842 a_11415_3650# digital_0.hold28.A VDPWR VDPWR sky130_fd_pr__pfet_01v8_hvt ad=0.1176 pd=1.4 as=0.0693 ps=0.75 w=0.42 l=0.15
X843 a_12646_412# digital_0._112_.D VGND VGND sky130_fd_pr__nfet_01v8 ad=0.066 pd=0.745 as=0.2205 ps=1.89 w=0.42 l=0.15
X844 VDPWR VGND VDPWR VDPWR sky130_fd_pr__pfet_01v8_hvt ad=0.2262 pd=2.26 as=0 ps=0 w=0.87 l=0.59
X845 VGND VDPWR VGND VGND sky130_fd_pr__nfet_01v8 ad=0.143 pd=1.62 as=0 ps=0 w=0.55 l=0.59
X846 a_14935_1322# a_14891_930# a_14769_1334# VGND sky130_fd_pr__nfet_01v8 ad=0.0441 pd=0.63 as=0.1401 ps=1.1 w=0.42 l=0.15
X847 VDPWR a_12138_n702# a_11898_n518# VDPWR sky130_fd_pr__pfet_01v8_hvt ad=0.19265 pd=1.415 as=0.2173 ps=2.17 w=0.82 l=0.25
X848 digital_0.clkload0.A a_11388_956# VDPWR VDPWR sky130_fd_pr__pfet_01v8_hvt ad=0.14 pd=1.28 as=0.14 ps=1.28 w=1 l=0.15
X849 a_8996_1500# clk VGND VGND sky130_fd_pr__nfet_01v8 ad=0.0588 pd=0.7 as=0.1113 ps=1.37 w=0.42 l=0.15
X850 VGND VGND LELO_GR01_0.x7.x15.I1 sky130_fd_pr__pnp_05v5_W3p40L3p40
**devattr s=462400,2720
X851 a_19032_16564# a_19248_14644# VGND sky130_fd_pr__res_high_po w=0.36 l=7.36
X852 LELO_GR01_0.x8.x5.XA7.CN LELO_GR01_0.x8.x5.XA7.C VGND VGND sky130_fd_pr__nfet_01v8 ad=0.468 pd=2.84 as=0.468 ps=2.84 w=0.9 l=0.16
X853 a_4292_0# a_4609_110# a_4567_234# VGND sky130_fd_pr__special_nfet_01v8 ad=0.0711 pd=0.755 as=0.0669 ps=0.75 w=0.36 l=0.15
X854 a_22266_16564# a_22482_14644# VGND sky130_fd_pr__res_high_po w=0.36 l=7.36
X855 VGND digital_0._107_.RESET_B a_6719_234# VGND sky130_fd_pr__nfet_01v8 ad=0.12495 pd=1.015 as=0.06405 ps=0.725 w=0.42 l=0.15
X856 VDPWR digital_0.input1.X a_6705_412# VDPWR sky130_fd_pr__pfet_01v8_hvt ad=0.0864 pd=0.91 as=0.1664 ps=1.8 w=0.64 l=0.15
X857 VGND VDPWR VGND VGND sky130_fd_pr__nfet_01v8 ad=0.143 pd=1.62 as=0 ps=0 w=0.55 l=0.59
X858 a_10089_n132# a_9465_n126# a_9981_246# VDPWR sky130_fd_pr__pfet_01v8_hvt ad=0.1155 pd=0.97 as=0.07245 ps=0.765 w=0.42 l=0.15
X859 VDPWR a_15225_n702# a_14967_n702# VDPWR sky130_fd_pr__pfet_01v8_hvt ad=0.0567 pd=0.69 as=0.1092 ps=1.36 w=0.42 l=0.5
X860 a_15537_n132# digital_0._116_.Q VDPWR VDPWR sky130_fd_pr__pfet_01v8_hvt ad=0.135 pd=1.27 as=0.135 ps=1.27 w=1 l=0.15
X861 a_12116_188# digital_0._063_.A digital_0._113_.D VGND sky130_fd_pr__nfet_01v8 ad=0.169 pd=1.82 as=0.10563 ps=0.975 w=0.65 l=0.15
X862 VGND VDPWR VGND VGND sky130_fd_pr__nfet_01v8 ad=0.143 pd=1.62 as=0 ps=0 w=0.55 l=0.59
X863 VDPWR LELO_GR01_0.x7.xd1<4>.A LELO_GR01_0.x7.x15.I2 VDPWR sky130_fd_pr__pfet_01v8_lvt ad=0.5088 pd=2.98 as=0.3168 ps=1.62 w=0.96 l=0.94
X864 a_14578_1322# digital_0._104_.D VGND VGND sky130_fd_pr__nfet_01v8 ad=0.066 pd=0.745 as=0.2205 ps=1.89 w=0.42 l=0.15
X865 a_5029_956# a_4405_962# a_4921_1334# VDPWR sky130_fd_pr__pfet_01v8_hvt ad=0.1155 pd=0.97 as=0.07245 ps=0.765 w=0.42 l=0.15
X866 a_15400_956# a_14323_962# a_15238_1334# VDPWR sky130_fd_pr__pfet_01v8_hvt ad=0.0567 pd=0.69 as=0.0588 ps=0.7 w=0.42 l=0.15
X867 VGND VDPWR VGND VGND sky130_fd_pr__nfet_01v8 ad=0.143 pd=1.62 as=0 ps=0 w=0.55 l=0.59
X868 a_3471_1474# digital_0.input2.X VDPWR VDPWR sky130_fd_pr__pfet_01v8_hvt ad=0.0567 pd=0.69 as=0.16655 ps=1.39 w=0.42 l=0.15
X869 VDPWR digital_0.input1.X a_6889_2588# VDPWR sky130_fd_pr__pfet_01v8_hvt ad=0.0864 pd=0.91 as=0.1664 ps=1.8 w=0.64 l=0.15
X870 a_7580_11154# a_7364_9234# VGND sky130_fd_pr__res_high_po w=0.36 l=7.36
X871 VGND a_7961_386# digital_0._115_.Q VGND sky130_fd_pr__nfet_01v8 ad=0.169 pd=1.82 as=0.08775 ps=0.92 w=0.65 l=0.15
X872 VGND digital_0.input1.X a_8729_412# VGND sky130_fd_pr__nfet_01v8 ad=0.0567 pd=0.69 as=0.1092 ps=1.36 w=0.42 l=0.15
X873 VGND a_11415_3650# a_11349_3676# VGND sky130_fd_pr__nfet_01v8 ad=0.1449 pd=1.11 as=0.0693 ps=0.75 w=0.42 l=0.15
X874 LELO_GR01_0.x7.x21.D LELO_GR01_0.x8.PWRUP_N_1V8 LELO_GR01_0.x7.x20.D VDPWR sky130_fd_pr__pfet_01v8_lvt ad=0.5088 pd=2.98 as=0.3168 ps=1.62 w=0.96 l=0.94
X875 VGND VDPWR VGND VGND sky130_fd_pr__nfet_01v8 ad=0.143 pd=1.62 as=0 ps=0 w=0.55 l=0.59
X876 VDPWR digital_0.output13.A a_6906_3132# VDPWR sky130_fd_pr__pfet_01v8_hvt ad=0.135 pd=1.27 as=0.135 ps=1.27 w=1 l=0.15
X877 VDPWR digital_0._107_.RESET_B a_7302_n132# VDPWR sky130_fd_pr__pfet_01v8_hvt ad=0.07035 pd=0.755 as=0.1092 ps=1.36 w=0.42 l=0.15
X878 VDPWR LELO_GR01_0.x7.xd1<4>.A sky130_fd_pr__cap_mim_m3_1 l=5 w=5
X879 LELO_GR01_0.x7.x18.D LELO_GR01_0.x8.PWRUP_N_1V8 LELO_GR01_0.x7.x19.D VDPWR sky130_fd_pr__pfet_01v8_lvt ad=0.3168 pd=1.62 as=0.5088 ps=2.98 w=0.96 l=0.94
X880 a_7099_956# digital_0._060_.A_N VDPWR VDPWR sky130_fd_pr__pfet_01v8_hvt ad=0.135 pd=1.27 as=0.1625 ps=1.325 w=1 l=0.15
X881 VDPWR VGND VDPWR VDPWR sky130_fd_pr__pfet_01v8_hvt ad=0.2262 pd=2.26 as=0 ps=0 w=0.87 l=0.59
X882 VDPWR digital_0.load_slew15.X digital_0._118_.RESET_B VDPWR sky130_fd_pr__pfet_01v8_hvt ad=0.26 pd=2.52 as=0.135 ps=1.27 w=1 l=0.15
X883 a_12189_3650# digital_0.output8.A VDPWR VDPWR sky130_fd_pr__pfet_01v8_hvt ad=0.1092 pd=1.36 as=0.0567 ps=0.69 w=0.42 l=0.15
X884 a_27238_16564# a_27454_14644# VGND sky130_fd_pr__res_high_po w=0.36 l=7.36
X885 a_9981_246# a_9465_n126# a_9886_234# VGND sky130_fd_pr__special_nfet_01v8 ad=0.0594 pd=0.69 as=0.066 ps=0.745 w=0.36 l=0.15
X886 a_6961_2044# digital_0._108_.RESET_B VDPWR VDPWR sky130_fd_pr__pfet_01v8_hvt ad=0.1092 pd=1.36 as=0.07035 ps=0.755 w=0.42 l=0.15
X887 a_15413_1260# digital_0._104_.RESET_B VDPWR VDPWR sky130_fd_pr__pfet_01v8_hvt ad=0.0567 pd=0.69 as=0.0819 ps=0.81 w=0.42 l=0.15
X888 VDPWR VGND VDPWR VDPWR sky130_fd_pr__pfet_01v8_hvt ad=0.2262 pd=2.26 as=0 ps=0 w=0.87 l=0.59
X889 a_3471_1474# digital_0._116_.Q a_3717_1528# VGND sky130_fd_pr__nfet_01v8 ad=0.1176 pd=1.4 as=0.0567 ps=0.69 w=0.42 l=0.15
X890 VGND a_8145_2562# a_8079_2588# VGND sky130_fd_pr__nfet_01v8 ad=0.12495 pd=1.015 as=0.0669 ps=0.75 w=0.42 l=0.15
X891 VGND VDPWR VGND VGND sky130_fd_pr__nfet_01v8 ad=0.143 pd=1.62 as=0 ps=0 w=0.55 l=0.59
X892 a_3743_3138# a_3577_3138# VDPWR VDPWR sky130_fd_pr__pfet_01v8_hvt ad=0.1664 pd=1.8 as=0.0864 ps=0.91 w=0.64 l=0.15
X893 VDPWR digital_0._116_.Q a_7717_3926# VDPWR sky130_fd_pr__pfet_01v8_hvt ad=0.135 pd=1.27 as=0.28 ps=2.56 w=1 l=0.15
X894 VDPWR digital_0.hold28.X a_5328_n132# VDPWR sky130_fd_pr__pfet_01v8_hvt ad=0.1092 pd=1.36 as=0.0651 ps=0.73 w=0.42 l=0.15
X895 a_18600_16564# a_18384_14644# VGND sky130_fd_pr__res_high_po w=0.36 l=7.36
X896 LELO_GR01_0.x7.x1.x5.IBN LELO_GR01_0.x7.x1.x5.x9<2>.G VGND VGND sky130_fd_pr__nfet_01v8_lvt ad=0.3168 pd=1.62 as=0.5088 ps=2.98 w=0.96 l=0.94
X897 VGND a_11951_2146# digital_0._063_.A VGND sky130_fd_pr__nfet_01v8 ad=0.17875 pd=1.85 as=0.08775 ps=0.92 w=0.65 l=0.15
X898 digital_0._118_.RESET_B digital_0.load_slew15.X VGND VGND sky130_fd_pr__nfet_01v8 ad=0.08775 pd=0.92 as=0.169 ps=1.82 w=0.65 l=0.15
X899 a_13003_412# a_12959_654# a_12837_412# VGND sky130_fd_pr__nfet_01v8 ad=0.0441 pd=0.63 as=0.1401 ps=1.1 w=0.42 l=0.15
X900 VDPWR clk a_8996_1500# VDPWR sky130_fd_pr__pfet_01v8_hvt ad=0.14 pd=1.28 as=0.14 ps=1.28 w=1 l=0.15
X901 LELO_GR01_0.x7.x29.P a_25054_11144# VGND sky130_fd_pr__res_high_po w=0.36 l=7.36
X902 VGND a_8578_n132# a_8689_n132# VGND sky130_fd_pr__nfet_01v8 ad=0.1856 pd=1.26 as=0.17225 ps=1.83 w=0.65 l=0.25
X903 a_5661_1260# a_5486_1334# a_5840_1322# VGND sky130_fd_pr__nfet_01v8 ad=0.1092 pd=1.36 as=0.06405 ps=0.725 w=0.42 l=0.15
X904 VDPWR a_7418_2422# a_7593_2348# VDPWR sky130_fd_pr__pfet_01v8_hvt ad=0.1134 pd=1.38 as=0.0567 ps=0.69 w=0.42 l=0.15
X905 a_4488_778# a_4118_412# VDPWR VDPWR sky130_fd_pr__pfet_01v8_hvt ad=0.0441 pd=0.63 as=0.1092 ps=1.36 w=0.42 l=0.15
X906 a_14298_1652# digital_0._112_.Q a_14440_1500# VGND sky130_fd_pr__nfet_01v8 ad=0.09975 pd=0.895 as=0.0693 ps=0.75 w=0.42 l=0.15
X907 a_14769_3436# digital_0._102_.RESET_B VDPWR VDPWR sky130_fd_pr__pfet_01v8_hvt ad=0.0567 pd=0.69 as=0.0819 ps=0.81 w=0.42 l=0.15
X908 a_3290_6824# a_3074_4904# VGND sky130_fd_pr__res_high_po w=0.36 l=7.36
X909 VGND digital_0._108_.Q a_7607_3452# VGND sky130_fd_pr__nfet_01v8 ad=0.10725 pd=0.98 as=0.06825 ps=0.86 w=0.65 l=0.15
X910 VGND VDPWR VGND VGND sky130_fd_pr__nfet_01v8 ad=0.143 pd=1.62 as=0 ps=0 w=0.55 l=0.59
X911 digital_0._114_.Q a_9985_386# VGND VGND sky130_fd_pr__nfet_01v8 ad=0.08775 pd=0.92 as=0.2087 ps=2.02 w=0.65 l=0.15
X912 a_9631_n126# a_9465_n126# VDPWR VDPWR sky130_fd_pr__pfet_01v8_hvt ad=0.1664 pd=1.8 as=0.0864 ps=0.91 w=0.64 l=0.15
X913 a_14229_n132# digital_0._105_.RESET_B VDPWR VDPWR sky130_fd_pr__pfet_01v8_hvt ad=0.1092 pd=1.36 as=0.07035 ps=0.755 w=0.42 l=0.15
X914 VDPWR digital_0._065_.A2_N a_11951_2146# VDPWR sky130_fd_pr__pfet_01v8_hvt ad=0.15075 pd=1.345 as=0.07438 ps=0.815 w=0.42 l=0.15
X915 a_11839_2588# a_11673_2588# VGND VGND sky130_fd_pr__nfet_01v8 ad=0.1092 pd=1.36 as=0.0567 ps=0.69 w=0.42 l=0.15
X916 LELO_GR01_0.x8.x3.A LELO_GR01_0.x8.x7.D VGND VGND sky130_fd_pr__nfet_01v8 ad=0.468 pd=2.84 as=0.468 ps=2.84 w=0.9 l=0.16
X917 VDPWR a_6315_1474# digital_0.clkbuf_1_0__f_clk.X VDPWR sky130_fd_pr__pfet_01v8_hvt ad=0.14 pd=1.28 as=0.14 ps=1.28 w=1 l=0.15
X918 a_4934_2422# a_4019_2050# a_4587_2018# VGND sky130_fd_pr__special_nfet_01v8 ad=0.0711 pd=0.755 as=0.0999 ps=0.985 w=0.36 l=0.15
X919 VGND digital_0._111_.Q a_10571_2588# VGND sky130_fd_pr__nfet_01v8 ad=0.0567 pd=0.69 as=0.0567 ps=0.69 w=0.42 l=0.15
X920 digital_0.hold28.A a_4833_3436# VGND VGND sky130_fd_pr__nfet_01v8 ad=0.08775 pd=0.92 as=0.2087 ps=2.02 w=0.65 l=0.15
X921 LELO_GR01_0.x7.x25.D LELO_GR01_0.x8.PWRUP_N_1V8 LELO_GR01_0.x7.x24.D VDPWR sky130_fd_pr__pfet_01v8_lvt ad=0.5088 pd=2.98 as=0.3168 ps=1.62 w=0.96 l=0.94
X922 VDPWR VGND VDPWR VDPWR sky130_fd_pr__pfet_01v8_hvt ad=0.2262 pd=2.26 as=0 ps=0 w=0.87 l=0.59
X923 LELO_GR01_0.x8.VREF_BG LELO_GR01_0.x7.xd1<4>.A VDPWR VDPWR sky130_fd_pr__pfet_01v8_lvt ad=0.3168 pd=1.62 as=0.5088 ps=2.98 w=0.96 l=0.94
X924 LELO_GR01_0.x7.x22.D LELO_GR01_0.x8.PWRUP_N_1V8 LELO_GR01_0.x7.x23.D VDPWR sky130_fd_pr__pfet_01v8_lvt ad=0.3168 pd=1.62 as=0.5088 ps=2.98 w=0.96 l=0.94
X925 a_8578_n676# a_8361_n676# VGND VGND sky130_fd_pr__nfet_01v8 ad=0.17225 pd=1.83 as=0.1228 ps=1.065 w=0.65 l=0.25
X926 LELO_GR01_0.x7.x29.N a_19234_11144# VGND sky130_fd_pr__res_high_po w=0.36 l=7.36
X927 a_7157_n158# a_6962_n16# a_7467_234# VGND sky130_fd_pr__special_nfet_01v8 ad=0.0594 pd=0.69 as=0.1401 ps=1.1 w=0.36 l=0.15
X928 a_13771_n126# a_13605_n126# VDPWR VDPWR sky130_fd_pr__pfet_01v8_hvt ad=0.1664 pd=1.8 as=0.0864 ps=0.91 w=0.64 l=0.15
X929 a_10723_1276# digital_0._069_.A a_10639_1276# VGND sky130_fd_pr__nfet_01v8 ad=0.13975 pd=1.08 as=0.08775 ps=0.92 w=0.65 l=0.15
X930 LELO_GR01_0.x7.x1.x5.x8.G LELO_GR01_0.x7.x1.x5.x8.G LELO_GR01_0.x7.x1.x5.x9<2>.G VGND sky130_fd_pr__nfet_01v8_lvt ad=0.3168 pd=1.62 as=0.5088 ps=2.98 w=0.96 l=0.94
X931 VDPWR digital_0._065_.A2_N a_10997_386# VDPWR sky130_fd_pr__pfet_01v8_hvt ad=0.0777 pd=0.79 as=0.0588 ps=0.7 w=0.42 l=0.15
X932 a_5855_564# a_5951_386# VDPWR VDPWR sky130_fd_pr__pfet_01v8_hvt ad=0.1092 pd=1.36 as=0.14075 ps=1.325 w=0.42 l=0.5
X933 VDPWR digital_0._119_.RESET_B a_4910_n132# VDPWR sky130_fd_pr__pfet_01v8_hvt ad=0.07035 pd=0.755 as=0.1092 ps=1.36 w=0.42 l=0.15
X934 VGND digital_0._108_.RESET_B a_7115_2410# VGND sky130_fd_pr__nfet_01v8 ad=0.1346 pd=1.15 as=0.0441 ps=0.63 w=0.42 l=0.15
X935 a_28934_13064# a_29150_11144# VGND sky130_fd_pr__res_high_po w=0.36 l=7.36
X936 a_13306_412# a_12225_412# a_12959_654# VDPWR sky130_fd_pr__pfet_01v8_hvt ad=0.0588 pd=0.7 as=0.12915 ps=1.185 w=0.42 l=0.15
X937 VGND a_4015_1652# digital_0.hold19.X VGND sky130_fd_pr__nfet_01v8 ad=0.097 pd=0.975 as=0.169 ps=1.82 w=0.65 l=0.15
X938 a_10708_2044# a_9631_2050# a_10546_2422# VDPWR sky130_fd_pr__pfet_01v8_hvt ad=0.0567 pd=0.69 as=0.0588 ps=0.7 w=0.42 l=0.15
X939 digital_0.clkbuf_1_0__f_clk.X a_6315_1474# VGND VGND sky130_fd_pr__nfet_01v8 ad=0.0588 pd=0.7 as=0.0588 ps=0.7 w=0.42 l=0.15
X940 LELO_GR01_0.x8.x5.XA6.A LELO_GR01_0.x8.x5.XA5.A LELO_GR01_0.x8.x8.D LELO_GR01_0.x8.x8.D sky130_fd_pr__pfet_01v8 ad=0.468 pd=2.84 as=0.468 ps=2.84 w=0.9 l=0.16
X941 VDPWR VGND VDPWR VDPWR sky130_fd_pr__pfet_01v8_hvt ad=0.2262 pd=2.26 as=0 ps=0 w=0.87 l=0.59
X942 VDPWR VGND VDPWR VDPWR sky130_fd_pr__pfet_01v8_hvt ad=0.2262 pd=2.26 as=0 ps=0 w=0.87 l=0.59
X943 a_14861_172# digital_0._105_.RESET_B VDPWR VDPWR sky130_fd_pr__pfet_01v8_hvt ad=0.0567 pd=0.69 as=0.0819 ps=0.81 w=0.42 l=0.15
X944 a_10199_n158# a_9981_246# VGND VGND sky130_fd_pr__nfet_01v8 ad=0.0999 pd=0.985 as=0.1346 ps=1.15 w=0.64 l=0.15
X945 a_11949_3132# digital_0._067_.A VDPWR VDPWR sky130_fd_pr__pfet_01v8_hvt ad=0.135 pd=1.27 as=0.135 ps=1.27 w=1 l=0.15
X946 VGND a_5974_n676# digital_0._116_.D VGND sky130_fd_pr__nfet_01v8 ad=0.17225 pd=1.83 as=0.091 ps=0.93 w=0.65 l=0.15
X947 a_5014_778# a_4746_412# VDPWR VDPWR sky130_fd_pr__pfet_01v8_hvt ad=0.0945 pd=0.87 as=0.0798 ps=0.8 w=0.42 l=0.15
X948 VGND a_4369_1474# a_4111_1474# VGND sky130_fd_pr__nfet_01v8 ad=0.0567 pd=0.69 as=0.1092 ps=1.36 w=0.42 l=0.5
X949 a_4019_2050# a_3853_2050# VGND VGND sky130_fd_pr__nfet_01v8 ad=0.1092 pd=1.36 as=0.0567 ps=0.69 w=0.42 l=0.15
X950 VGND a_13978_3650# a_13738_3834# VGND sky130_fd_pr__nfet_01v8 ad=0.1228 pd=1.065 as=0.17225 ps=1.83 w=0.65 l=0.25
X951 VDPWR LELO_GR01_0.x7.xd1<4>.A LELO_GR01_0.x8.IBP_BG VDPWR sky130_fd_pr__pfet_01v8_lvt ad=0.5088 pd=2.98 as=0.3168 ps=1.62 w=0.96 l=0.94
X952 a_7329_778# a_6705_412# a_7221_412# VDPWR sky130_fd_pr__pfet_01v8_hvt ad=0.1155 pd=0.97 as=0.07245 ps=0.765 w=0.42 l=0.15
X953 VDPWR a_10074_2562# digital_0._111_.D VDPWR sky130_fd_pr__pfet_01v8_hvt ad=0.154 pd=1.335 as=0.135 ps=1.27 w=1 l=0.15
X954 VGND a_13746_n524# digital_0._105_.D VGND sky130_fd_pr__nfet_01v8 ad=0.11285 pd=1.045 as=0.169 ps=1.82 w=0.65 l=0.15
X955 a_4093_3510# a_3743_3138# a_3998_3498# VDPWR sky130_fd_pr__pfet_01v8_hvt ad=0.07245 pd=0.765 as=0.0651 ps=0.73 w=0.42 l=0.15
X956 a_12718_3676# a_12501_3676# VDPWR VDPWR sky130_fd_pr__pfet_01v8_hvt ad=0.2173 pd=2.17 as=0.19265 ps=1.415 w=0.82 l=0.25
X957 digital_0.clkbuf_1_1__f_clk.A a_8996_1500# VDPWR VDPWR sky130_fd_pr__pfet_01v8_hvt ad=0.14 pd=1.28 as=0.14 ps=1.28 w=1 l=0.15
X958 a_16440_16564# a_16656_14644# VGND sky130_fd_pr__res_high_po w=0.36 l=7.36
X959 VDPWR VGND VDPWR VDPWR sky130_fd_pr__pfet_01v8_hvt ad=0.2262 pd=2.26 as=0 ps=0 w=0.87 l=0.59
X960 digital_0._115_.D digital_0._060_.A_N a_7375_1276# VGND sky130_fd_pr__nfet_01v8 ad=0.10563 pd=0.975 as=0.169 ps=1.82 w=0.65 l=0.15
X961 VDPWR a_7970_2588# a_8145_2562# VDPWR sky130_fd_pr__pfet_01v8_hvt ad=0.1134 pd=1.38 as=0.0567 ps=0.69 w=0.42 l=0.15
X962 a_12977_2044# digital_0.load_slew17.A digital_0._110_.RESET_B VDPWR sky130_fd_pr__pfet_01v8_hvt ad=0.135 pd=1.27 as=0.135 ps=1.27 w=1 l=0.15
X963 VDPWR VGND VDPWR VDPWR sky130_fd_pr__pfet_01v8_hvt ad=0.2262 pd=2.26 as=0 ps=0 w=0.87 l=0.59
X964 a_12849_778# a_12225_412# a_12741_412# VDPWR sky130_fd_pr__pfet_01v8_hvt ad=0.1155 pd=0.97 as=0.07245 ps=0.765 w=0.42 l=0.15
X965 VGND digital_0._065_.A2_N a_12106_2404# VGND sky130_fd_pr__nfet_01v8 ad=0.1304 pd=1.105 as=0.05355 ps=0.675 w=0.42 l=0.15
X966 VDPWR digital_0._112_.Q a_11951_2146# VDPWR sky130_fd_pr__pfet_01v8_hvt ad=0.0567 pd=0.69 as=0.1092 ps=1.36 w=0.42 l=0.15
X967 a_23130_16564# a_22914_14644# VGND sky130_fd_pr__res_high_po w=0.36 l=7.36
X968 digital_0._110_.D digital_0._067_.A VGND VGND sky130_fd_pr__nfet_01v8 ad=0.08775 pd=0.92 as=0.182 ps=1.86 w=0.65 l=0.15
X969 a_6315_1474# digital_0.clkbuf_1_1__f_clk.A VDPWR VDPWR sky130_fd_pr__pfet_01v8_hvt ad=0.14 pd=1.28 as=0.14 ps=1.28 w=1 l=0.15
X970 digital_0._109_.Q a_8145_2562# VGND VGND sky130_fd_pr__nfet_01v8 ad=0.08775 pd=0.92 as=0.2087 ps=2.02 w=0.65 l=0.15
X971 VGND VDPWR VGND VGND sky130_fd_pr__nfet_01v8 ad=0.143 pd=1.62 as=0 ps=0 w=0.55 l=0.59
X972 VDPWR a_13746_n524# digital_0._105_.D VDPWR sky130_fd_pr__pfet_01v8_hvt ad=0.15835 pd=1.395 as=0.26 ps=2.52 w=1 l=0.15
X973 a_9463_654# a_9245_412# VGND VGND sky130_fd_pr__nfet_01v8 ad=0.0999 pd=0.985 as=0.1346 ps=1.15 w=0.64 l=0.15
X974 digital_0._069_.B digital_0.output13.A a_7436_3452# VGND sky130_fd_pr__nfet_01v8 ad=0.091 pd=0.93 as=0.08937 ps=0.925 w=0.65 l=0.15
X975 VDPWR a_3471_1474# digital_0._118_.D VDPWR sky130_fd_pr__pfet_01v8_hvt ad=0.16655 pd=1.39 as=0.195 ps=1.39 w=1 l=0.15
X976 a_4921_1334# a_4405_962# a_4826_1322# VGND sky130_fd_pr__special_nfet_01v8 ad=0.0594 pd=0.69 as=0.066 ps=0.745 w=0.36 l=0.15
X977 digital_0._110_.RESET_B digital_0.load_slew17.A VGND VGND sky130_fd_pr__nfet_01v8 ad=0.08775 pd=0.92 as=0.169 ps=1.82 w=0.65 l=0.15
X978 a_4201_3132# a_3577_3138# a_4093_3510# VDPWR sky130_fd_pr__pfet_01v8_hvt ad=0.1155 pd=0.97 as=0.07245 ps=0.765 w=0.42 l=0.15
X979 LELO_GR01_0.x7.x15.I1 a_7364_9234# VGND sky130_fd_pr__res_high_po w=0.36 l=7.36
X980 LELO_GR01_0.x7.x7.G LELO_GR01_0.x7.xd1<4>.A VDPWR VDPWR sky130_fd_pr__pfet_01v8_lvt ad=0.3168 pd=1.62 as=0.5088 ps=2.98 w=0.96 l=0.94
X981 LELO_GR01_0.x8.x5.XA5.A LELO_GR01_0.x8.x5.XA7.C LELO_GR01_0.x8.x5.XA3.MN1.S VGND sky130_fd_pr__nfet_01v8 ad=0.468 pd=2.84 as=0.288 ps=1.54 w=0.9 l=0.16
X982 VGND digital_0._060_.A_N a_9417_n702# VGND sky130_fd_pr__nfet_01v8 ad=0.1092 pd=1.36 as=0.1092 ps=1.36 w=0.42 l=0.15
X983 VDPWR a_15268_1474# digital_0.load_slew17.A VDPWR sky130_fd_pr__pfet_01v8_hvt ad=0.2726 pd=1.61 as=0.495 ps=2.99 w=1 l=0.15
X984 a_10900_2410# digital_0._111_.RESET_B VGND VGND sky130_fd_pr__nfet_01v8 ad=0.06405 pd=0.725 as=0.12495 ps=1.015 w=0.42 l=0.15
X985 VGND digital_0.load_slew15.X digital_0._107_.RESET_B VGND sky130_fd_pr__nfet_01v8 ad=0.169 pd=1.82 as=0.08775 ps=0.92 w=0.65 l=0.15
X986 digital_0._116_.D a_5974_n676# VDPWR VDPWR sky130_fd_pr__pfet_01v8_hvt ad=0.14 pd=1.28 as=0.265 ps=2.53 w=1 l=0.15
X987 VDPWR digital_0._110_.Q a_12517_2044# VDPWR sky130_fd_pr__pfet_01v8_hvt ad=0.135 pd=1.27 as=0.135 ps=1.27 w=1 l=0.15
X988 VGND a_9564_930# digital_0.load_slew15.A VGND sky130_fd_pr__nfet_01v8 ad=0.1856 pd=1.26 as=0.2079 ps=1.83 w=0.42 l=0.15
X989 digital_0._108_.D digital_0._108_.Q a_6455_3452# VGND sky130_fd_pr__nfet_01v8 ad=0.10563 pd=0.975 as=0.169 ps=1.82 w=0.65 l=0.15
X990 VGND a_12929_2562# digital_0._110_.Q VGND sky130_fd_pr__nfet_01v8 ad=0.169 pd=1.82 as=0.08775 ps=0.92 w=0.65 l=0.15
X991 a_9463_654# a_9245_412# VDPWR VDPWR sky130_fd_pr__pfet_01v8_hvt ad=0.12915 pd=1.185 as=0.2184 ps=2.2 w=0.84 l=0.15
X992 VGND VDPWR VGND VGND sky130_fd_pr__nfet_01v8 ad=0.143 pd=1.62 as=0 ps=0 w=0.55 l=0.59
X993 VDPWR LELO_GR01_0.PWRUP_1V8 LELO_GR01_0.x8.x1.x7.D VDPWR sky130_fd_pr__pfet_01v8_lvt ad=0.5088 pd=2.98 as=0.3168 ps=1.62 w=0.96 l=0.94
X994 VDPWR a_8996_1500# digital_0.clkbuf_1_1__f_clk.A VDPWR sky130_fd_pr__pfet_01v8_hvt ad=0.14 pd=1.28 as=0.14 ps=1.28 w=1 l=0.15
X995 a_3722_6824# a_3938_4904# VGND sky130_fd_pr__res_high_po w=0.36 l=7.36
X996 a_4015_1652# a_4111_1474# VGND VGND sky130_fd_pr__nfet_01v8 ad=0.1092 pd=1.36 as=0.097 ps=0.975 w=0.42 l=0.5
X997 VDPWR VGND VDPWR VDPWR sky130_fd_pr__pfet_01v8_hvt ad=0.2262 pd=2.26 as=0 ps=0 w=0.87 l=0.59
X998 a_7623_2830# a_7405_2588# VDPWR VDPWR sky130_fd_pr__pfet_01v8_hvt ad=0.12915 pd=1.185 as=0.2184 ps=2.2 w=0.84 l=0.15
R4 uio_oe<6> JNWTR_TIEL_CV_0.Y sky130_fd_pr__res_generic_m4 w=0.3 l=0.3
X999 a_9980_6824# a_9764_4904# VGND sky130_fd_pr__res_high_po w=0.36 l=7.36
X1000 a_28102_16564# a_27886_14644# VGND sky130_fd_pr__res_high_po w=0.36 l=7.36
X1001 VGND digital_0.input1.X a_9465_2050# VGND sky130_fd_pr__nfet_01v8 ad=0.0567 pd=0.69 as=0.1092 ps=1.36 w=0.42 l=0.15
X1002 digital_0.clkload0.A a_11388_956# VDPWR VDPWR sky130_fd_pr__pfet_01v8_hvt ad=0.14 pd=1.28 as=0.1375 ps=1.275 w=1 l=0.15
X1003 VDPWR a_11098_3510# a_11273_3436# VDPWR sky130_fd_pr__pfet_01v8_hvt ad=0.1134 pd=1.38 as=0.0567 ps=0.69 w=0.42 l=0.15
X1004 digital_0._107_.RESET_B digital_0.load_slew15.X VDPWR VDPWR sky130_fd_pr__pfet_01v8_hvt ad=0.135 pd=1.27 as=0.26 ps=2.52 w=1 l=0.15
X1005 a_13468_1866# a_12391_1500# a_13306_1500# VDPWR sky130_fd_pr__pfet_01v8_hvt ad=0.0567 pd=0.69 as=0.0588 ps=0.7 w=0.42 l=0.15
X1006 VGND a_14769_3436# digital_0.output7.A VGND sky130_fd_pr__nfet_01v8 ad=0.169 pd=1.82 as=0.08775 ps=0.92 w=0.65 l=0.15
X1007 a_10089_n132# digital_0._106_.RESET_B VDPWR VDPWR sky130_fd_pr__pfet_01v8_hvt ad=0.1092 pd=1.36 as=0.07035 ps=0.755 w=0.42 l=0.15
X1008 a_5043_2422# a_3853_2050# a_4934_2422# VGND sky130_fd_pr__special_nfet_01v8 ad=0.0669 pd=0.75 as=0.0711 ps=0.755 w=0.36 l=0.15
X1009 uo_out<0> LELO_GR01_0.x8.x5.XA7.CN LELO_GR01_0.x8.x5.XA7.MP1.S LELO_GR01_0.x8.x8.D sky130_fd_pr__pfet_01v8 ad=0.468 pd=2.84 as=0.288 ps=1.54 w=0.9 l=0.16
X1010 VGND a_5422_n702# a_5182_n518# VGND sky130_fd_pr__nfet_01v8 ad=0.1228 pd=1.065 as=0.17225 ps=1.83 w=0.65 l=0.25
X1011 VDPWR a_14247_3106# a_14137_3132# VDPWR sky130_fd_pr__pfet_01v8_hvt ad=0.07035 pd=0.755 as=0.1155 ps=0.97 w=0.42 l=0.15
X1012 a_22902_13064# a_22686_11144# VGND sky130_fd_pr__res_high_po w=0.36 l=7.36
X1013 digital_0.load_slew15.X a_8085_1500# VGND VGND sky130_fd_pr__nfet_01v8 ad=0.08775 pd=0.92 as=0.08775 ps=0.92 w=0.65 l=0.15
X1014 VDPWR VGND VDPWR VDPWR sky130_fd_pr__pfet_01v8_hvt ad=0.2262 pd=2.26 as=0 ps=0 w=0.87 l=0.59
X1015 LELO_GR01_0.x7.x30.N a_3074_4904# VGND sky130_fd_pr__res_high_po w=0.36 l=7.36
X1016 digital_0._115_.Q a_7961_386# VDPWR VDPWR sky130_fd_pr__pfet_01v8_hvt ad=0.135 pd=1.27 as=0.3012 ps=2.66 w=1 l=0.15
X1017 a_10655_2910# digital_0._111_.Q a_10074_2562# VDPWR sky130_fd_pr__pfet_01v8_hvt ad=0.0864 pd=0.91 as=0.0928 ps=0.93 w=0.64 l=0.15
X1018 VDPWR digital_0.output13.A a_6179_3132# VDPWR sky130_fd_pr__pfet_01v8_hvt ad=0.135 pd=1.27 as=0.135 ps=1.27 w=1 l=0.15
X1019 a_10721_172# a_10546_246# a_10900_234# VGND sky130_fd_pr__nfet_01v8 ad=0.1092 pd=1.36 as=0.06405 ps=0.725 w=0.42 l=0.15
X1020 VDPWR VGND VDPWR VDPWR sky130_fd_pr__pfet_01v8_hvt ad=0.2262 pd=2.26 as=0 ps=0 w=0.87 l=0.59
X1021 a_6197_2588# digital_0.hold25.X a_5834_2740# VGND sky130_fd_pr__nfet_01v8 ad=0.0693 pd=0.75 as=0.09975 ps=0.895 w=0.42 l=0.15
X1022 digital_0.clkbuf_1_0__f_clk.X a_6315_1474# VGND VGND sky130_fd_pr__nfet_01v8 ad=0.0588 pd=0.7 as=0.05775 ps=0.695 w=0.42 l=0.15
X1023 VDPWR a_10546_246# a_10721_172# VDPWR sky130_fd_pr__pfet_01v8_hvt ad=0.1134 pd=1.38 as=0.0567 ps=0.69 w=0.42 l=0.15
X1024 digital_0._102_.D a_12889_3171# VGND VGND sky130_fd_pr__nfet_01v8 ad=0.169 pd=1.82 as=0.11285 ps=1.045 w=0.65 l=0.15
X1025 a_5976_2588# digital_0.hold28.A VGND VGND sky130_fd_pr__nfet_01v8 ad=0.0693 pd=0.75 as=0.11285 ps=1.045 w=0.42 l=0.15
X1026 VGND ui_in<0> a_8361_n132# VGND sky130_fd_pr__nfet_01v8 ad=0.1228 pd=1.065 as=0.1134 ps=1.38 w=0.42 l=0.15
X1027 a_7375_1276# digital_0._060_.A_N digital_0._115_.D VGND sky130_fd_pr__nfet_01v8 ad=0.08775 pd=0.92 as=0.10563 ps=0.975 w=0.65 l=0.15
X1028 a_4465_2422# a_4019_2050# a_4369_2422# VGND sky130_fd_pr__special_nfet_01v8 ad=0.1401 pd=1.1 as=0.0594 ps=0.69 w=0.36 l=0.15
X1029 VDPWR a_12929_2562# a_12916_2954# VDPWR sky130_fd_pr__pfet_01v8_hvt ad=0.0819 pd=0.81 as=0.0567 ps=0.69 w=0.42 l=0.15
X1030 a_7970_2588# a_6889_2588# a_7623_2830# VDPWR sky130_fd_pr__pfet_01v8_hvt ad=0.0588 pd=0.7 as=0.12915 ps=1.185 w=0.42 l=0.15
X1031 VDPWR digital_0.output4.A a_4243_n676# VDPWR sky130_fd_pr__pfet_01v8_hvt ad=0.0567 pd=0.69 as=0.1092 ps=1.36 w=0.42 l=0.15
X1032 digital_0.clkload0.A a_11388_956# VDPWR VDPWR sky130_fd_pr__pfet_01v8_hvt ad=0.14 pd=1.28 as=0.14 ps=1.28 w=1 l=0.15
X1033 VGND digital_0.output12.A a_6451_n676# VGND sky130_fd_pr__nfet_01v8 ad=0.0567 pd=0.69 as=0.1092 ps=1.36 w=0.42 l=0.15
X1034 a_28502_13064# a_28718_11144# VGND sky130_fd_pr__res_high_po w=0.36 l=7.36
X1035 a_9981_246# a_9631_n126# a_9886_234# VDPWR sky130_fd_pr__pfet_01v8_hvt ad=0.07245 pd=0.765 as=0.0651 ps=0.73 w=0.42 l=0.15
X1036 VGND a_11388_956# digital_0.clkload0.A VGND sky130_fd_pr__nfet_01v8 ad=0.0588 pd=0.7 as=0.0588 ps=0.7 w=0.42 l=0.15
X1037 a_20970_16564# a_21186_14644# VGND sky130_fd_pr__res_high_po w=0.36 l=7.36
X1038 LELO_GR01_0.x8.x1.x5.x8.G LELO_GR01_0.x8.x1.x5.x8.G LELO_GR01_0.x8.x1.x5.x9<2>.G VGND sky130_fd_pr__nfet_01v8_lvt ad=0.3168 pd=1.62 as=0.5088 ps=2.98 w=0.96 l=0.94
X1039 a_7157_n158# a_7001_110# a_7302_n132# VDPWR sky130_fd_pr__pfet_01v8_hvt ad=0.07245 pd=0.765 as=0.1155 ps=0.97 w=0.42 l=0.15
X1040 a_5785_n426# digital_0._116_.Q VDPWR VDPWR sky130_fd_pr__pfet_01v8_hvt ad=0.14 pd=1.28 as=0.1575 ps=1.315 w=1 l=0.15
X1041 digital_0.clkbuf_1_0__f_clk.X a_6315_1474# VDPWR VDPWR sky130_fd_pr__pfet_01v8_hvt ad=0.14 pd=1.28 as=0.265 ps=2.53 w=1 l=0.15
X1042 VGND a_12929_2562# a_12863_2588# VGND sky130_fd_pr__nfet_01v8 ad=0.12495 pd=1.015 as=0.0669 ps=0.75 w=0.42 l=0.15
X1043 VGND a_5855_564# digital_0.hold22.X VGND sky130_fd_pr__nfet_01v8 ad=0.097 pd=0.975 as=0.169 ps=1.82 w=0.65 l=0.15
X1044 VDPWR LELO_GR01_0.x8.x1.x7.D LELO_GR01_0.x8.x1.x7.D VDPWR sky130_fd_pr__pfet_01v8_lvt ad=0.5088 pd=2.98 as=0.3168 ps=1.62 w=0.96 l=0.94
X1045 VGND digital_0._115_.RESET_B a_7483_412# VGND sky130_fd_pr__nfet_01v8 ad=0.1346 pd=1.15 as=0.0441 ps=0.63 w=0.42 l=0.15
X1046 digital_0._108_.RESET_B digital_0.load_slew15.A VGND VGND sky130_fd_pr__nfet_01v8 ad=0.08775 pd=0.92 as=0.169 ps=1.82 w=0.65 l=0.15
X1047 VDPWR digital_0._116_.Q a_5785_1750# VDPWR sky130_fd_pr__pfet_01v8_hvt ad=0.135 pd=1.27 as=0.28 ps=2.56 w=1 l=0.15
X1048 a_9557_2838# digital_0.load_slew17.A digital_0._111_.RESET_B VDPWR sky130_fd_pr__pfet_01v8_hvt ad=0.26 pd=2.52 as=0.135 ps=1.27 w=1 l=0.15
X1049 VGND LELO_GR01_0.x8.x1.x5.x9<2>.G LELO_GR01_0.x8.x1.x5.x8.G VGND sky130_fd_pr__nfet_01v8_lvt ad=0.5088 pd=2.98 as=0.3168 ps=1.62 w=0.96 l=0.94
X1050 LELO_GR01_0.x8.x7.D LELO_GR01_0.x8.x1.x7.D VDPWR VDPWR sky130_fd_pr__pfet_01v8_lvt ad=0.3168 pd=1.62 as=0.5088 ps=2.98 w=0.96 l=0.94
X1051 VDPWR VGND VDPWR VDPWR sky130_fd_pr__pfet_01v8_hvt ad=0.2262 pd=2.26 as=0 ps=0 w=0.87 l=0.59
X1052 digital_0._116_.SET_B digital_0.load_slew15.X VDPWR VDPWR sky130_fd_pr__pfet_01v8_hvt ad=0.135 pd=1.27 as=0.26 ps=2.52 w=1 l=0.15
X1053 digital_0._115_.RESET_B digital_0.load_slew17.X a_5785_1750# VDPWR sky130_fd_pr__pfet_01v8_hvt ad=0.135 pd=1.27 as=0.135 ps=1.27 w=1 l=0.15
X1054 a_5787_2146# digital_0._109_.Q VDPWR VDPWR sky130_fd_pr__pfet_01v8_hvt ad=0.07438 pd=0.815 as=0.0567 ps=0.69 w=0.42 l=0.15
X1055 digital_0.clkbuf_1_1__f_clk.A a_8996_1500# VDPWR VDPWR sky130_fd_pr__pfet_01v8_hvt ad=0.14 pd=1.28 as=0.14 ps=1.28 w=1 l=0.15
X1056 VDPWR digital_0.input1.X a_6337_2050# VDPWR sky130_fd_pr__pfet_01v8_hvt ad=0.0864 pd=0.91 as=0.1664 ps=1.8 w=0.64 l=0.15
X1057 a_13679_3138# a_13513_3138# VGND VGND sky130_fd_pr__nfet_01v8 ad=0.1092 pd=1.36 as=0.0567 ps=0.69 w=0.42 l=0.15
X1058 VGND a_11673_412# digital_0.clkload0.X VGND sky130_fd_pr__nfet_01v8 ad=0.1218 pd=1.42 as=0.0588 ps=0.7 w=0.42 l=0.15
X1059 LELO_GR01_0.x8.IBP_BG VGND sky130_fd_pr__cap_mim_m3_1 l=5 w=5
X1060 VGND digital_0._118_.RESET_B a_5183_1322# VGND sky130_fd_pr__nfet_01v8 ad=0.1346 pd=1.15 as=0.0441 ps=0.63 w=0.42 l=0.15
X1061 a_3492_930# a_3618_1194# VGND VGND sky130_fd_pr__nfet_01v8 ad=0.17225 pd=1.83 as=0.1856 ps=1.26 w=0.65 l=0.25
X1062 a_14762_2018# digital_0.load_slew17.A VGND VGND sky130_fd_pr__nfet_01v8 ad=0.1092 pd=1.36 as=0.097 ps=0.975 w=0.42 l=0.15
X1063 a_10164_412# digital_0._114_.RESET_B VGND VGND sky130_fd_pr__nfet_01v8 ad=0.06405 pd=0.725 as=0.12495 ps=1.015 w=0.42 l=0.15
X1064 VDPWR a_12959_1742# a_12849_1866# VDPWR sky130_fd_pr__pfet_01v8_hvt ad=0.07035 pd=0.755 as=0.1155 ps=0.97 w=0.42 l=0.15
X1065 a_4568_412# a_4530_626# a_3982_386# VGND sky130_fd_pr__nfet_01v8 ad=0.0441 pd=0.63 as=0.0735 ps=0.77 w=0.42 l=0.15
X1066 a_6455_3452# digital_0._108_.Q digital_0._108_.D VGND sky130_fd_pr__nfet_01v8 ad=0.08775 pd=0.92 as=0.10563 ps=0.975 w=0.65 l=0.15
X1067 a_4765_n158# a_4570_n16# a_5075_234# VGND sky130_fd_pr__special_nfet_01v8 ad=0.0594 pd=0.69 as=0.1401 ps=1.1 w=0.36 l=0.15
X1068 a_4891_2588# a_4512_2954# a_4819_2588# VGND sky130_fd_pr__nfet_01v8 ad=0.1401 pd=1.1 as=0.0441 ps=0.63 w=0.42 l=0.15
X1069 a_14703_3510# a_13513_3138# a_14594_3510# VGND sky130_fd_pr__special_nfet_01v8 ad=0.0669 pd=0.75 as=0.0711 ps=0.755 w=0.36 l=0.15
X1070 VGND digital_0._119_.RESET_B a_4327_234# VGND sky130_fd_pr__nfet_01v8 ad=0.12495 pd=1.015 as=0.06405 ps=0.725 w=0.42 l=0.15
X1071 VGND digital_0._065_.A2_N a_11655_1500# VGND sky130_fd_pr__nfet_01v8 ad=0.10725 pd=0.98 as=0.06825 ps=0.86 w=0.65 l=0.15
X1072 VDPWR a_15662_2044# a_15773_2044# VDPWR sky130_fd_pr__pfet_01v8_hvt ad=0.2726 pd=1.61 as=0.2173 ps=2.17 w=0.82 l=0.25
X1073 VGND a_13612_3650# uio_out<2> VGND sky130_fd_pr__nfet_01v8 ad=0.1856 pd=1.26 as=0.2079 ps=1.83 w=0.42 l=0.15
X1074 LELO_GR01_0.x8.x5.XA6.MN1.S LELO_GR01_0.x8.x5.XA6.A VGND VGND sky130_fd_pr__nfet_01v8 ad=0.288 pd=1.54 as=0.468 ps=2.84 w=0.9 l=0.16
X1075 a_7720_n132# a_6962_n16# a_7157_n158# VDPWR sky130_fd_pr__pfet_01v8_hvt ad=0.0651 pd=0.73 as=0.07245 ps=0.765 w=0.42 l=0.15
X1076 a_15634_1474# digital_0.input3.X VDPWR VDPWR sky130_fd_pr__pfet_01v8_hvt ad=0.27 pd=2.54 as=0.19265 ps=1.415 w=1 l=0.15
X1077 a_4383_2588# a_3821_2562# VGND VGND sky130_fd_pr__nfet_01v8 ad=0.0669 pd=0.75 as=0.12495 ps=1.015 w=0.42 l=0.15
X1078 LELO_GR01_0.x8.IBP_BG VGND sky130_fd_pr__cap_mim_m3_1 l=5 w=5
X1079 VGND VDPWR VGND VGND sky130_fd_pr__nfet_01v8 ad=0.143 pd=1.62 as=0 ps=0 w=0.55 l=0.59
X1080 digital_0.clkload0.X a_11673_412# VGND VGND sky130_fd_pr__nfet_01v8 ad=0.0588 pd=0.7 as=0.0588 ps=0.7 w=0.42 l=0.15
X1081 VGND a_4479_n676# a_4585_n676# VGND sky130_fd_pr__nfet_01v8 ad=0.097 pd=0.975 as=0.1092 ps=1.36 w=0.42 l=0.5
X1082 uo_out<0> LELO_GR01_0.x8.x5.XA7.C LELO_GR01_0.x8.x5.XA6.MP1.S LELO_GR01_0.x8.x8.D sky130_fd_pr__pfet_01v8 ad=0.468 pd=2.84 as=0.288 ps=1.54 w=0.9 l=0.16
X1083 a_25942_16564# a_26158_14644# VGND sky130_fd_pr__res_high_po w=0.36 l=7.36
X1084 a_4833_3436# a_4658_3510# a_5012_3498# VGND sky130_fd_pr__nfet_01v8 ad=0.1092 pd=1.36 as=0.06405 ps=0.725 w=0.42 l=0.15
X1085 a_10066_n524# digital_0.hold21.X a_10208_n349# VDPWR sky130_fd_pr__pfet_01v8_hvt ad=0.1932 pd=1.34 as=0.07665 ps=0.785 w=0.42 l=0.15
X1086 a_15268_1474# a_15394_1658# VGND VGND sky130_fd_pr__nfet_01v8 ad=0.17225 pd=1.83 as=0.1856 ps=1.26 w=0.65 l=0.25
X1087 VGND LELO_GR01_0.x7.x1.x5.x9<2>.G LELO_GR01_0.x7.x1.x5.x8.G VGND sky130_fd_pr__nfet_01v8_lvt ad=0.5088 pd=2.98 as=0.3168 ps=1.62 w=0.96 l=0.94
X1088 VGND VDPWR VGND VGND sky130_fd_pr__nfet_01v8 ad=0.143 pd=1.62 as=0 ps=0 w=0.55 l=0.59
X1089 LELO_GR01_0.x7.x29.N a_16214_11144# VGND sky130_fd_pr__res_high_po w=0.36 l=7.36
X1090 a_17304_16564# a_17088_14644# VGND sky130_fd_pr__res_high_po w=0.36 l=7.36
X1091 VDPWR digital_0._112_.Q a_10555_956# VDPWR sky130_fd_pr__pfet_01v8_hvt ad=0.135 pd=1.27 as=0.215 ps=1.43 w=1 l=0.15
X1092 LELO_GR01_0.x7.x6<3>.G LELO_GR01_0.x7.x6<3>.G LELO_GR01_0.x7.x7.S VGND sky130_fd_pr__nfet_01v8_lvt ad=0.3168 pd=1.62 as=0.5088 ps=2.98 w=0.96 l=0.94
X1093 VGND a_6315_1474# digital_0.clkbuf_1_0__f_clk.X VGND sky130_fd_pr__nfet_01v8 ad=0.0588 pd=0.7 as=0.0588 ps=0.7 w=0.42 l=0.15
X1094 a_7001_110# digital_0.clkload0.A VGND VGND sky130_fd_pr__nfet_01v8 ad=0.1092 pd=1.36 as=0.0567 ps=0.69 w=0.42 l=0.15
X1095 VDPWR digital_0.load_slew15.X digital_0._101_.RESET_B VDPWR sky130_fd_pr__pfet_01v8_hvt ad=0.26 pd=2.52 as=0.135 ps=1.27 w=1 l=0.15
X1096 a_12116_n132# digital_0._113_.Q VDPWR VDPWR sky130_fd_pr__pfet_01v8_hvt ad=0.135 pd=1.27 as=0.135 ps=1.27 w=1 l=0.15
X1097 digital_0._111_.RESET_B digital_0._116_.Q VGND VGND sky130_fd_pr__nfet_01v8 ad=0.08775 pd=0.92 as=0.182 ps=1.86 w=0.65 l=0.15
X1098 VDPWR clk a_8996_1500# VDPWR sky130_fd_pr__pfet_01v8_hvt ad=0.14 pd=1.28 as=0.14 ps=1.28 w=1 l=0.15
X1099 a_7356_n676# digital_0.hold28.A VGND VGND sky130_fd_pr__nfet_01v8 ad=0.0693 pd=0.75 as=0.11285 ps=1.045 w=0.42 l=0.15
X1100 LELO_GR01_0.x8.x1.x5.x6.N LELO_GR01_0.x8.x1.x5.x8.G LELO_GR01_0.x8.x1.x5.x9<2>.G LELO_GR01_0.x8.x1.x5.x6.N sky130_fd_pr__pfet_01v8_lvt ad=0.5088 pd=2.98 as=0.3168 ps=1.62 w=0.96 l=0.94
X1101 a_10655_246# a_9465_n126# a_10546_246# VGND sky130_fd_pr__special_nfet_01v8 ad=0.0669 pd=0.75 as=0.0711 ps=0.755 w=0.36 l=0.15
X1102 VDPWR VGND VDPWR VDPWR sky130_fd_pr__pfet_01v8_hvt ad=0.2262 pd=2.26 as=0 ps=0 w=0.87 l=0.59
X1103 VGND LELO_GR01_0.x7.x7.G LELO_GR01_0.x7.x7.S VDPWR sky130_fd_pr__pfet_01v8_lvt ad=0.3168 pd=1.62 as=0.5088 ps=2.98 w=0.96 l=0.94
X1104 a_5218_778# a_4438_386# a_4610_386# VGND sky130_fd_pr__special_nfet_01v8 ad=0.0935 pd=0.965 as=0.072 ps=0.76 w=0.36 l=0.15
X1105 a_11673_n132# digital_0._063_.A a_11758_188# VDPWR sky130_fd_pr__pfet_01v8_hvt ad=0.26 pd=2.52 as=0.135 ps=1.27 w=1 l=0.15
X1106 VGND VDPWR VGND VGND sky130_fd_pr__nfet_01v8 ad=0.143 pd=1.62 as=0 ps=0 w=0.55 l=0.59
X1107 VGND a_11772_n702# uio_out<5> VGND sky130_fd_pr__nfet_01v8 ad=0.1856 pd=1.26 as=0.2079 ps=1.83 w=0.42 l=0.15
X1108 VDPWR a_6315_1474# digital_0.clkbuf_1_0__f_clk.X VDPWR sky130_fd_pr__pfet_01v8_hvt ad=0.1375 pd=1.275 as=0.14 ps=1.28 w=1 l=0.15
X1109 VGND a_11673_412# digital_0.clkload0.X VGND sky130_fd_pr__nfet_01v8 ad=0.0588 pd=0.7 as=0.0588 ps=0.7 w=0.42 l=0.15
X1110 a_4631_2410# a_4587_2018# a_4465_2422# VGND sky130_fd_pr__nfet_01v8 ad=0.0441 pd=0.63 as=0.1401 ps=1.1 w=0.42 l=0.15
X1111 digital_0._112_.Q a_13481_386# VGND VGND sky130_fd_pr__nfet_01v8 ad=0.08775 pd=0.92 as=0.2087 ps=2.02 w=0.65 l=0.15
X1112 a_3998_3498# digital_0.hold19.X VGND VGND sky130_fd_pr__nfet_01v8 ad=0.066 pd=0.745 as=0.2205 ps=1.89 w=0.42 l=0.15
X1113 VGND VGND LELO_GR01_0.x7.x15.I1 sky130_fd_pr__pnp_05v5_W3p40L3p40
**devattr s=462400,2720
X1114 LELO_GR01_0.x7.x1.x5.IBN LELO_GR01_0.x7.x1.x5.x9<2>.G VGND VGND sky130_fd_pr__nfet_01v8_lvt ad=0.3168 pd=1.62 as=0.5088 ps=2.98 w=0.96 l=0.94
X1115 VGND VDPWR VGND VGND sky130_fd_pr__nfet_01v8 ad=0.143 pd=1.62 as=0 ps=0 w=0.55 l=0.59
X1116 LELO_GR01_0.x7.x24.D LELO_GR01_0.x8.PWRUP_N_1V8 LELO_GR01_0.x7.x25.D VDPWR sky130_fd_pr__pfet_01v8_lvt ad=0.3168 pd=1.62 as=0.5088 ps=2.98 w=0.96 l=0.94
X1117 VDPWR a_8996_1500# digital_0.clkbuf_1_1__f_clk.A VDPWR sky130_fd_pr__pfet_01v8_hvt ad=0.1375 pd=1.275 as=0.14 ps=1.28 w=1 l=0.15
X1118 a_5328_n132# a_4609_110# a_4765_n158# VGND sky130_fd_pr__special_nfet_01v8 ad=0.066 pd=0.745 as=0.0594 ps=0.69 w=0.36 l=0.15
X1119 a_4479_n676# a_4243_n676# VGND VGND sky130_fd_pr__nfet_01v8 ad=0.1092 pd=1.36 as=0.0567 ps=0.69 w=0.42 l=0.5
X1120 VDPWR a_15634_1474# a_15394_1658# VDPWR sky130_fd_pr__pfet_01v8_hvt ad=0.19265 pd=1.415 as=0.2173 ps=2.17 w=0.82 l=0.25
X1121 a_9886_2410# digital_0._111_.D VDPWR VDPWR sky130_fd_pr__pfet_01v8_hvt ad=0.0651 pd=0.73 as=0.1092 ps=1.36 w=0.42 l=0.15
X1122 VDPWR digital_0._108_.Q a_7349_3132# VDPWR sky130_fd_pr__pfet_01v8_hvt ad=0.14 pd=1.28 as=0.28 ps=2.56 w=1 l=0.15
X1123 VGND VGND LELO_GR01_0.x7.x15.I1 sky130_fd_pr__pnp_05v5_W3p40L3p40
**devattr s=462400,2720
X1124 digital_0.hold25.X a_5321_3676# VGND VGND sky130_fd_pr__nfet_01v8 ad=0.169 pd=1.82 as=0.097 ps=0.975 w=0.65 l=0.15
X1125 VGND VDPWR VGND VGND sky130_fd_pr__nfet_01v8 ad=0.143 pd=1.62 as=0 ps=0 w=0.55 l=0.59
X1126 a_4274_2410# digital_0._101_.D VGND VGND sky130_fd_pr__nfet_01v8 ad=0.066 pd=0.745 as=0.2205 ps=1.89 w=0.42 l=0.15
X1127 a_12297_2954# digital_0._110_.RESET_B VDPWR VDPWR sky130_fd_pr__pfet_01v8_hvt ad=0.1092 pd=1.36 as=0.07035 ps=0.755 w=0.42 l=0.15
X1128 a_4767_3510# a_3577_3138# a_4658_3510# VGND sky130_fd_pr__special_nfet_01v8 ad=0.0669 pd=0.75 as=0.0711 ps=0.755 w=0.36 l=0.15
X1129 VDPWR a_6407_1188# digital_0.hold28.X VDPWR sky130_fd_pr__pfet_01v8_hvt ad=0.14075 pd=1.325 as=0.26 ps=2.52 w=1 l=0.15
X1130 VGND a_5056_n702# digital_0.input1.X VGND sky130_fd_pr__nfet_01v8 ad=0.1856 pd=1.26 as=0.2079 ps=1.83 w=0.42 l=0.15
X1131 digital_0.output12.A a_6397_n158# VDPWR VDPWR sky130_fd_pr__pfet_01v8_hvt ad=0.135 pd=1.27 as=0.26 ps=2.52 w=1 l=0.15
X1132 VDPWR LELO_GR01_0.PWRUP_1V8 LELO_GR01_0.x7.xd1<4>.A VDPWR sky130_fd_pr__pfet_01v8_lvt ad=0.5088 pd=2.98 as=0.3168 ps=1.62 w=0.96 l=0.94
X1133 a_25510_16564# a_25294_14644# VGND sky130_fd_pr__res_high_po w=0.36 l=7.36
X1134 VDPWR a_11772_n702# uio_out<5> VDPWR sky130_fd_pr__pfet_01v8_hvt ad=0.2726 pd=1.61 as=0.495 ps=2.99 w=1 l=0.15
X1135 VGND digital_0.load_slew17.X digital_0._105_.RESET_B VGND sky130_fd_pr__nfet_01v8 ad=0.169 pd=1.82 as=0.08775 ps=0.92 w=0.65 l=0.15
X1136 VGND digital_0._109_.Q digital_0._069_.B VGND sky130_fd_pr__nfet_01v8 ad=0.26 pd=2.1 as=0.08775 ps=0.92 w=0.65 l=0.15
X1137 VGND LELO_GR01_0.x8.PWRUP_N_1V8 LELO_GR01_0.x7.x1.x5.x9<2>.G VGND sky130_fd_pr__nfet_01v8_lvt ad=0.5088 pd=2.98 as=0.3168 ps=1.62 w=0.96 l=0.94
X1138 a_10208_n676# digital_0.hold28.A VGND VGND sky130_fd_pr__nfet_01v8 ad=0.0693 pd=0.75 as=0.11285 ps=1.045 w=0.42 l=0.15
X1139 a_9548_6824# a_9764_4904# VGND sky130_fd_pr__res_high_po w=0.36 l=7.36
X1140 VDPWR VGND VDPWR VDPWR sky130_fd_pr__pfet_01v8_hvt ad=0.2262 pd=2.26 as=0 ps=0 w=0.87 l=0.59
X1141 VGND digital_0.output5.A a_4979_3676# VGND sky130_fd_pr__nfet_01v8 ad=0.0567 pd=0.69 as=0.1092 ps=1.36 w=0.42 l=0.15
X1142 VGND a_9151_n702# digital_0._114_.D VGND sky130_fd_pr__nfet_01v8 ad=0.10187 pd=0.99 as=0.08775 ps=0.92 w=0.65 l=0.15
X1143 digital_0.clkbuf_1_0__f_clk.X a_6315_1474# VGND VGND sky130_fd_pr__nfet_01v8 ad=0.0588 pd=0.7 as=0.0588 ps=0.7 w=0.42 l=0.15
X1144 a_12929_2562# digital_0._110_.RESET_B VDPWR VDPWR sky130_fd_pr__pfet_01v8_hvt ad=0.0567 pd=0.69 as=0.0819 ps=0.81 w=0.42 l=0.15
X1145 digital_0._107_.RESET_B digital_0.load_slew15.X VGND VGND sky130_fd_pr__nfet_01v8 ad=0.08775 pd=0.92 as=0.169 ps=1.82 w=0.65 l=0.15
X1146 digital_0._057_.D a_12903_206# VGND VGND sky130_fd_pr__nfet_01v8 ad=0.12675 pd=1.04 as=0.1118 ps=1.04 w=0.65 l=0.15
X1147 VGND digital_0.load_slew15.A digital_0._109_.RESET_B VGND sky130_fd_pr__nfet_01v8 ad=0.169 pd=1.82 as=0.08775 ps=0.92 w=0.65 l=0.15
X1148 a_14848_n132# a_13771_n126# a_14686_246# VDPWR sky130_fd_pr__pfet_01v8_hvt ad=0.0567 pd=0.69 as=0.0588 ps=0.7 w=0.42 l=0.15
X1149 VDPWR VGND VDPWR VDPWR sky130_fd_pr__pfet_01v8_hvt ad=0.2262 pd=2.26 as=0 ps=0 w=0.87 l=0.59
X1150 digital_0._067_.B digital_0._069_.A a_12517_2044# VDPWR sky130_fd_pr__pfet_01v8_hvt ad=0.135 pd=1.27 as=0.26 ps=2.52 w=1 l=0.15
X1151 a_6179_3132# a_6235_3106# digital_0._108_.D VDPWR sky130_fd_pr__pfet_01v8_hvt ad=0.26 pd=2.52 as=0.135 ps=1.27 w=1 l=0.15
X1152 a_4228_3650# a_4354_3834# VDPWR VDPWR sky130_fd_pr__pfet_01v8_hvt ad=0.2173 pd=2.17 as=0.2726 ps=1.61 w=0.82 l=0.25
X1153 digital_0.clkbuf_1_0__f_clk.X a_6315_1474# VDPWR VDPWR sky130_fd_pr__pfet_01v8_hvt ad=0.14 pd=1.28 as=0.14 ps=1.28 w=1 l=0.15
X1154 JNWTR_IVX1_CV_0.Y rst_n VDPWR VDPWR sky130_fd_pr__pfet_01v8 ad=0.468 pd=2.84 as=0.468 ps=2.84 w=0.9 l=0.16
X1155 a_12116_n132# a_11758_188# digital_0._113_.D VDPWR sky130_fd_pr__pfet_01v8_hvt ad=0.28 pd=2.56 as=0.135 ps=1.27 w=1 l=0.15
X1156 VDPWR a_9985_386# a_9972_778# VDPWR sky130_fd_pr__pfet_01v8_hvt ad=0.0819 pd=0.81 as=0.0567 ps=0.69 w=0.42 l=0.15
R5 uio_oe<3> JNWTR_TIEL_CV_0.Y sky130_fd_pr__res_generic_m4 w=0.3 l=0.3
X1157 a_9150_412# digital_0._114_.D VDPWR VDPWR sky130_fd_pr__pfet_01v8_hvt ad=0.0651 pd=0.73 as=0.1092 ps=1.36 w=0.42 l=0.15
X1158 VDPWR a_5056_n702# digital_0.input1.X VDPWR sky130_fd_pr__pfet_01v8_hvt ad=0.2726 pd=1.61 as=0.495 ps=2.99 w=1 l=0.15
X1159 digital_0._100_.RESET_B digital_0.load_slew15.X VGND VGND sky130_fd_pr__nfet_01v8 ad=0.08775 pd=0.92 as=0.169 ps=1.82 w=0.65 l=0.15
X1160 a_23562_16564# a_23778_14644# VGND sky130_fd_pr__res_high_po w=0.36 l=7.36
X1161 LELO_GR01_0.x8.x5.Q uo_out<0> VGND VGND sky130_fd_pr__nfet_01v8 ad=0.468 pd=2.84 as=0.468 ps=2.84 w=0.9 l=0.16
X1162 VGND a_9930_930# a_9690_1194# VGND sky130_fd_pr__nfet_01v8 ad=0.1228 pd=1.065 as=0.17225 ps=1.83 w=0.65 l=0.25
X1163 a_18168_16564# a_18384_14644# VGND sky130_fd_pr__res_high_po w=0.36 l=7.36
X1164 VDPWR digital_0.load_slew17.X digital_0._105_.RESET_B VDPWR sky130_fd_pr__pfet_01v8_hvt ad=0.26 pd=2.52 as=0.135 ps=1.27 w=1 l=0.15
X1165 a_7329_778# digital_0._115_.RESET_B VDPWR VDPWR sky130_fd_pr__pfet_01v8_hvt ad=0.1092 pd=1.36 as=0.07035 ps=0.755 w=0.42 l=0.15
X1166 VDPWR a_14861_172# digital_0.output10.A VDPWR sky130_fd_pr__pfet_01v8_hvt ad=0.26 pd=2.52 as=0.135 ps=1.27 w=1 l=0.15
X1167 digital_0.clkbuf_1_1__f_clk.A a_8996_1500# VDPWR VDPWR sky130_fd_pr__pfet_01v8_hvt ad=0.14 pd=1.28 as=0.14 ps=1.28 w=1 l=0.15
X1168 VDPWR a_9151_n702# digital_0._114_.D VDPWR sky130_fd_pr__pfet_01v8_hvt ad=0.22895 pd=1.745 as=0.135 ps=1.27 w=1 l=0.15
X1169 VGND a_12138_n702# a_11898_n518# VGND sky130_fd_pr__nfet_01v8 ad=0.1228 pd=1.065 as=0.17225 ps=1.83 w=0.65 l=0.25
X1170 a_9650_11154# a_9866_9234# VGND sky130_fd_pr__res_high_po w=0.36 l=7.36
X1171 VDPWR a_10997_386# digital_0._060_.A_N VDPWR sky130_fd_pr__pfet_01v8_hvt ad=0.27995 pd=1.615 as=0.165 ps=1.33 w=1 l=0.15
X1172 VDPWR digital_0.clkbuf_1_1__f_clk.A a_11388_956# VDPWR sky130_fd_pr__pfet_01v8_hvt ad=0.14 pd=1.28 as=0.14 ps=1.28 w=1 l=0.15
X1173 digital_0._108_.Q a_7593_2348# VGND VGND sky130_fd_pr__nfet_01v8 ad=0.08775 pd=0.92 as=0.2087 ps=2.02 w=0.65 l=0.15
X1174 VGND digital_0.load_slew17.A digital_0._103_.RESET_B VGND sky130_fd_pr__nfet_01v8 ad=0.169 pd=1.82 as=0.08775 ps=0.92 w=0.65 l=0.15
X1175 LELO_GR01_0.x7.x15.I2 LELO_GR01_0.x7.xd1<4>.A VDPWR VDPWR sky130_fd_pr__pfet_01v8_lvt ad=0.3168 pd=1.62 as=0.5088 ps=2.98 w=0.96 l=0.94
X1176 a_8837_2838# digital_0.load_slew15.A digital_0._108_.RESET_B VDPWR sky130_fd_pr__pfet_01v8_hvt ad=0.135 pd=1.27 as=0.135 ps=1.27 w=1 l=0.15
X1177 a_7772_2410# digital_0._108_.RESET_B VGND VGND sky130_fd_pr__nfet_01v8 ad=0.06405 pd=0.725 as=0.12495 ps=1.015 w=0.42 l=0.15
X1178 a_11452_3498# digital_0._103_.RESET_B VGND VGND sky130_fd_pr__nfet_01v8 ad=0.06405 pd=0.725 as=0.12495 ps=1.015 w=0.42 l=0.15
X1179 VGND ui_in<1> JNWTR_ORX1_CV_0.XA2.A VGND sky130_fd_pr__nfet_01v8 ad=0.468 pd=2.84 as=0.288 ps=1.54 w=0.9 l=0.16
X1180 LELO_GR01_0.x7.x7.S LELO_GR01_0.x7.x6<3>.G LELO_GR01_0.x7.x6<3>.G VGND sky130_fd_pr__nfet_01v8_lvt ad=0.5088 pd=2.98 as=0.3168 ps=1.62 w=0.96 l=0.94
X1181 VDPWR a_9810_412# a_9985_386# VDPWR sky130_fd_pr__pfet_01v8_hvt ad=0.1134 pd=1.38 as=0.0567 ps=0.69 w=0.42 l=0.15
X1182 VGND a_6315_1474# digital_0.clkbuf_1_0__f_clk.X VGND sky130_fd_pr__nfet_01v8 ad=0.0588 pd=0.7 as=0.0588 ps=0.7 w=0.42 l=0.15
X1183 a_6315_1474# digital_0.clkbuf_1_1__f_clk.A VDPWR VDPWR sky130_fd_pr__pfet_01v8_hvt ad=0.14 pd=1.28 as=0.14 ps=1.28 w=1 l=0.15
X1184 VDPWR LELO_GR01_0.x7.xd1<4>.A sky130_fd_pr__cap_mim_m3_1 l=5 w=5
X1185 VGND a_7961_386# a_7895_412# VGND sky130_fd_pr__nfet_01v8 ad=0.12495 pd=1.015 as=0.0669 ps=0.75 w=0.42 l=0.15
X1186 a_10285_2910# digital_0._069_.A VDPWR VDPWR sky130_fd_pr__pfet_01v8_hvt ad=0.173 pd=1.4 as=0.154 ps=1.335 w=0.64 l=0.15
X1187 a_13660_412# digital_0._112_.RESET_B VGND VGND sky130_fd_pr__nfet_01v8 ad=0.06405 pd=0.725 as=0.12495 ps=1.015 w=0.42 l=0.15
X1188 a_14661_1500# digital_0.hold23.X a_14298_1652# VGND sky130_fd_pr__nfet_01v8 ad=0.0693 pd=0.75 as=0.09975 ps=0.895 w=0.42 l=0.15
X1189 VDPWR a_5486_1334# a_5661_1260# VDPWR sky130_fd_pr__pfet_01v8_hvt ad=0.1134 pd=1.38 as=0.0567 ps=0.69 w=0.42 l=0.15
X1190 VGND VDPWR VGND VGND sky130_fd_pr__nfet_01v8 ad=0.143 pd=1.62 as=0 ps=0 w=0.55 l=0.59
X1191 a_12718_3676# a_12501_3676# VGND VGND sky130_fd_pr__nfet_01v8 ad=0.17225 pd=1.83 as=0.1228 ps=1.065 w=0.65 l=0.25
X1192 LELO_GR01_0.x7.x15.I2 LELO_GR01_0.x7.xd1<4>.A VDPWR VDPWR sky130_fd_pr__pfet_01v8_lvt ad=0.3168 pd=1.62 as=0.5088 ps=2.98 w=0.96 l=0.94
X1193 a_3998_3498# digital_0.hold19.X VDPWR VDPWR sky130_fd_pr__pfet_01v8_hvt ad=0.0651 pd=0.73 as=0.1092 ps=1.36 w=0.42 l=0.15
X1194 VGND a_14769_3436# a_14703_3510# VGND sky130_fd_pr__nfet_01v8 ad=0.12495 pd=1.015 as=0.0669 ps=0.75 w=0.42 l=0.15
X1195 a_12189_2588# a_11673_2588# a_12094_2588# VGND sky130_fd_pr__special_nfet_01v8 ad=0.0594 pd=0.69 as=0.066 ps=0.745 w=0.36 l=0.15
X1196 digital_0.load_slew15.X a_8085_1500# VGND VGND sky130_fd_pr__nfet_01v8 ad=0.08775 pd=0.92 as=0.08775 ps=0.92 w=0.65 l=0.15
X1197 a_10655_2422# a_9465_2050# a_10546_2422# VGND sky130_fd_pr__special_nfet_01v8 ad=0.0669 pd=0.75 as=0.0711 ps=0.755 w=0.36 l=0.15
X1198 VGND digital_0.clkbuf_1_1__f_clk.A a_6315_1474# VGND sky130_fd_pr__nfet_01v8 ad=0.1113 pd=1.37 as=0.0588 ps=0.7 w=0.42 l=0.15
X1199 a_8132_2954# a_7055_2588# a_7970_2588# VDPWR sky130_fd_pr__pfet_01v8_hvt ad=0.0567 pd=0.69 as=0.0588 ps=0.7 w=0.42 l=0.15
X1200 a_26374_16564# a_26590_14644# VGND sky130_fd_pr__res_high_po w=0.36 l=7.36
X1201 VGND a_3492_n702# JNWTR_ORX1_CV_0.A VGND sky130_fd_pr__nfet_01v8 ad=0.1856 pd=1.26 as=0.2079 ps=1.83 w=0.42 l=0.15
X1202 a_4438_386# digital_0.clkbuf_1_0__f_clk.X VGND VGND sky130_fd_pr__nfet_01v8 ad=0.1092 pd=1.36 as=0.0567 ps=0.69 w=0.42 l=0.15
X1203 VDPWR a_8996_1500# digital_0.clkbuf_1_1__f_clk.A VDPWR sky130_fd_pr__pfet_01v8_hvt ad=0.14 pd=1.28 as=0.14 ps=1.28 w=1 l=0.15
X1204 VDPWR VGND VDPWR VDPWR sky130_fd_pr__pfet_01v8_hvt ad=0.2262 pd=2.26 as=0 ps=0 w=0.87 l=0.59
X1205 a_5882_6824# a_5666_4904# VGND sky130_fd_pr__res_high_po w=0.36 l=7.36
X1206 VGND a_7157_n158# a_7088_n132# VGND sky130_fd_pr__nfet_01v8 ad=0.1346 pd=1.15 as=0.0999 ps=0.985 w=0.64 l=0.15
X1207 VDPWR VGND VDPWR VDPWR sky130_fd_pr__pfet_01v8_hvt ad=0.2262 pd=2.26 as=0 ps=0 w=0.87 l=0.59
X1208 a_9557_2838# digital_0._116_.Q VDPWR VDPWR sky130_fd_pr__pfet_01v8_hvt ad=0.135 pd=1.27 as=0.135 ps=1.27 w=1 l=0.15
X1209 VDPWR VGND VDPWR VDPWR sky130_fd_pr__pfet_01v8_hvt ad=0.2262 pd=2.26 as=0 ps=0 w=0.87 l=0.59
X1210 digital_0.clkload0.A a_11388_956# VGND VGND sky130_fd_pr__nfet_01v8 ad=0.0588 pd=0.7 as=0.0588 ps=0.7 w=0.42 l=0.15
X1211 VDPWR a_6315_1474# digital_0.clkbuf_1_0__f_clk.X VDPWR sky130_fd_pr__pfet_01v8_hvt ad=0.14 pd=1.28 as=0.14 ps=1.28 w=1 l=0.15
X1212 VGND a_4425_2730# a_4386_2856# VGND sky130_fd_pr__nfet_01v8 ad=0.0567 pd=0.69 as=0.1092 ps=1.36 w=0.42 l=0.15
X1213 a_5834_2740# digital_0.hold25.X a_5976_2915# VDPWR sky130_fd_pr__pfet_01v8_hvt ad=0.1932 pd=1.34 as=0.07665 ps=0.785 w=0.42 l=0.15
X1214 a_5422_n702# uo_out<0> VGND VGND sky130_fd_pr__nfet_01v8 ad=0.1134 pd=1.38 as=0.1228 ps=1.065 w=0.42 l=0.15
X1215 a_12391_1500# a_12225_1500# VGND VGND sky130_fd_pr__nfet_01v8 ad=0.1092 pd=1.36 as=0.0567 ps=0.69 w=0.42 l=0.15
X1216 VGND digital_0._100_.D a_5144_2954# VGND sky130_fd_pr__nfet_01v8 ad=0.2205 pd=1.89 as=0.066 ps=0.745 w=0.42 l=0.15
X1217 VDPWR digital_0._100_.D a_5144_2954# VDPWR sky130_fd_pr__pfet_01v8_hvt ad=0.1092 pd=1.36 as=0.0651 ps=0.73 w=0.42 l=0.15
X1218 a_7467_234# a_7088_n132# a_7395_234# VGND sky130_fd_pr__nfet_01v8 ad=0.1401 pd=1.1 as=0.0441 ps=0.63 w=0.42 l=0.15
X1219 VDPWR a_4369_1474# a_4111_1474# VDPWR sky130_fd_pr__pfet_01v8_hvt ad=0.0567 pd=0.69 as=0.1092 ps=1.36 w=0.42 l=0.5
X1220 VGND a_11835_3828# digital_0.hold20.X VGND sky130_fd_pr__nfet_01v8 ad=0.097 pd=0.975 as=0.169 ps=1.82 w=0.65 l=0.15
X1221 a_11415_3650# digital_0.hold28.A VGND VGND sky130_fd_pr__nfet_01v8 ad=0.1092 pd=1.36 as=0.1449 ps=1.11 w=0.42 l=0.15
X1222 VDPWR VGND VDPWR VDPWR sky130_fd_pr__pfet_01v8_hvt ad=0.2262 pd=2.26 as=0 ps=0 w=0.87 l=0.59
X1223 VDPWR VGND VDPWR VDPWR sky130_fd_pr__pfet_01v8_hvt ad=0.2262 pd=2.26 as=0 ps=0 w=0.87 l=0.59
X1224 digital_0._114_.RESET_B digital_0._116_.Q VGND VGND sky130_fd_pr__nfet_01v8 ad=0.08775 pd=0.92 as=0.182 ps=1.86 w=0.65 l=0.15
X1225 VGND digital_0._115_.Q a_7155_930# VGND sky130_fd_pr__nfet_01v8 ad=0.17875 pd=1.85 as=0.08775 ps=0.92 w=0.65 l=0.15
X1226 VDPWR a_3492_n702# JNWTR_ORX1_CV_0.A VDPWR sky130_fd_pr__pfet_01v8_hvt ad=0.2726 pd=1.61 as=0.495 ps=2.99 w=1 l=0.15
X1227 LELO_GR01_0.x8.x5.XA5.A LELO_GR01_0.x8.x5.XA7.CN LELO_GR01_0.x8.x5.XA4.MN1.S VGND sky130_fd_pr__nfet_01v8 ad=0.468 pd=2.84 as=0.288 ps=1.54 w=0.9 l=0.16
X1228 VGND digital_0.hold28.A a_13110_3498# VGND sky130_fd_pr__nfet_01v8 ad=0.11285 pd=1.045 as=0.0693 ps=0.75 w=0.42 l=0.15
X1229 a_12889_3171# digital_0.hold24.X a_12889_3498# VGND sky130_fd_pr__nfet_01v8 ad=0.09975 pd=0.895 as=0.0693 ps=0.75 w=0.42 l=0.15
X1230 a_5422_n702# uo_out<0> VDPWR VDPWR sky130_fd_pr__pfet_01v8_hvt ad=0.27 pd=2.54 as=0.19265 ps=1.415 w=1 l=0.15
X1231 VGND ui_in<1> sky130_fd_pr__diode_pw2nd_05v5 perim=1.8e+06 area=2.025e+11
X1232 a_14121_246# a_13771_n126# a_14026_234# VDPWR sky130_fd_pr__pfet_01v8_hvt ad=0.07245 pd=0.765 as=0.0651 ps=0.73 w=0.42 l=0.15
X1233 digital_0._113_.D digital_0._063_.A a_12116_188# VGND sky130_fd_pr__nfet_01v8 ad=0.10563 pd=0.975 as=0.08775 ps=0.92 w=0.65 l=0.15
X1234 VDPWR VGND VDPWR VDPWR sky130_fd_pr__pfet_01v8_hvt ad=0.2262 pd=2.26 as=0 ps=0 w=0.87 l=0.59
X1235 digital_0.clkload0.A a_11388_956# VDPWR VDPWR sky130_fd_pr__pfet_01v8_hvt ad=0.14 pd=1.28 as=0.14 ps=1.28 w=1 l=0.15
X1236 a_14673_3650# digital_0.output7.A VDPWR VDPWR sky130_fd_pr__pfet_01v8_hvt ad=0.1092 pd=1.36 as=0.0567 ps=0.69 w=0.42 l=0.15
X1237 a_14175_n702# digital_0.hold28.A VDPWR VDPWR sky130_fd_pr__pfet_01v8_hvt ad=0.1176 pd=1.4 as=0.0693 ps=0.75 w=0.42 l=0.15
X1238 a_5882_6824# a_6098_4904# VGND sky130_fd_pr__res_high_po w=0.36 l=7.36
X1239 a_14298_1652# digital_0.hold23.X a_14440_1827# VDPWR sky130_fd_pr__pfet_01v8_hvt ad=0.1932 pd=1.34 as=0.07665 ps=0.785 w=0.42 l=0.15
X1240 VDPWR a_7623_2830# a_7513_2954# VDPWR sky130_fd_pr__pfet_01v8_hvt ad=0.07035 pd=0.755 as=0.1155 ps=0.97 w=0.42 l=0.15
X1241 a_14229_n132# a_13605_n126# a_14121_246# VDPWR sky130_fd_pr__pfet_01v8_hvt ad=0.1155 pd=0.97 as=0.07245 ps=0.765 w=0.42 l=0.15
X1242 VGND a_11388_956# digital_0.clkload0.A VGND sky130_fd_pr__nfet_01v8 ad=0.0588 pd=0.7 as=0.0588 ps=0.7 w=0.42 l=0.15
X1243 a_10639_1276# digital_0._065_.A2_N VGND VGND sky130_fd_pr__nfet_01v8 ad=0.08775 pd=0.92 as=0.08775 ps=0.92 w=0.65 l=0.15
X1244 VDPWR a_3821_2562# digital_0.output5.A VDPWR sky130_fd_pr__pfet_01v8_hvt ad=0.3012 pd=2.66 as=0.135 ps=1.27 w=1 l=0.15
X1245 a_7071_2018# a_6853_2422# VGND VGND sky130_fd_pr__nfet_01v8 ad=0.0999 pd=0.985 as=0.1346 ps=1.15 w=0.64 l=0.15
X1246 a_10708_n132# a_9631_n126# a_10546_246# VDPWR sky130_fd_pr__pfet_01v8_hvt ad=0.0567 pd=0.69 as=0.0588 ps=0.7 w=0.42 l=0.15
X1247 VGND LELO_GR01_0.x8.PWRUP_N_1V8 LELO_GR01_0.x8.IBP_BG VGND sky130_fd_pr__nfet_01v8_lvt ad=0.5088 pd=2.98 as=0.3168 ps=1.62 w=0.96 l=0.94
X1248 a_10997_386# digital_0._112_.Q a_11478_412# VGND sky130_fd_pr__nfet_01v8 ad=0.1092 pd=1.36 as=0.06195 ps=0.715 w=0.42 l=0.15
X1249 VGND a_14762_2018# digital_0.load_slew17.X VGND sky130_fd_pr__nfet_01v8 ad=0.097 pd=0.975 as=0.08775 ps=0.92 w=0.65 l=0.15
X1250 VGND digital_0.output13.A a_6235_3106# VGND sky130_fd_pr__nfet_01v8 ad=0.17875 pd=1.85 as=0.08775 ps=0.92 w=0.65 l=0.15
X1251 digital_0._102_.RESET_B digital_0.load_slew17.A VDPWR VDPWR sky130_fd_pr__pfet_01v8_hvt ad=0.135 pd=1.27 as=0.26 ps=2.52 w=1 l=0.15
X1252 a_25702_13064# a_25486_11144# VGND sky130_fd_pr__res_high_po w=0.36 l=7.36
X1253 a_9548_6824# a_9332_4904# VGND sky130_fd_pr__res_high_po w=0.36 l=7.36
X1254 a_4765_n158# a_4609_110# a_4910_n132# VDPWR sky130_fd_pr__pfet_01v8_hvt ad=0.07245 pd=0.765 as=0.1155 ps=0.97 w=0.42 l=0.15
X1255 VDPWR digital_0._060_.A_N a_7099_956# VDPWR sky130_fd_pr__pfet_01v8_hvt ad=0.1625 pd=1.325 as=0.26 ps=2.52 w=1 l=0.15
X1256 a_7895_412# a_6705_412# a_7786_412# VGND sky130_fd_pr__special_nfet_01v8 ad=0.0669 pd=0.75 as=0.0711 ps=0.755 w=0.36 l=0.15
X1257 a_14440_1827# digital_0.hold28.A VDPWR VDPWR sky130_fd_pr__pfet_01v8_hvt ad=0.07665 pd=0.785 as=0.15835 ps=1.395 w=0.42 l=0.15
X1258 a_8578_n132# a_8361_n132# VGND VGND sky130_fd_pr__nfet_01v8 ad=0.17225 pd=1.83 as=0.1228 ps=1.065 w=0.65 l=0.25
X1259 VGND a_5109_2348# a_5043_2422# VGND sky130_fd_pr__nfet_01v8 ad=0.12495 pd=1.015 as=0.0669 ps=0.75 w=0.42 l=0.15
X1260 digital_0._060_.B a_10253_930# VGND VGND sky130_fd_pr__nfet_01v8 ad=0.08775 pd=0.92 as=0.169 ps=1.82 w=0.65 l=0.15
X1261 VDPWR a_14673_3650# a_14415_3650# VDPWR sky130_fd_pr__pfet_01v8_hvt ad=0.0567 pd=0.69 as=0.1092 ps=1.36 w=0.42 l=0.5
X1262 VGND a_6397_n158# digital_0.output12.A VGND sky130_fd_pr__nfet_01v8 ad=0.2087 pd=2.02 as=0.08775 ps=0.92 w=0.65 l=0.15
X1263 a_10199_2018# a_9981_2422# VDPWR VDPWR sky130_fd_pr__pfet_01v8_hvt ad=0.12915 pd=1.185 as=0.2184 ps=2.2 w=0.84 l=0.15
X1264 digital_0._111_.Q a_10721_2348# VDPWR VDPWR sky130_fd_pr__pfet_01v8_hvt ad=0.135 pd=1.27 as=0.3012 ps=2.66 w=1 l=0.15
X1265 digital_0._069_.B digital_0._109_.Q a_7349_3132# VDPWR sky130_fd_pr__pfet_01v8_hvt ad=0.135 pd=1.27 as=0.135 ps=1.27 w=1 l=0.15
X1266 VGND a_11273_3436# digital_0.output8.A VGND sky130_fd_pr__nfet_01v8 ad=0.169 pd=1.82 as=0.08775 ps=0.92 w=0.65 l=0.15
X1267 VDPWR a_13481_386# a_13468_778# VDPWR sky130_fd_pr__pfet_01v8_hvt ad=0.0819 pd=0.81 as=0.0567 ps=0.69 w=0.42 l=0.15
X1268 a_4015_1652# a_4111_1474# VDPWR VDPWR sky130_fd_pr__pfet_01v8_hvt ad=0.1092 pd=1.36 as=0.14075 ps=1.325 w=0.42 l=0.5
X1269 VDPWR a_11415_3650# a_11445_4003# VDPWR sky130_fd_pr__pfet_01v8_hvt ad=0.0693 pd=0.75 as=0.0441 ps=0.63 w=0.42 l=0.15
X1270 VDPWR digital_0.load_slew15.X digital_0._100_.RESET_B VDPWR sky130_fd_pr__pfet_01v8_hvt ad=0.26 pd=2.52 as=0.135 ps=1.27 w=1 l=0.15
X1271 a_5834_2740# digital_0._108_.Q a_5976_2588# VGND sky130_fd_pr__nfet_01v8 ad=0.09975 pd=0.895 as=0.0693 ps=0.75 w=0.42 l=0.15
X1272 VGND LELO_GR01_0.x8.PWRUP_N_1V8 LELO_GR01_0.x8.x1.x5.x9<2>.G VGND sky130_fd_pr__nfet_01v8_lvt ad=0.5088 pd=2.98 as=0.3168 ps=1.62 w=0.96 l=0.94
X1273 VGND a_11107_2562# digital_0._067_.A VGND sky130_fd_pr__nfet_01v8 ad=0.1118 pd=1.04 as=0.12675 ps=1.04 w=0.65 l=0.15
X1274 VDPWR digital_0.hold28.A a_13103_3171# VDPWR sky130_fd_pr__pfet_01v8_hvt ad=0.15835 pd=1.395 as=0.07665 ps=0.785 w=0.42 l=0.15
X1275 digital_0.output13.A a_5661_1260# VDPWR VDPWR sky130_fd_pr__pfet_01v8_hvt ad=0.135 pd=1.27 as=0.3012 ps=2.66 w=1 l=0.15
X1276 VGND VDPWR VGND VGND sky130_fd_pr__nfet_01v8 ad=0.143 pd=1.62 as=0 ps=0 w=0.55 l=0.59
X1277 VGND digital_0._107_.D a_7720_n132# VGND sky130_fd_pr__nfet_01v8 ad=0.2205 pd=1.89 as=0.066 ps=0.745 w=0.42 l=0.15
X1278 LELO_GR01_0.x8.IBP_BG VGND sky130_fd_pr__cap_mim_m3_1 l=5 w=5
X1279 VDPWR a_3982_386# a_4118_412# VDPWR sky130_fd_pr__pfet_01v8_hvt ad=0.12075 pd=1.165 as=0.2226 ps=2.21 w=0.84 l=0.15
X1280 a_7643_n702# digital_0.hold28.A VDPWR VDPWR sky130_fd_pr__pfet_01v8_hvt ad=0.1176 pd=1.4 as=0.0693 ps=0.75 w=0.42 l=0.15
X1281 VDPWR a_8085_1500# digital_0.load_slew15.X VDPWR sky130_fd_pr__pfet_01v8_hvt ad=0.135 pd=1.27 as=0.135 ps=1.27 w=1 l=0.15
X1282 a_3858_n702# digital_0.output13.A VGND VGND sky130_fd_pr__nfet_01v8 ad=0.1134 pd=1.38 as=0.1228 ps=1.065 w=0.42 l=0.15
X1283 VDPWR a_7786_412# a_7961_386# VDPWR sky130_fd_pr__pfet_01v8_hvt ad=0.1134 pd=1.38 as=0.0567 ps=0.69 w=0.42 l=0.15
X1284 VGND VDPWR VGND VGND sky130_fd_pr__nfet_01v8 ad=0.143 pd=1.62 as=0 ps=0 w=0.55 l=0.59
X1285 a_5328_n132# a_4570_n16# a_4765_n158# VDPWR sky130_fd_pr__pfet_01v8_hvt ad=0.0651 pd=0.73 as=0.07245 ps=0.765 w=0.42 l=0.15
X1286 digital_0.clkload0.A a_11388_956# VGND VGND sky130_fd_pr__nfet_01v8 ad=0.0588 pd=0.7 as=0.05775 ps=0.695 w=0.42 l=0.15
X1287 a_19032_16564# a_18816_14644# VGND sky130_fd_pr__res_high_po w=0.36 l=7.36
X1288 VDPWR a_10628_4904# VGND sky130_fd_pr__res_high_po w=0.36 l=7.36
X1289 a_14673_1334# a_14323_962# a_14578_1322# VDPWR sky130_fd_pr__pfet_01v8_hvt ad=0.07245 pd=0.765 as=0.0651 ps=0.73 w=0.42 l=0.15
X1290 a_6871_412# a_6705_412# VGND VGND sky130_fd_pr__nfet_01v8 ad=0.1092 pd=1.36 as=0.0567 ps=0.69 w=0.42 l=0.15
X1291 VDPWR digital_0.output9.A a_15445_2044# VDPWR sky130_fd_pr__pfet_01v8_hvt ad=0.19265 pd=1.415 as=0.27 ps=2.54 w=1 l=0.15
X1292 a_22470_13064# a_22686_11144# VGND sky130_fd_pr__res_high_po w=0.36 l=7.36
X1293 a_11835_3828# a_11931_3650# VGND VGND sky130_fd_pr__nfet_01v8 ad=0.1092 pd=1.36 as=0.097 ps=0.975 w=0.42 l=0.5
X1294 VDPWR a_4730_1652# digital_0._101_.D VDPWR sky130_fd_pr__pfet_01v8_hvt ad=0.15835 pd=1.395 as=0.26 ps=2.52 w=1 l=0.15
X1295 VGND digital_0._112_.Q digital_0._063_.B VGND sky130_fd_pr__nfet_01v8 ad=0.26 pd=2.1 as=0.08775 ps=0.92 w=0.65 l=0.15
X1296 a_10546_2422# a_9465_2050# a_10199_2018# VDPWR sky130_fd_pr__pfet_01v8_hvt ad=0.0588 pd=0.7 as=0.12915 ps=1.185 w=0.42 l=0.15
X1297 VGND a_6315_1474# digital_0.clkbuf_1_0__f_clk.X VGND sky130_fd_pr__nfet_01v8 ad=0.0588 pd=0.7 as=0.0588 ps=0.7 w=0.42 l=0.15
X1298 a_5093_1500# digital_0.hold22.X a_4730_1652# VGND sky130_fd_pr__nfet_01v8 ad=0.0693 pd=0.75 as=0.09975 ps=0.895 w=0.42 l=0.15
X1299 a_13103_3171# digital_0.hold24.X a_12889_3171# VDPWR sky130_fd_pr__pfet_01v8_hvt ad=0.07665 pd=0.785 as=0.1932 ps=1.34 w=0.42 l=0.15
X1300 a_4872_1500# digital_0.hold28.A VGND VGND sky130_fd_pr__nfet_01v8 ad=0.0693 pd=0.75 as=0.11285 ps=1.045 w=0.42 l=0.15
X1301 VGND VDPWR VGND VGND sky130_fd_pr__nfet_01v8 ad=0.143 pd=1.62 as=0 ps=0 w=0.55 l=0.59
X1302 VDPWR a_13306_412# a_13481_386# VDPWR sky130_fd_pr__pfet_01v8_hvt ad=0.1134 pd=1.38 as=0.0567 ps=0.69 w=0.42 l=0.15
X1303 a_12646_412# digital_0._112_.D VDPWR VDPWR sky130_fd_pr__pfet_01v8_hvt ad=0.0651 pd=0.73 as=0.1092 ps=1.36 w=0.42 l=0.15
X1304 a_5840_1322# digital_0._118_.RESET_B VGND VGND sky130_fd_pr__nfet_01v8 ad=0.06405 pd=0.725 as=0.12495 ps=1.015 w=0.42 l=0.15
X1305 LELO_GR01_0.x7.x1.x5.x8.S a_10472_18216# VGND sky130_fd_pr__res_high_po w=0.36 l=7.36
X1306 VDPWR a_6315_1474# digital_0.clkbuf_1_0__f_clk.X VDPWR sky130_fd_pr__pfet_01v8_hvt ad=0.14 pd=1.28 as=0.14 ps=1.28 w=1 l=0.15
X1307 digital_0._069_.A a_5787_2146# VGND VGND sky130_fd_pr__nfet_01v8 ad=0.08775 pd=0.92 as=0.1304 ps=1.105 w=0.65 l=0.15
X1308 VDPWR VGND VDPWR VDPWR sky130_fd_pr__pfet_01v8_hvt ad=0.2262 pd=2.26 as=0 ps=0 w=0.87 l=0.59
X1309 VGND a_11758_188# digital_0._113_.D VGND sky130_fd_pr__nfet_01v8 ad=0.169 pd=1.82 as=0.08775 ps=0.92 w=0.65 l=0.15
X1310 a_3858_n702# digital_0.output13.A VDPWR VDPWR sky130_fd_pr__pfet_01v8_hvt ad=0.27 pd=2.54 as=0.19265 ps=1.415 w=1 l=0.15
X1311 digital_0._116_.D a_5974_n676# VGND VGND sky130_fd_pr__nfet_01v8 ad=0.091 pd=0.93 as=0.1105 ps=0.99 w=0.65 l=0.15
X1312 a_11349_3676# digital_0.hold20.X a_10986_3828# VGND sky130_fd_pr__nfet_01v8 ad=0.0693 pd=0.75 as=0.09975 ps=0.895 w=0.42 l=0.15
X1313 LELO_GR01_0.x8.x1.x5.x8.G LELO_GR01_0.x8.x1.x5.x8.G LELO_GR01_0.x8.x1.x5.x8.S LELO_GR01_0.x8.x1.x5.x8.S sky130_fd_pr__pfet_01v8_lvt ad=0.3168 pd=1.62 as=0.5088 ps=2.98 w=0.96 l=0.94
X1314 LELO_GR01_0.x8.x5.XA7.MN0.S VDPWR VGND VGND sky130_fd_pr__nfet_01v8 ad=0.288 pd=1.54 as=0.468 ps=2.84 w=0.9 l=0.16
X1315 a_10495_n702# digital_0.hold28.A VDPWR VDPWR sky130_fd_pr__pfet_01v8_hvt ad=0.1176 pd=1.4 as=0.0693 ps=0.75 w=0.42 l=0.15
X1316 a_12977_2044# digital_0._116_.Q VDPWR VDPWR sky130_fd_pr__pfet_01v8_hvt ad=0.28 pd=2.56 as=0.135 ps=1.27 w=1 l=0.15
X1317 a_4425_2730# digital_0.clkbuf_1_0__f_clk.X VDPWR VDPWR sky130_fd_pr__pfet_01v8_hvt ad=0.1664 pd=1.8 as=0.0864 ps=0.91 w=0.64 l=0.15
X1318 LELO_GR01_0.x7.x7.G a_10730_9234# VGND sky130_fd_pr__res_high_po w=0.36 l=7.36
X1319 digital_0._116_.SET_B digital_0.load_slew15.X VGND VGND sky130_fd_pr__nfet_01v8 ad=0.08775 pd=0.92 as=0.169 ps=1.82 w=0.65 l=0.15
X1320 VDPWR a_8996_1500# digital_0.clkbuf_1_1__f_clk.A VDPWR sky130_fd_pr__pfet_01v8_hvt ad=0.14 pd=1.28 as=0.14 ps=1.28 w=1 l=0.15
X1321 VGND digital_0.load_slew17.X digital_0._115_.RESET_B VGND sky130_fd_pr__nfet_01v8 ad=0.169 pd=1.82 as=0.08775 ps=0.92 w=0.65 l=0.15
X1322 a_8996_1500# clk VGND VGND sky130_fd_pr__nfet_01v8 ad=0.0588 pd=0.7 as=0.0588 ps=0.7 w=0.42 l=0.15
X1323 LELO_GR01_0.x8.x5.XA7.MP1.S LELO_GR01_0.x8.x5.Q LELO_GR01_0.x8.x8.D LELO_GR01_0.x8.x8.D sky130_fd_pr__pfet_01v8 ad=0.288 pd=1.54 as=0.288 ps=1.54 w=0.9 l=0.16
X1324 VGND digital_0.input1.X a_6337_2050# VGND sky130_fd_pr__nfet_01v8 ad=0.0567 pd=0.69 as=0.1092 ps=1.36 w=0.42 l=0.15
X1325 VGND digital_0.clkload0.A a_10017_3138# VGND sky130_fd_pr__nfet_01v8 ad=0.0567 pd=0.69 as=0.1092 ps=1.36 w=0.42 l=0.15
X1326 VGND a_7001_110# a_6962_n16# VGND sky130_fd_pr__nfet_01v8 ad=0.0567 pd=0.69 as=0.1092 ps=1.36 w=0.42 l=0.15
X1327 a_15238_1334# a_14323_962# a_14891_930# VGND sky130_fd_pr__special_nfet_01v8 ad=0.0711 pd=0.755 as=0.0999 ps=0.985 w=0.36 l=0.15
X1328 a_5450_6824# a_5666_4904# VGND sky130_fd_pr__res_high_po w=0.36 l=7.36
X1329 digital_0._110_.D digital_0._067_.B VGND VGND sky130_fd_pr__nfet_01v8 ad=0.08775 pd=0.92 as=0.08775 ps=0.92 w=0.65 l=0.15
X1330 a_9985_386# digital_0._114_.RESET_B VDPWR VDPWR sky130_fd_pr__pfet_01v8_hvt ad=0.0567 pd=0.69 as=0.0819 ps=0.81 w=0.42 l=0.15
X1331 a_15225_n702# digital_0.output10.A VDPWR VDPWR sky130_fd_pr__pfet_01v8_hvt ad=0.1092 pd=1.36 as=0.0567 ps=0.69 w=0.42 l=0.15
X1332 VDPWR a_11388_956# digital_0.clkload0.A VDPWR sky130_fd_pr__pfet_01v8_hvt ad=0.1375 pd=1.275 as=0.14 ps=1.28 w=1 l=0.15
X1333 VDPWR a_4658_3510# a_4833_3436# VDPWR sky130_fd_pr__pfet_01v8_hvt ad=0.1134 pd=1.38 as=0.0567 ps=0.69 w=0.42 l=0.15
X1334 VDPWR a_10986_3828# digital_0._103_.D VDPWR sky130_fd_pr__pfet_01v8_hvt ad=0.15835 pd=1.395 as=0.26 ps=2.52 w=1 l=0.15
X1335 a_14891_930# a_14673_1334# VDPWR VDPWR sky130_fd_pr__pfet_01v8_hvt ad=0.12915 pd=1.185 as=0.2184 ps=2.2 w=0.84 l=0.15
X1336 a_9985_386# a_9810_412# a_10164_412# VGND sky130_fd_pr__nfet_01v8 ad=0.1092 pd=1.36 as=0.06405 ps=0.725 w=0.42 l=0.15
X1337 digital_0._110_.RESET_B digital_0._116_.Q VGND VGND sky130_fd_pr__nfet_01v8 ad=0.08775 pd=0.92 as=0.08775 ps=0.92 w=0.65 l=0.15
X1338 VDPWR a_12903_206# digital_0._057_.D VDPWR sky130_fd_pr__pfet_01v8_hvt ad=0.38 pd=2.76 as=0.195 ps=1.39 w=1 l=0.15
X1339 VGND VDPWR VGND VGND sky130_fd_pr__nfet_01v8 ad=0.143 pd=1.62 as=0 ps=0 w=0.55 l=0.59
X1340 LELO_GR01_0.x7.x1.x5.x8.G LELO_GR01_0.x7.x1.x5.x8.G LELO_GR01_0.x7.x1.x5.x8.S LELO_GR01_0.x7.x1.x5.x8.S sky130_fd_pr__pfet_01v8_lvt ad=0.3168 pd=1.62 as=0.5088 ps=2.98 w=0.96 l=0.94
X1341 digital_0.clkbuf_1_0__f_clk.X a_6315_1474# VGND VGND sky130_fd_pr__nfet_01v8 ad=0.0588 pd=0.7 as=0.0588 ps=0.7 w=0.42 l=0.15
X1342 digital_0._067_.A a_11107_2562# VGND VGND sky130_fd_pr__nfet_01v8 ad=0.12675 pd=1.04 as=0.247 ps=2.06 w=0.65 l=0.15
X1343 a_5486_1334# a_4405_962# a_5139_930# VDPWR sky130_fd_pr__pfet_01v8_hvt ad=0.0588 pd=0.7 as=0.12915 ps=1.185 w=0.42 l=0.15
X1344 LELO_GR01_0.x8.x7.D LELO_GR01_0.x8.PWRUP_N_1V8 VGND VGND sky130_fd_pr__nfet_01v8_lvt ad=0.3168 pd=1.62 as=0.5088 ps=2.98 w=0.96 l=0.94
R6 uio_oe<2> JNWTR_TIEL_CV_0.Y sky130_fd_pr__res_generic_m4 w=0.3 l=0.3
X1345 a_4610_386# a_4438_386# a_5014_778# VDPWR sky130_fd_pr__pfet_01v8_hvt ad=0.0567 pd=0.69 as=0.0945 ps=0.87 w=0.42 l=0.15
X1346 VGND a_13481_1474# a_13415_1500# VGND sky130_fd_pr__nfet_01v8 ad=0.12495 pd=1.015 as=0.0669 ps=0.75 w=0.42 l=0.15
X1347 a_10082_11154# a_9866_9234# VGND sky130_fd_pr__res_high_po w=0.36 l=7.36
X1348 LELO_GR01_0.x8.x5.CK LELO_GR01_0.x8.x3.A VGND VGND sky130_fd_pr__nfet_01v8 ad=0.468 pd=2.84 as=0.468 ps=2.84 w=0.9 l=0.16
X1349 VGND a_4438_386# a_4530_626# VGND sky130_fd_pr__nfet_01v8 ad=0.0567 pd=0.69 as=0.1092 ps=1.36 w=0.42 l=0.15
X1350 digital_0.clkbuf_1_0__f_clk.X a_6315_1474# VDPWR VDPWR sky130_fd_pr__pfet_01v8_hvt ad=0.14 pd=1.28 as=0.14 ps=1.28 w=1 l=0.15
X1351 digital_0._111_.D a_10074_2562# VGND VGND sky130_fd_pr__nfet_01v8 ad=0.08775 pd=0.92 as=0.18525 ps=1.87 w=0.65 l=0.15
X1352 digital_0._116_.Q a_3814_386# VGND VGND sky130_fd_pr__nfet_01v8 ad=0.08775 pd=0.92 as=0.169 ps=1.82 w=0.65 l=0.15
X1353 a_5075_234# a_4696_n132# a_5003_234# VGND sky130_fd_pr__nfet_01v8 ad=0.1401 pd=1.1 as=0.0441 ps=0.63 w=0.42 l=0.15
X1354 VDPWR digital_0._110_.Q a_11107_2562# VDPWR sky130_fd_pr__pfet_01v8_hvt ad=0.1176 pd=1.4 as=0.0567 ps=0.69 w=0.42 l=0.15
X1355 VGND VDPWR VGND VGND sky130_fd_pr__nfet_01v8 ad=0.143 pd=1.62 as=0 ps=0 w=0.55 l=0.59
X1356 a_16872_16564# a_17088_14644# VGND sky130_fd_pr__res_high_po w=0.36 l=7.36
X1357 VGND VDPWR VGND VGND sky130_fd_pr__nfet_01v8 ad=0.143 pd=1.62 as=0 ps=0 w=0.55 l=0.59
X1358 a_12837_1500# a_12391_1500# a_12741_1500# VGND sky130_fd_pr__special_nfet_01v8 ad=0.1401 pd=1.1 as=0.0594 ps=0.69 w=0.36 l=0.15
X1359 LELO_GR01_0.x7.x26.P a_27854_11144# VGND sky130_fd_pr__res_high_po w=0.36 l=7.36
X1360 VGND VDPWR VGND VGND sky130_fd_pr__nfet_01v8 ad=0.143 pd=1.62 as=0 ps=0 w=0.55 l=0.59
X1361 digital_0.output4.A a_4005_n158# VDPWR VDPWR sky130_fd_pr__pfet_01v8_hvt ad=0.135 pd=1.27 as=0.26 ps=2.52 w=1 l=0.15
X1362 VDPWR digital_0.input1.X a_12225_1500# VDPWR sky130_fd_pr__pfet_01v8_hvt ad=0.0864 pd=0.91 as=0.1664 ps=1.8 w=0.64 l=0.15
X1363 digital_0.clkbuf_1_1__f_clk.A a_8996_1500# VDPWR VDPWR sky130_fd_pr__pfet_01v8_hvt ad=0.14 pd=1.28 as=0.14 ps=1.28 w=1 l=0.15
X1364 VGND a_4228_3650# uo_out<1> VGND sky130_fd_pr__nfet_01v8 ad=0.1856 pd=1.26 as=0.2079 ps=1.83 w=0.42 l=0.15
X1365 LELO_GR01_0.x7.x1.x7.D LELO_GR01_0.PWRUP_1V8 VDPWR VDPWR sky130_fd_pr__pfet_01v8_lvt ad=0.3168 pd=1.62 as=0.5088 ps=2.98 w=0.96 l=0.94
X1366 a_5974_n676# digital_0.hold18.X a_5785_n426# VDPWR sky130_fd_pr__pfet_01v8_hvt ad=0.265 pd=2.53 as=0.14 ps=1.28 w=1 l=0.15
R7 uio_oe<4> JNWTR_TIEL_CV_0.Y sky130_fd_pr__res_generic_m4 w=0.3 l=0.3
X1367 a_5109_2348# digital_0._101_.RESET_B VDPWR VDPWR sky130_fd_pr__pfet_01v8_hvt ad=0.0567 pd=0.69 as=0.0819 ps=0.81 w=0.42 l=0.15
X1368 VDPWR digital_0._107_.RESET_B a_6397_n158# VDPWR sky130_fd_pr__pfet_01v8_hvt ad=0.0819 pd=0.81 as=0.0567 ps=0.69 w=0.42 l=0.15
X1369 VDPWR VGND VDPWR VDPWR sky130_fd_pr__pfet_01v8_hvt ad=0.2262 pd=2.26 as=0 ps=0 w=0.87 l=0.59
X1370 a_9810_412# a_8729_412# a_9463_654# VDPWR sky130_fd_pr__pfet_01v8_hvt ad=0.0588 pd=0.7 as=0.12915 ps=1.185 w=0.42 l=0.15
X1371 VGND VDPWR VGND VGND sky130_fd_pr__nfet_01v8 ad=0.143 pd=1.62 as=0 ps=0 w=0.55 l=0.59
X1372 a_8252_6824# a_8036_4904# VGND sky130_fd_pr__res_high_po w=0.36 l=7.36
X1373 uio_out<4> a_15773_2044# VDPWR VDPWR sky130_fd_pr__pfet_01v8_hvt ad=0.495 pd=2.99 as=0.2726 ps=1.61 w=1 l=0.15
X1374 VGND digital_0._110_.Q digital_0._067_.B VGND sky130_fd_pr__nfet_01v8 ad=0.182 pd=1.86 as=0.08775 ps=0.92 w=0.65 l=0.15
X1375 LELO_GR01_0.x8.x1.x5.x8.S a_22292_9915# VGND sky130_fd_pr__res_high_po w=0.36 l=7.36
X1376 a_9930_930# digital_0.load_slew17.X VGND VGND sky130_fd_pr__nfet_01v8 ad=0.1134 pd=1.38 as=0.1228 ps=1.065 w=0.42 l=0.15
X1377 a_4228_3650# a_4354_3834# VGND VGND sky130_fd_pr__nfet_01v8 ad=0.17225 pd=1.83 as=0.1856 ps=1.26 w=0.65 l=0.25
X1378 a_5139_930# a_4921_1334# VGND VGND sky130_fd_pr__nfet_01v8 ad=0.0999 pd=0.985 as=0.1346 ps=1.15 w=0.64 l=0.15
X1379 VGND a_11431_2382# digital_0._065_.A2_N VGND sky130_fd_pr__nfet_01v8 ad=0.247 pd=2.06 as=0.12675 ps=1.04 w=0.65 l=0.15
X1380 a_13306_1500# a_12225_1500# a_12959_1742# VDPWR sky130_fd_pr__pfet_01v8_hvt ad=0.0588 pd=0.7 as=0.12915 ps=1.185 w=0.42 l=0.15
X1381 a_4696_n132# a_4570_n16# a_4292_0# VGND sky130_fd_pr__special_nfet_01v8 ad=0.0999 pd=0.985 as=0.0711 ps=0.755 w=0.36 l=0.15
X1382 VGND digital_0.load_slew17.A digital_0._104_.RESET_B VGND sky130_fd_pr__nfet_01v8 ad=0.169 pd=1.82 as=0.08775 ps=0.92 w=0.65 l=0.15
X1383 a_4820_3132# a_3743_3138# a_4658_3510# VDPWR sky130_fd_pr__pfet_01v8_hvt ad=0.0567 pd=0.69 as=0.0588 ps=0.7 w=0.42 l=0.15
X1384 VDPWR VGND VDPWR VDPWR sky130_fd_pr__pfet_01v8_hvt ad=0.2262 pd=2.26 as=0 ps=0 w=0.87 l=0.59
X1385 LELO_GR01_0.x7.x6<3>.G LELO_GR01_0.x7.x6<3>.G LELO_GR01_0.x7.x7.S VGND sky130_fd_pr__nfet_01v8_lvt ad=0.3168 pd=1.62 as=0.5088 ps=2.98 w=0.96 l=0.94
X1386 a_12116_188# digital_0._113_.Q VGND VGND sky130_fd_pr__nfet_01v8 ad=0.08775 pd=0.92 as=0.08775 ps=0.92 w=0.65 l=0.15
X1387 a_8079_2588# a_6889_2588# a_7970_2588# VGND sky130_fd_pr__special_nfet_01v8 ad=0.0669 pd=0.75 as=0.0711 ps=0.755 w=0.36 l=0.15
X1388 a_7375_1276# digital_0._115_.Q VGND VGND sky130_fd_pr__nfet_01v8 ad=0.169 pd=1.82 as=0.08775 ps=0.92 w=0.65 l=0.15
X1389 digital_0.load_slew17.X a_14762_2018# VDPWR VDPWR sky130_fd_pr__pfet_01v8_hvt ad=0.135 pd=1.27 as=0.265 ps=2.53 w=1 l=0.15
X1390 LELO_GR01_0.x7.x1.x5.x9<2>.G LELO_GR01_0.x7.x1.x5.x9<2>.G VGND VGND sky130_fd_pr__nfet_01v8_lvt ad=0.3168 pd=1.62 as=0.5088 ps=2.98 w=0.96 l=0.94
X1391 LELO_GR01_0.x8.x5.XA7.C LELO_GR01_0.x8.x5.CK LELO_GR01_0.x8.x8.D LELO_GR01_0.x8.x8.D sky130_fd_pr__pfet_01v8 ad=0.288 pd=1.54 as=0.468 ps=2.84 w=0.9 l=0.16
X1392 a_14205_n349# digital_0._113_.Q a_13746_n524# VDPWR sky130_fd_pr__pfet_01v8_hvt ad=0.0441 pd=0.63 as=0.1932 ps=1.34 w=0.42 l=0.15
X1393 LELO_GR01_0.x7.x11.N a_25294_14644# VGND sky130_fd_pr__res_high_po w=0.36 l=7.36
X1394 a_6949_2422# a_6503_2050# a_6853_2422# VGND sky130_fd_pr__special_nfet_01v8 ad=0.1401 pd=1.1 as=0.0594 ps=0.69 w=0.36 l=0.15
X1395 VGND a_12903_206# digital_0._057_.D VGND sky130_fd_pr__nfet_01v8 ad=0.247 pd=2.06 as=0.12675 ps=1.04 w=0.65 l=0.15
X1396 LELO_GR01_0.x7.x29.P a_20744_11144# VGND sky130_fd_pr__res_high_po w=0.36 l=7.36
X1397 VGND digital_0.clkbuf_1_1__f_clk.A a_6315_1474# VGND sky130_fd_pr__nfet_01v8 ad=0.0588 pd=0.7 as=0.0588 ps=0.7 w=0.42 l=0.15
X1398 a_21834_16564# a_21618_14644# VGND sky130_fd_pr__res_high_po w=0.36 l=7.36
X1399 a_7483_412# a_7439_654# a_7317_412# VGND sky130_fd_pr__nfet_01v8 ad=0.0441 pd=0.63 as=0.1401 ps=1.1 w=0.42 l=0.15
X1400 a_16440_16564# a_16224_14644# VGND sky130_fd_pr__res_high_po w=0.36 l=7.36
X1401 digital_0.clkload0.A a_11388_956# VGND VGND sky130_fd_pr__nfet_01v8 ad=0.0588 pd=0.7 as=0.0588 ps=0.7 w=0.42 l=0.15
X1402 a_5870_2404# digital_0.output13.A a_5787_2146# VGND sky130_fd_pr__nfet_01v8 ad=0.0441 pd=0.63 as=0.1092 ps=1.36 w=0.42 l=0.15
X1403 VGND digital_0._108_.Q a_6235_3106# VGND sky130_fd_pr__nfet_01v8 ad=0.08775 pd=0.92 as=0.08775 ps=0.92 w=0.65 l=0.15
X1404 VDPWR digital_0.clkload0.A a_14157_962# VDPWR sky130_fd_pr__pfet_01v8_hvt ad=0.0864 pd=0.91 as=0.1664 ps=1.8 w=0.64 l=0.15
X1405 LELO_GR01_0.x7.x22.D LELO_GR01_0.x8.PWRUP_N_1V8 LELO_GR01_0.x7.x21.D VDPWR sky130_fd_pr__pfet_01v8_lvt ad=0.5088 pd=2.98 as=0.3168 ps=1.62 w=0.96 l=0.94
X1406 a_10412_6824# a_10628_4904# VGND sky130_fd_pr__res_high_po w=0.36 l=7.36
X1407 digital_0.output8.A a_11273_3436# VDPWR VDPWR sky130_fd_pr__pfet_01v8_hvt ad=0.135 pd=1.27 as=0.3012 ps=2.66 w=1 l=0.15
X1408 a_5868_n676# digital_0._080_.A2 VGND VGND sky130_fd_pr__nfet_01v8 ad=0.1235 pd=1.03 as=0.17225 ps=1.83 w=0.65 l=0.15
X1409 VGND digital_0.input1.X a_6889_2588# VGND sky130_fd_pr__nfet_01v8 ad=0.0567 pd=0.69 as=0.1092 ps=1.36 w=0.42 l=0.15
X1410 LELO_GR01_0.x7.x19.D LELO_GR01_0.x8.PWRUP_N_1V8 LELO_GR01_0.x7.x20.D VDPWR sky130_fd_pr__pfet_01v8_lvt ad=0.3168 pd=1.62 as=0.5088 ps=2.98 w=0.96 l=0.94
X1411 a_6455_3452# digital_0.output13.A VGND VGND sky130_fd_pr__nfet_01v8 ad=0.169 pd=1.82 as=0.08775 ps=0.92 w=0.65 l=0.15
X1412 LELO_GR01_0.x7.x6<3>.G LELO_GR01_0.x7.x6<3>.G LELO_GR01_0.x7.x7.S VGND sky130_fd_pr__nfet_01v8_lvt ad=0.3168 pd=1.62 as=0.5088 ps=2.98 w=0.96 l=0.94
X1413 a_23334_13064# a_23118_11144# VGND sky130_fd_pr__res_high_po w=0.36 l=7.36
X1414 VDPWR VGND VDPWR VDPWR sky130_fd_pr__pfet_01v8_hvt ad=0.2262 pd=2.26 as=0 ps=0 w=0.87 l=0.59
X1415 VGND VDPWR VGND VGND sky130_fd_pr__nfet_01v8 ad=0.143 pd=1.62 as=0 ps=0 w=0.55 l=0.59
X1416 LELO_GR01_0.x7.x1.x5.IBN LELO_GR01_0.x7.x1.x5.x9<2>.G VGND VGND sky130_fd_pr__nfet_01v8_lvt ad=0.3168 pd=1.62 as=0.5088 ps=2.98 w=0.96 l=0.94
X1417 VDPWR digital_0.output13.A a_7349_3132# VDPWR sky130_fd_pr__pfet_01v8_hvt ad=0.135 pd=1.27 as=0.14 ps=1.28 w=1 l=0.15
X1418 VDPWR LELO_GR01_0.x7.xd1<4>.A LELO_GR01_0.x7.x15.I2 VDPWR sky130_fd_pr__pfet_01v8_lvt ad=0.5088 pd=2.98 as=0.3168 ps=1.62 w=0.96 l=0.94
X1419 digital_0._080_.A2 digital_0.input2.X VGND VGND sky130_fd_pr__nfet_01v8 ad=0.08775 pd=0.92 as=0.169 ps=1.82 w=0.65 l=0.15
X1420 a_12189_2588# a_11839_2588# a_12094_2588# VDPWR sky130_fd_pr__pfet_01v8_hvt ad=0.07245 pd=0.765 as=0.0651 ps=0.73 w=0.42 l=0.15
X1421 a_12817_3171# a_12635_3171# VDPWR VDPWR sky130_fd_pr__pfet_01v8_hvt ad=0.0441 pd=0.63 as=0.0693 ps=0.75 w=0.42 l=0.15
X1422 VGND digital_0._063_.A a_11758_188# VGND sky130_fd_pr__nfet_01v8 ad=0.169 pd=1.82 as=0.08775 ps=0.92 w=0.65 l=0.15
X1423 a_7673_n349# digital_0._115_.Q a_7214_n524# VDPWR sky130_fd_pr__pfet_01v8_hvt ad=0.0441 pd=0.63 as=0.1932 ps=1.34 w=0.42 l=0.15
X1424 VDPWR digital_0.load_slew15.A a_8085_1500# VDPWR sky130_fd_pr__pfet_01v8_hvt ad=0.135 pd=1.27 as=0.26 ps=2.52 w=1 l=0.15
X1425 VGND digital_0._110_.Q a_11517_2382# VGND sky130_fd_pr__nfet_01v8 ad=0.1118 pd=1.04 as=0.0567 ps=0.69 w=0.42 l=0.15
X1426 a_26806_16564# a_26590_14644# VGND sky130_fd_pr__res_high_po w=0.36 l=7.36
X1427 a_9886_234# digital_0._106_.D VDPWR VDPWR sky130_fd_pr__pfet_01v8_hvt ad=0.0651 pd=0.73 as=0.1092 ps=1.36 w=0.42 l=0.15
X1428 a_4154_6824# a_4370_4904# VGND sky130_fd_pr__res_high_po w=0.36 l=7.36
X1429 VGND a_15685_386# a_15427_386# VGND sky130_fd_pr__nfet_01v8 ad=0.0567 pd=0.69 as=0.1092 ps=1.36 w=0.42 l=0.5
X1430 VGND digital_0._069_.B digital_0._109_.D VGND sky130_fd_pr__nfet_01v8 ad=0.08775 pd=0.92 as=0.08775 ps=0.92 w=0.65 l=0.15
X1431 digital_0._112_.D digital_0._063_.B VGND VGND sky130_fd_pr__nfet_01v8 ad=0.08775 pd=0.92 as=0.08775 ps=0.92 w=0.65 l=0.15
X1432 digital_0._065_.A2_N a_11431_2382# VGND VGND sky130_fd_pr__nfet_01v8 ad=0.12675 pd=1.04 as=0.1118 ps=1.04 w=0.65 l=0.15
X1433 a_4369_1474# digital_0.output13.A VGND VGND sky130_fd_pr__nfet_01v8 ad=0.1092 pd=1.36 as=0.0567 ps=0.69 w=0.42 l=0.15
X1434 VGND a_3858_930# a_3618_1194# VGND sky130_fd_pr__nfet_01v8 ad=0.1228 pd=1.065 as=0.17225 ps=1.83 w=0.65 l=0.25
X1435 a_4594_3650# digital_0.output4.A VGND VGND sky130_fd_pr__nfet_01v8 ad=0.1134 pd=1.38 as=0.1228 ps=1.065 w=0.42 l=0.15
X1436 VGND a_11388_956# digital_0.clkload0.A VGND sky130_fd_pr__nfet_01v8 ad=0.0588 pd=0.7 as=0.0588 ps=0.7 w=0.42 l=0.15
X1437 a_6758_2410# digital_0._108_.D VDPWR VDPWR sky130_fd_pr__pfet_01v8_hvt ad=0.0651 pd=0.73 as=0.1092 ps=1.36 w=0.42 l=0.15
X1438 LELO_GR01_0.x7.x15.I2 LELO_GR01_0.x7.xd1<4>.A VDPWR VDPWR sky130_fd_pr__pfet_01v8_lvt ad=0.3168 pd=1.62 as=0.5088 ps=2.98 w=0.96 l=0.94
X1439 digital_0._111_.RESET_B digital_0.load_slew17.A VGND VGND sky130_fd_pr__nfet_01v8 ad=0.08775 pd=0.92 as=0.08775 ps=0.92 w=0.65 l=0.15
X1440 digital_0._103_.RESET_B digital_0.load_slew17.A VDPWR VDPWR sky130_fd_pr__pfet_01v8_hvt ad=0.135 pd=1.27 as=0.26 ps=2.52 w=1 l=0.15
X1441 a_13481_386# digital_0._112_.RESET_B VDPWR VDPWR sky130_fd_pr__pfet_01v8_hvt ad=0.0567 pd=0.69 as=0.0819 ps=0.81 w=0.42 l=0.15
X1442 a_7071_2018# a_6853_2422# VDPWR VDPWR sky130_fd_pr__pfet_01v8_hvt ad=0.12915 pd=1.185 as=0.2184 ps=2.2 w=0.84 l=0.15
X1443 VGND digital_0.clkbuf_1_0__f_clk.X a_4405_962# VGND sky130_fd_pr__nfet_01v8 ad=0.0567 pd=0.69 as=0.1092 ps=1.36 w=0.42 l=0.15
X1444 VGND a_3492_3650# uio_out<0> VGND sky130_fd_pr__nfet_01v8 ad=0.1856 pd=1.26 as=0.2079 ps=1.83 w=0.42 l=0.15
X1445 a_7820_6824# a_7604_4904# VGND sky130_fd_pr__res_high_po w=0.36 l=7.36
X1446 a_13481_386# a_13306_412# a_13660_412# VGND sky130_fd_pr__nfet_01v8 ad=0.1092 pd=1.36 as=0.06405 ps=0.725 w=0.42 l=0.15
X1447 LELO_GR01_0.x7.x1.x7.D LELO_GR01_0.x7.x7.G LELO_GR01_0.x7.x1.x5.IBN VGND sky130_fd_pr__nfet_01v8_lvt ad=0.3168 pd=1.62 as=0.5088 ps=2.98 w=0.96 l=0.94
X1448 VDPWR VGND VDPWR VDPWR sky130_fd_pr__pfet_01v8_hvt ad=0.2262 pd=2.26 as=0 ps=0 w=0.87 l=0.59
X1449 a_12297_2954# a_11673_2588# a_12189_2588# VDPWR sky130_fd_pr__pfet_01v8_hvt ad=0.1155 pd=0.97 as=0.07245 ps=0.765 w=0.42 l=0.15
X1450 LELO_GR01_0.x7.x23.D LELO_GR01_0.x8.PWRUP_N_1V8 LELO_GR01_0.x7.x24.D VDPWR sky130_fd_pr__pfet_01v8_lvt ad=0.3168 pd=1.62 as=0.5088 ps=2.98 w=0.96 l=0.94
X1451 VGND LELO_GR01_0.x8.x5.CK LELO_GR01_0.x8.IBP_BG VGND sky130_fd_pr__nfet_01v8_lvt ad=0.5088 pd=2.98 as=0.3168 ps=1.62 w=0.96 l=0.94
X1452 LELO_GR01_0.x8.x8.D LELO_GR01_0.x8.PWRUP_N_1V8 VDPWR VDPWR sky130_fd_pr__pfet_01v8_lvt ad=0.3168 pd=1.62 as=0.5088 ps=2.98 w=0.96 l=0.94
X1453 digital_0.clkbuf_1_0__f_clk.X a_6315_1474# VDPWR VDPWR sky130_fd_pr__pfet_01v8_hvt ad=0.14 pd=1.28 as=0.14 ps=1.28 w=1 l=0.15
X1454 a_10525_n349# digital_0._114_.Q a_10066_n524# VDPWR sky130_fd_pr__pfet_01v8_hvt ad=0.0441 pd=0.63 as=0.1932 ps=1.34 w=0.42 l=0.15
X1455 VGND a_15634_1474# a_15394_1658# VGND sky130_fd_pr__nfet_01v8 ad=0.1228 pd=1.065 as=0.17225 ps=1.83 w=0.65 l=0.25
X1456 VDPWR VGND VDPWR VDPWR sky130_fd_pr__pfet_01v8_hvt ad=0.2262 pd=2.26 as=0 ps=0 w=0.87 l=0.59
X1457 a_8578_n132# a_8361_n132# VDPWR VDPWR sky130_fd_pr__pfet_01v8_hvt ad=0.2173 pd=2.17 as=0.19265 ps=1.415 w=0.82 l=0.25
X1458 VGND VGND LELO_GR01_0.x7.x15.I1 sky130_fd_pr__pnp_05v5_W3p40L3p40
**devattr s=462400,2720
X1459 JNWTR_ORX1_CV_0.XA2.A JNWTR_ORX1_CV_0.A VGND VGND sky130_fd_pr__nfet_01v8 ad=0.288 pd=1.54 as=0.468 ps=2.84 w=0.9 l=0.16
X1460 a_14339_n158# a_14121_246# VDPWR VDPWR sky130_fd_pr__pfet_01v8_hvt ad=0.12915 pd=1.185 as=0.2184 ps=2.2 w=0.84 l=0.15
X1461 VGND VGND LELO_GR01_0.x7.x15.I1 sky130_fd_pr__pnp_05v5_W3p40L3p40
**devattr s=462400,2720
X1462 digital_0.output10.A a_14861_172# VDPWR VDPWR sky130_fd_pr__pfet_01v8_hvt ad=0.135 pd=1.27 as=0.3012 ps=2.66 w=1 l=0.15
X1463 a_7418_2422# a_6337_2050# a_7071_2018# VDPWR sky130_fd_pr__pfet_01v8_hvt ad=0.0588 pd=0.7 as=0.12915 ps=1.185 w=0.42 l=0.15
X1464 a_13481_1474# a_13306_1500# a_13660_1500# VGND sky130_fd_pr__nfet_01v8 ad=0.1092 pd=1.36 as=0.06405 ps=0.725 w=0.42 l=0.15
X1465 a_4369_2422# a_3853_2050# a_4274_2410# VGND sky130_fd_pr__special_nfet_01v8 ad=0.0594 pd=0.69 as=0.066 ps=0.745 w=0.36 l=0.15
X1466 VGND clk a_8996_1500# VGND sky130_fd_pr__nfet_01v8 ad=0.0588 pd=0.7 as=0.0588 ps=0.7 w=0.42 l=0.15
X1467 a_6758_2410# digital_0._108_.D VGND VGND sky130_fd_pr__nfet_01v8 ad=0.066 pd=0.745 as=0.2205 ps=1.89 w=0.42 l=0.15
X1468 a_10438_3498# digital_0._103_.D VGND VGND sky130_fd_pr__nfet_01v8 ad=0.066 pd=0.745 as=0.2205 ps=1.89 w=0.42 l=0.15
X1469 VDPWR digital_0.load_slew17.X digital_0._106_.RESET_B VDPWR sky130_fd_pr__pfet_01v8_hvt ad=0.26 pd=2.52 as=0.135 ps=1.27 w=1 l=0.15
X1470 a_28502_13064# a_28286_11144# VGND sky130_fd_pr__res_high_po w=0.36 l=7.36
X1471 VGND a_4005_n158# digital_0.output4.A VGND sky130_fd_pr__nfet_01v8 ad=0.2087 pd=2.02 as=0.08775 ps=0.92 w=0.65 l=0.15
X1472 VDPWR a_14990_386# a_14750_570# VDPWR sky130_fd_pr__pfet_01v8_hvt ad=0.19265 pd=1.415 as=0.2173 ps=2.17 w=0.82 l=0.25
X1473 VDPWR a_14769_3436# a_14756_3132# VDPWR sky130_fd_pr__pfet_01v8_hvt ad=0.0819 pd=0.81 as=0.0567 ps=0.69 w=0.42 l=0.15
X1474 digital_0._112_.RESET_B digital_0.load_slew17.X VGND VGND sky130_fd_pr__nfet_01v8 ad=0.08775 pd=0.92 as=0.08775 ps=0.92 w=0.65 l=0.15
X1475 VDPWR digital_0._116_.SET_B a_4746_412# VDPWR sky130_fd_pr__pfet_01v8_hvt ad=0.0798 pd=0.8 as=0.0567 ps=0.69 w=0.42 l=0.15
X1476 a_7820_6824# a_8036_4904# VGND sky130_fd_pr__res_high_po w=0.36 l=7.36
X1477 digital_0.output12.A a_6397_n158# VGND VGND sky130_fd_pr__nfet_01v8 ad=0.08775 pd=0.92 as=0.169 ps=1.82 w=0.65 l=0.15
X1478 VGND a_6315_1474# digital_0.clkbuf_1_0__f_clk.X VGND sky130_fd_pr__nfet_01v8 ad=0.0588 pd=0.7 as=0.0588 ps=0.7 w=0.42 l=0.15
X1479 digital_0._063_.A a_11951_2146# VDPWR VDPWR sky130_fd_pr__pfet_01v8_hvt ad=0.135 pd=1.27 as=0.15075 ps=1.345 w=1 l=0.15
X1480 a_13468_778# a_12391_412# a_13306_412# VDPWR sky130_fd_pr__pfet_01v8_hvt ad=0.0567 pd=0.69 as=0.0588 ps=0.7 w=0.42 l=0.15
X1481 a_14686_246# a_13605_n126# a_14339_n158# VDPWR sky130_fd_pr__pfet_01v8_hvt ad=0.0588 pd=0.7 as=0.12915 ps=1.185 w=0.42 l=0.15
X1482 VDPWR a_8578_n676# a_8689_n676# VDPWR sky130_fd_pr__pfet_01v8_hvt ad=0.2726 pd=1.61 as=0.2173 ps=2.17 w=0.82 l=0.25
X1483 a_27670_16564# a_27886_14644# VGND sky130_fd_pr__res_high_po w=0.36 l=7.36
X1484 VDPWR a_11388_956# digital_0.clkload0.A VDPWR sky130_fd_pr__pfet_01v8_hvt ad=0.14 pd=1.28 as=0.14 ps=1.28 w=1 l=0.15
X1485 VDPWR VGND VDPWR VDPWR sky130_fd_pr__pfet_01v8_hvt ad=0.2262 pd=2.26 as=0 ps=0 w=0.87 l=0.59
X1486 VDPWR a_6315_1474# digital_0.clkbuf_1_0__f_clk.X VDPWR sky130_fd_pr__pfet_01v8_hvt ad=0.14 pd=1.28 as=0.14 ps=1.28 w=1 l=0.15
X1487 a_7310_2588# digital_0._109_.D VDPWR VDPWR sky130_fd_pr__pfet_01v8_hvt ad=0.0651 pd=0.73 as=0.1092 ps=1.36 w=0.42 l=0.15
X1488 uio_out<3> a_12829_3676# VDPWR VDPWR sky130_fd_pr__pfet_01v8_hvt ad=0.495 pd=2.99 as=0.2726 ps=1.61 w=1 l=0.15
X1489 LELO_GR01_0.x8.x7.D LELO_GR01_0.x8.VREF_BG LELO_GR01_0.x8.x1.x5.IBN VGND sky130_fd_pr__nfet_01v8_lvt ad=0.3168 pd=1.62 as=0.5088 ps=2.98 w=0.96 l=0.94
X1490 VGND a_15413_1260# a_15347_1334# VGND sky130_fd_pr__nfet_01v8 ad=0.12495 pd=1.015 as=0.0669 ps=0.75 w=0.42 l=0.15
X1491 digital_0._112_.RESET_B digital_0.load_slew17.X a_15537_n426# VDPWR sky130_fd_pr__pfet_01v8_hvt ad=0.135 pd=1.27 as=0.135 ps=1.27 w=1 l=0.15
X1492 VDPWR digital_0._112_.Q a_10997_386# VDPWR sky130_fd_pr__pfet_01v8_hvt ad=0.1092 pd=1.36 as=0.07455 ps=0.775 w=0.42 l=0.15
X1493 VGND digital_0.input1.X a_6705_412# VGND sky130_fd_pr__nfet_01v8 ad=0.0567 pd=0.69 as=0.1092 ps=1.36 w=0.42 l=0.15
X1494 a_4526_n132# a_4005_n158# VDPWR VDPWR sky130_fd_pr__pfet_01v8_hvt ad=0.0567 pd=0.69 as=0.0819 ps=0.81 w=0.42 l=0.15
X1495 a_7155_930# digital_0._060_.A_N VGND VGND sky130_fd_pr__nfet_01v8 ad=0.08775 pd=0.92 as=0.169 ps=1.82 w=0.65 l=0.15
X1496 a_25270_13064# a_25486_11144# VGND sky130_fd_pr__res_high_po w=0.36 l=7.36
X1497 digital_0._104_.RESET_B digital_0.load_slew17.A VDPWR VDPWR sky130_fd_pr__pfet_01v8_hvt ad=0.135 pd=1.27 as=0.26 ps=2.52 w=1 l=0.15
X1498 LELO_GR01_0.x7.xd1<4>.A LELO_GR01_0.x7.x18.D LELO_GR01_0.x7.x6<3>.G VGND sky130_fd_pr__nfet_01v8_lvt ad=0.3168 pd=1.62 as=0.5088 ps=2.98 w=0.96 l=0.94
X1499 VDPWR a_7001_110# a_6962_n16# VDPWR sky130_fd_pr__pfet_01v8_hvt ad=0.0864 pd=0.91 as=0.1664 ps=1.8 w=0.64 l=0.15
X1500 a_4108_2840# a_4386_2856# a_4342_2954# VDPWR sky130_fd_pr__pfet_01v8_hvt ad=0.0588 pd=0.7 as=0.0567 ps=0.69 w=0.42 l=0.15
X1501 VDPWR digital_0.clkbuf_1_0__f_clk.X a_3853_2050# VDPWR sky130_fd_pr__pfet_01v8_hvt ad=0.0864 pd=0.91 as=0.1664 ps=1.8 w=0.64 l=0.15
X1502 a_14029_3510# a_13513_3138# a_13934_3498# VGND sky130_fd_pr__special_nfet_01v8 ad=0.0594 pd=0.69 as=0.066 ps=0.745 w=0.36 l=0.15
X1503 VGND digital_0._069_.A digital_0._067_.B VGND sky130_fd_pr__nfet_01v8 ad=0.08775 pd=0.92 as=0.08775 ps=0.92 w=0.65 l=0.15
X1504 a_8145_2562# a_7970_2588# a_8324_2588# VGND sky130_fd_pr__nfet_01v8 ad=0.1092 pd=1.36 as=0.06405 ps=0.725 w=0.42 l=0.15
X1505 a_12626_n676# a_12409_n676# VDPWR VDPWR sky130_fd_pr__pfet_01v8_hvt ad=0.2173 pd=2.17 as=0.19265 ps=1.415 w=0.82 l=0.25
X1506 VDPWR LELO_GR01_0.x7.xd1<4>.A LELO_GR01_0.x7.x7.G VDPWR sky130_fd_pr__pfet_01v8_lvt ad=0.5088 pd=2.98 as=0.3168 ps=1.62 w=0.96 l=0.94
X1507 VDPWR a_4594_3650# a_4354_3834# VDPWR sky130_fd_pr__pfet_01v8_hvt ad=0.19265 pd=1.415 as=0.2173 ps=2.17 w=0.82 l=0.25
X1508 a_3858_3650# digital_0.output5.A VGND VGND sky130_fd_pr__nfet_01v8 ad=0.1134 pd=1.38 as=0.1228 ps=1.065 w=0.42 l=0.15
X1509 digital_0._113_.D a_11758_188# VGND VGND sky130_fd_pr__nfet_01v8 ad=0.08775 pd=0.92 as=0.169 ps=1.82 w=0.65 l=0.15
X1510 a_11353_2616# digital_0._069_.A VGND VGND sky130_fd_pr__nfet_01v8 ad=0.0567 pd=0.69 as=0.1118 ps=1.04 w=0.42 l=0.15
X1511 LELO_GR01_0.x7.x15.I2 LELO_GR01_0.x7.xd1<4>.A VDPWR VDPWR sky130_fd_pr__pfet_01v8_lvt ad=0.3168 pd=1.62 as=0.5088 ps=2.98 w=0.96 l=0.94
X1512 VGND VDPWR VGND VGND sky130_fd_pr__nfet_01v8 ad=0.143 pd=1.62 as=0 ps=0 w=0.55 l=0.59
X1513 LELO_GR01_0.x8.x1.x5.x8.S LELO_GR01_0.x8.PWRUP_N_1V8 VDPWR VDPWR sky130_fd_pr__pfet_01v8_lvt ad=0.3168 pd=1.62 as=0.5088 ps=2.98 w=0.96 l=0.94
X1514 digital_0.clkbuf_1_1__f_clk.A a_8996_1500# VGND VGND sky130_fd_pr__nfet_01v8 ad=0.0588 pd=0.7 as=0.0588 ps=0.7 w=0.42 l=0.15
X1515 a_10555_956# digital_0._069_.A VDPWR VDPWR sky130_fd_pr__pfet_01v8_hvt ad=0.215 pd=1.43 as=0.135 ps=1.27 w=1 l=0.15
X1516 VGND digital_0.output12.A a_8361_n676# VGND sky130_fd_pr__nfet_01v8 ad=0.1228 pd=1.065 as=0.1134 ps=1.38 w=0.42 l=0.15
X1517 a_11397_1750# digital_0._069_.A VDPWR VDPWR sky130_fd_pr__pfet_01v8_hvt ad=0.14 pd=1.28 as=0.14 ps=1.28 w=1 l=0.15
X1518 a_6235_3106# digital_0._108_.Q VGND VGND sky130_fd_pr__nfet_01v8 ad=0.08775 pd=0.92 as=0.169 ps=1.82 w=0.65 l=0.15
X1519 VGND LELO_GR01_0.x8.x1.x5.x9<2>.G LELO_GR01_0.x8.x1.x5.IBN VGND sky130_fd_pr__nfet_01v8_lvt ad=0.5088 pd=2.98 as=0.3168 ps=1.62 w=0.96 l=0.94
X1520 VGND VDPWR VGND VGND sky130_fd_pr__nfet_01v8 ad=0.143 pd=1.62 as=0 ps=0 w=0.55 l=0.59
X1521 VGND LELO_GR01_0.x7.x1.x5.x9<2>.G LELO_GR01_0.x7.x1.x5.IBN VGND sky130_fd_pr__nfet_01v8_lvt ad=0.5088 pd=2.98 as=0.3168 ps=1.62 w=0.96 l=0.94
X1522 a_7717_3926# digital_0._116_.Q VDPWR VDPWR sky130_fd_pr__pfet_01v8_hvt ad=0.135 pd=1.27 as=0.135 ps=1.27 w=1 l=0.15
X1523 VGND digital_0._105_.RESET_B a_14383_234# VGND sky130_fd_pr__nfet_01v8 ad=0.1346 pd=1.15 as=0.0441 ps=0.63 w=0.42 l=0.15
X1524 a_6315_1474# digital_0.clkbuf_1_1__f_clk.A VGND VGND sky130_fd_pr__nfet_01v8 ad=0.0588 pd=0.7 as=0.0588 ps=0.7 w=0.42 l=0.15
X1525 a_4154_6824# a_3938_4904# VGND sky130_fd_pr__res_high_po w=0.36 l=7.36
X1526 a_7826_956# digital_0._115_.Q VDPWR VDPWR sky130_fd_pr__pfet_01v8_hvt ad=0.275 pd=2.55 as=0.135 ps=1.27 w=1 l=0.15
X1527 a_10438_3498# digital_0._103_.D VDPWR VDPWR sky130_fd_pr__pfet_01v8_hvt ad=0.0651 pd=0.73 as=0.1092 ps=1.36 w=0.42 l=0.15
X1528 VGND a_3471_1474# digital_0._118_.D VGND sky130_fd_pr__nfet_01v8 ad=0.1118 pd=1.04 as=0.12675 ps=1.04 w=0.65 l=0.15
X1529 digital_0._118_.D a_3471_1474# VDPWR VDPWR sky130_fd_pr__pfet_01v8_hvt ad=0.195 pd=1.39 as=0.38 ps=2.76 w=1 l=0.15
X1530 VDPWR digital_0._069_.A a_7181_3926# VDPWR sky130_fd_pr__pfet_01v8_hvt ad=0.135 pd=1.27 as=0.135 ps=1.27 w=1 l=0.15
X1531 LELO_GR01_0.x7.x1.x5.x8.S LELO_GR01_0.x8.PWRUP_N_1V8 VDPWR VDPWR sky130_fd_pr__pfet_01v8_lvt ad=0.3168 pd=1.62 as=0.5088 ps=2.98 w=0.96 l=0.94
X1532 a_7395_234# digital_0._107_.RESET_B VGND VGND sky130_fd_pr__nfet_01v8 ad=0.0441 pd=0.63 as=0.1346 ps=1.15 w=0.42 l=0.15
X1533 a_7439_654# a_7221_412# VDPWR VDPWR sky130_fd_pr__pfet_01v8_hvt ad=0.12915 pd=1.185 as=0.2184 ps=2.2 w=0.84 l=0.15
X1534 VGND a_4581_2825# a_4512_2954# VGND sky130_fd_pr__nfet_01v8 ad=0.1346 pd=1.15 as=0.0999 ps=0.985 w=0.64 l=0.15
X1535 a_10751_3106# a_10533_3510# VDPWR VDPWR sky130_fd_pr__pfet_01v8_hvt ad=0.12915 pd=1.185 as=0.2184 ps=2.2 w=0.84 l=0.15
X1536 VDPWR digital_0.output12.A a_8361_n676# VDPWR sky130_fd_pr__pfet_01v8_hvt ad=0.19265 pd=1.415 as=0.27 ps=2.54 w=1 l=0.15
X1537 VGND VDPWR VGND VGND sky130_fd_pr__nfet_01v8 ad=0.143 pd=1.62 as=0 ps=0 w=0.55 l=0.59
X1538 VGND VGND LELO_GR01_0.x7.x15.I1 sky130_fd_pr__pnp_05v5_W3p40L3p40
**devattr s=462400,2720
X1539 VGND a_15268_1474# digital_0.load_slew17.A VGND sky130_fd_pr__nfet_01v8 ad=0.1856 pd=1.26 as=0.2079 ps=1.83 w=0.42 l=0.15
X1540 VGND VDPWR VGND VGND sky130_fd_pr__nfet_01v8 ad=0.143 pd=1.62 as=0 ps=0 w=0.55 l=0.59
X1541 a_12451_2588# a_12407_2830# a_12285_2588# VGND sky130_fd_pr__nfet_01v8 ad=0.0441 pd=0.63 as=0.1401 ps=1.1 w=0.42 l=0.15
X1542 VDPWR VGND VDPWR VDPWR sky130_fd_pr__pfet_01v8_hvt ad=0.2262 pd=2.26 as=0 ps=0 w=0.87 l=0.59
X1543 digital_0._108_.RESET_B digital_0._116_.Q VGND VGND sky130_fd_pr__nfet_01v8 ad=0.08775 pd=0.92 as=0.08775 ps=0.92 w=0.65 l=0.15
X1544 a_9417_n702# digital_0._060_.A_N VDPWR VDPWR sky130_fd_pr__pfet_01v8_hvt ad=0.1092 pd=1.36 as=0.07665 ps=0.785 w=0.42 l=0.15
X1545 LELO_GR01_0.x7.x31.N a_7604_4904# VGND sky130_fd_pr__res_high_po w=0.36 l=7.36
X1546 VDPWR digital_0._113_.Q a_11673_n132# VDPWR sky130_fd_pr__pfet_01v8_hvt ad=0.135 pd=1.27 as=0.275 ps=2.55 w=1 l=0.15
X1547 a_10284_2588# digital_0._069_.A VGND VGND sky130_fd_pr__nfet_01v8 ad=0.06615 pd=0.735 as=0.09862 ps=0.98 w=0.42 l=0.15
X1548 VDPWR a_4609_110# a_4570_n16# VDPWR sky130_fd_pr__pfet_01v8_hvt ad=0.0864 pd=0.91 as=0.1664 ps=1.8 w=0.64 l=0.15
X1549 VGND ui_in<0> sky130_fd_pr__diode_pw2nd_05v5 perim=1.8e+06 area=2.025e+11
X1550 VDPWR digital_0._119_.RESET_B a_4005_n158# VDPWR sky130_fd_pr__pfet_01v8_hvt ad=0.0819 pd=0.81 as=0.0567 ps=0.69 w=0.42 l=0.15
X1551 a_10571_2588# digital_0._067_.A VGND VGND sky130_fd_pr__nfet_01v8 ad=0.1092 pd=1.36 as=0.0567 ps=0.69 w=0.42 l=0.15
X1552 VGND a_4833_3436# digital_0.hold28.A VGND sky130_fd_pr__nfet_01v8 ad=0.169 pd=1.82 as=0.08775 ps=0.92 w=0.65 l=0.15
X1553 VGND a_8996_1500# digital_0.clkbuf_1_1__f_clk.A VGND sky130_fd_pr__nfet_01v8 ad=0.0588 pd=0.7 as=0.0588 ps=0.7 w=0.42 l=0.15
X1554 a_10199_n158# a_9981_246# VDPWR VDPWR sky130_fd_pr__pfet_01v8_hvt ad=0.12915 pd=1.185 as=0.2184 ps=2.2 w=0.84 l=0.15
X1555 a_5159_1474# digital_0.hold28.A VDPWR VDPWR sky130_fd_pr__pfet_01v8_hvt ad=0.1176 pd=1.4 as=0.0693 ps=0.75 w=0.42 l=0.15
X1556 digital_0.output11.A a_10721_172# VDPWR VDPWR sky130_fd_pr__pfet_01v8_hvt ad=0.135 pd=1.27 as=0.3012 ps=2.66 w=1 l=0.15
X1557 a_12094_2588# digital_0._110_.D VGND VGND sky130_fd_pr__nfet_01v8 ad=0.066 pd=0.745 as=0.2205 ps=1.89 w=0.42 l=0.15
X1558 a_11098_3510# a_10017_3138# a_10751_3106# VDPWR sky130_fd_pr__pfet_01v8_hvt ad=0.0588 pd=0.7 as=0.12915 ps=1.185 w=0.42 l=0.15
X1559 digital_0._112_.D digital_0._063_.A VGND VGND sky130_fd_pr__nfet_01v8 ad=0.08775 pd=0.92 as=0.182 ps=1.86 w=0.65 l=0.15
X1560 a_23562_16564# a_23346_14644# VGND sky130_fd_pr__res_high_po w=0.36 l=7.36
X1561 VDPWR a_9417_n702# a_9151_n702# VDPWR sky130_fd_pr__pfet_01v8_hvt ad=0.07665 pd=0.785 as=0.0609 ps=0.71 w=0.42 l=0.15
X1562 LELO_GR01_0.x8.IBP_BG VGND sky130_fd_pr__cap_mim_m3_1 l=5 w=5
X1563 a_4512_2954# a_4386_2856# a_4108_2840# VGND sky130_fd_pr__special_nfet_01v8 ad=0.0999 pd=0.985 as=0.0711 ps=0.755 w=0.36 l=0.15
X1564 VDPWR a_5109_2348# digital_0.output6.A VDPWR sky130_fd_pr__pfet_01v8_hvt ad=0.26 pd=2.52 as=0.135 ps=1.27 w=1 l=0.15
X1565 VDPWR a_4311_3106# a_4201_3132# VDPWR sky130_fd_pr__pfet_01v8_hvt ad=0.07035 pd=0.755 as=0.1155 ps=0.97 w=0.42 l=0.15
X1566 digital_0.clkload0.A a_11388_956# VGND VGND sky130_fd_pr__nfet_01v8 ad=0.0588 pd=0.7 as=0.0588 ps=0.7 w=0.42 l=0.15
X1567 digital_0.clkload0.X a_11673_412# VDPWR VDPWR sky130_fd_pr__pfet_01v8_hvt ad=0.14 pd=1.28 as=0.165 ps=1.33 w=1 l=0.15
X1568 VDPWR a_11388_956# digital_0.clkload0.A VDPWR sky130_fd_pr__pfet_01v8_hvt ad=0.14 pd=1.28 as=0.14 ps=1.28 w=1 l=0.15
X1569 VGND a_5834_2740# digital_0._100_.D VGND sky130_fd_pr__nfet_01v8 ad=0.11285 pd=1.045 as=0.169 ps=1.82 w=0.65 l=0.15
X1570 a_10546_246# a_9465_n126# a_10199_n158# VDPWR sky130_fd_pr__pfet_01v8_hvt ad=0.0588 pd=0.7 as=0.12915 ps=1.185 w=0.42 l=0.15
X1571 VGND digital_0._113_.Q a_12116_188# VGND sky130_fd_pr__nfet_01v8 ad=0.08775 pd=0.92 as=0.169 ps=1.82 w=0.65 l=0.15
X1572 digital_0._115_.Q a_7961_386# VGND VGND sky130_fd_pr__nfet_01v8 ad=0.08775 pd=0.92 as=0.2087 ps=2.02 w=0.65 l=0.15
X1573 VDPWR digital_0.output5.A a_4979_3676# VDPWR sky130_fd_pr__pfet_01v8_hvt ad=0.0567 pd=0.69 as=0.1092 ps=1.36 w=0.42 l=0.15
X1574 digital_0.output6.A a_5109_2348# VGND VGND sky130_fd_pr__nfet_01v8 ad=0.08775 pd=0.92 as=0.2087 ps=2.02 w=0.65 l=0.15
X1575 digital_0._117_.RESET_B digital_0.load_slew15.X VGND VGND sky130_fd_pr__nfet_01v8 ad=0.08775 pd=0.92 as=0.169 ps=1.82 w=0.65 l=0.15
X1576 a_12391_412# a_12225_412# VDPWR VDPWR sky130_fd_pr__pfet_01v8_hvt ad=0.1664 pd=1.8 as=0.0864 ps=0.91 w=0.64 l=0.15
X1577 a_14757_1827# digital_0._112_.Q a_14298_1652# VDPWR sky130_fd_pr__pfet_01v8_hvt ad=0.0441 pd=0.63 as=0.1932 ps=1.34 w=0.42 l=0.15
X1578 uio_out<7> a_8689_n676# VGND VGND sky130_fd_pr__nfet_01v8 ad=0.2079 pd=1.83 as=0.1856 ps=1.26 w=0.42 l=0.15
X1579 a_4571_962# a_4405_962# VDPWR VDPWR sky130_fd_pr__pfet_01v8_hvt ad=0.1664 pd=1.8 as=0.0864 ps=0.91 w=0.64 l=0.15
X1580 digital_0.clkbuf_1_0__f_clk.X a_6315_1474# VGND VGND sky130_fd_pr__nfet_01v8 ad=0.0588 pd=0.7 as=0.1113 ps=1.37 w=0.42 l=0.15
X1581 VGND digital_0._106_.RESET_B a_10243_234# VGND sky130_fd_pr__nfet_01v8 ad=0.1346 pd=1.15 as=0.0441 ps=0.63 w=0.42 l=0.15
X1582 VGND a_11007_n524# digital_0.hold21.X VGND sky130_fd_pr__nfet_01v8 ad=0.097 pd=0.975 as=0.169 ps=1.82 w=0.65 l=0.15
X1583 LELO_GR01_0.x7.x15.I2 LELO_GR01_0.x7.xd1<4>.A VDPWR VDPWR sky130_fd_pr__pfet_01v8_lvt ad=0.3168 pd=1.62 as=0.5088 ps=2.98 w=0.96 l=0.94
X1584 a_14026_234# digital_0._105_.D VDPWR VDPWR sky130_fd_pr__pfet_01v8_hvt ad=0.0651 pd=0.73 as=0.1092 ps=1.36 w=0.42 l=0.15
X1585 a_14871_n524# a_14967_n702# VGND VGND sky130_fd_pr__nfet_01v8 ad=0.1092 pd=1.36 as=0.097 ps=0.975 w=0.42 l=0.5
X1586 VGND digital_0._104_.RESET_B a_14935_1322# VGND sky130_fd_pr__nfet_01v8 ad=0.1346 pd=1.15 as=0.0441 ps=0.63 w=0.42 l=0.15
X1587 VGND VDPWR VGND VGND sky130_fd_pr__nfet_01v8 ad=0.143 pd=1.62 as=0 ps=0 w=0.55 l=0.59
X1588 VDPWR digital_0.output12.A a_6451_n676# VDPWR sky130_fd_pr__pfet_01v8_hvt ad=0.0567 pd=0.69 as=0.1092 ps=1.36 w=0.42 l=0.15
X1589 a_7439_654# a_7221_412# VGND VGND sky130_fd_pr__nfet_01v8 ad=0.0999 pd=0.985 as=0.1346 ps=1.15 w=0.64 l=0.15
X1590 digital_0._115_.RESET_B digital_0._116_.Q VGND VGND sky130_fd_pr__nfet_01v8 ad=0.08775 pd=0.92 as=0.182 ps=1.86 w=0.65 l=0.15
X1591 VDPWR a_8085_1500# digital_0.load_slew15.X VDPWR sky130_fd_pr__pfet_01v8_hvt ad=0.26 pd=2.52 as=0.135 ps=1.27 w=1 l=0.15
X1592 VDPWR digital_0.clkload0.A a_11673_412# VDPWR sky130_fd_pr__pfet_01v8_hvt ad=0.165 pd=1.33 as=0.265 ps=2.53 w=1 l=0.15
X1593 LELO_GR01_0.x7.x11.P a_28318_14644# VGND sky130_fd_pr__res_high_po w=0.36 l=7.36
X1594 VDPWR a_3858_930# a_3618_1194# VDPWR sky130_fd_pr__pfet_01v8_hvt ad=0.19265 pd=1.415 as=0.2173 ps=2.17 w=0.82 l=0.25
X1595 digital_0._101_.RESET_B digital_0.load_slew15.X VGND VGND sky130_fd_pr__nfet_01v8 ad=0.08775 pd=0.92 as=0.169 ps=1.82 w=0.65 l=0.15
X1596 VDPWR LELO_GR01_0.x7.xd1<4>.A LELO_GR01_0.x7.x15.I2 VDPWR sky130_fd_pr__pfet_01v8_lvt ad=0.5088 pd=2.98 as=0.3168 ps=1.62 w=0.96 l=0.94
X1597 LELO_GR01_0.x8.x5.XA7.CN LELO_GR01_0.x8.x5.XA7.C LELO_GR01_0.x8.x8.D LELO_GR01_0.x8.x8.D sky130_fd_pr__pfet_01v8 ad=0.468 pd=2.84 as=0.468 ps=2.84 w=0.9 l=0.16
X1598 a_3743_3138# a_3577_3138# VGND VGND sky130_fd_pr__nfet_01v8 ad=0.1092 pd=1.36 as=0.0567 ps=0.69 w=0.42 l=0.15
X1599 a_4746_412# a_4610_386# VDPWR VDPWR sky130_fd_pr__pfet_01v8_hvt ad=0.0567 pd=0.69 as=0.0567 ps=0.69 w=0.42 l=0.15
X1600 VDPWR VGND VDPWR VDPWR sky130_fd_pr__pfet_01v8_hvt ad=0.2262 pd=2.26 as=0 ps=0 w=0.87 l=0.59
X1601 digital_0._115_.RESET_B digital_0.load_slew17.X VGND VGND sky130_fd_pr__nfet_01v8 ad=0.08775 pd=0.92 as=0.08775 ps=0.92 w=0.65 l=0.15
X1602 a_7580_2044# a_6503_2050# a_7418_2422# VDPWR sky130_fd_pr__pfet_01v8_hvt ad=0.0567 pd=0.69 as=0.0588 ps=0.7 w=0.42 l=0.15
X1603 VGND digital_0._113_.RESET_B a_13003_1500# VGND sky130_fd_pr__nfet_01v8 ad=0.1346 pd=1.15 as=0.0441 ps=0.63 w=0.42 l=0.15
X1604 VGND a_14861_172# digital_0.output10.A VGND sky130_fd_pr__nfet_01v8 ad=0.169 pd=1.82 as=0.08775 ps=0.92 w=0.65 l=0.15
X1605 digital_0.clkbuf_1_1__f_clk.A a_8996_1500# VGND VGND sky130_fd_pr__nfet_01v8 ad=0.0588 pd=0.7 as=0.0588 ps=0.7 w=0.42 l=0.15
X1606 a_14594_3510# a_13679_3138# a_14247_3106# VGND sky130_fd_pr__special_nfet_01v8 ad=0.0711 pd=0.755 as=0.0999 ps=0.985 w=0.36 l=0.15
X1607 a_6407_1188# a_6503_930# VGND VGND sky130_fd_pr__nfet_01v8 ad=0.1092 pd=1.36 as=0.097 ps=0.975 w=0.42 l=0.5
X1608 digital_0._112_.RESET_B digital_0._116_.Q VGND VGND sky130_fd_pr__nfet_01v8 ad=0.08775 pd=0.92 as=0.182 ps=1.86 w=0.65 l=0.15
X1609 digital_0.output5.A a_3821_2562# VGND VGND sky130_fd_pr__nfet_01v8 ad=0.08775 pd=0.92 as=0.169 ps=1.82 w=0.65 l=0.15
X1610 VGND VDPWR VGND VGND sky130_fd_pr__nfet_01v8 ad=0.143 pd=1.62 as=0 ps=0 w=0.55 l=0.59
X1611 LELO_GR01_0.x7.x1.x7.D LELO_GR01_0.x7.x1.x7.D VDPWR VDPWR sky130_fd_pr__pfet_01v8_lvt ad=0.3168 pd=1.62 as=0.5088 ps=2.98 w=0.96 l=0.94
X1612 VGND a_8145_2562# digital_0._109_.Q VGND sky130_fd_pr__nfet_01v8 ad=0.169 pd=1.82 as=0.08775 ps=0.92 w=0.65 l=0.15
X1613 a_3722_6824# a_3506_4904# VGND sky130_fd_pr__res_high_po w=0.36 l=7.36
X1614 a_26134_13064# a_25918_11144# VGND sky130_fd_pr__res_high_po w=0.36 l=7.36
X1615 LELO_GR01_0.x7.x29.N a_17724_11144# VGND sky130_fd_pr__res_high_po w=0.36 l=7.36
X1616 uio_out<7> a_8689_n676# VDPWR VDPWR sky130_fd_pr__pfet_01v8_hvt ad=0.495 pd=2.99 as=0.2726 ps=1.61 w=1 l=0.15
X1617 VDPWR digital_0.clkload0.A a_13513_3138# VDPWR sky130_fd_pr__pfet_01v8_hvt ad=0.0864 pd=0.91 as=0.1664 ps=1.8 w=0.64 l=0.15
X1618 a_15634_1474# digital_0.input3.X VGND VGND sky130_fd_pr__nfet_01v8 ad=0.1134 pd=1.38 as=0.1228 ps=1.065 w=0.42 l=0.15
X1619 VGND a_10721_2348# digital_0._111_.Q VGND sky130_fd_pr__nfet_01v8 ad=0.169 pd=1.82 as=0.08775 ps=0.92 w=0.65 l=0.15
X1620 VDPWR a_5974_n676# digital_0._116_.D VDPWR sky130_fd_pr__pfet_01v8_hvt ad=0.265 pd=2.53 as=0.14 ps=1.28 w=1 l=0.15
X1621 VDPWR a_11007_n524# digital_0.hold21.X VDPWR sky130_fd_pr__pfet_01v8_hvt ad=0.14075 pd=1.325 as=0.26 ps=2.52 w=1 l=0.15
X1622 digital_0._115_.D a_7155_930# VGND VGND sky130_fd_pr__nfet_01v8 ad=0.08775 pd=0.92 as=0.169 ps=1.82 w=0.65 l=0.15
X1623 LELO_GR01_0.x7.x25.D LELO_GR01_0.x8.PWRUP_N_1V8 LELO_GR01_0.x7.x30.N VDPWR sky130_fd_pr__pfet_01v8_lvt ad=0.3168 pd=1.62 as=0.5088 ps=2.98 w=0.96 l=0.94
X1624 VGND VDPWR VGND VGND sky130_fd_pr__nfet_01v8 ad=0.143 pd=1.62 as=0 ps=0 w=0.55 l=0.59
X1625 a_11388_956# digital_0.clkbuf_1_1__f_clk.A VDPWR VDPWR sky130_fd_pr__pfet_01v8_hvt ad=0.14 pd=1.28 as=0.14 ps=1.28 w=1 l=0.15
X1626 LELO_GR01_0.x8.x1.x5.IBN LELO_GR01_0.x8.x1.x5.x9<2>.G VGND VGND sky130_fd_pr__nfet_01v8_lvt ad=0.3168 pd=1.62 as=0.5088 ps=2.98 w=0.96 l=0.94
X1627 VGND digital_0.load_slew17.A digital_0._102_.RESET_B VGND sky130_fd_pr__nfet_01v8 ad=0.169 pd=1.82 as=0.08775 ps=0.92 w=0.65 l=0.15
X1628 VDPWR a_10199_2018# a_10089_2044# VDPWR sky130_fd_pr__pfet_01v8_hvt ad=0.07035 pd=0.755 as=0.1155 ps=0.97 w=0.42 l=0.15
X1629 a_4369_2422# a_4019_2050# a_4274_2410# VDPWR sky130_fd_pr__pfet_01v8_hvt ad=0.07245 pd=0.765 as=0.0651 ps=0.73 w=0.42 l=0.15
X1630 a_11758_188# digital_0._063_.A VGND VGND sky130_fd_pr__nfet_01v8 ad=0.08775 pd=0.92 as=0.08775 ps=0.92 w=0.65 l=0.15
X1631 a_3982_386# a_4438_386# a_4396_412# VGND sky130_fd_pr__nfet_01v8 ad=0.0735 pd=0.77 as=0.0441 ps=0.63 w=0.42 l=0.15
X1632 VDPWR VGND VDPWR VDPWR sky130_fd_pr__pfet_01v8_hvt ad=0.2262 pd=2.26 as=0 ps=0 w=0.87 l=0.59
X1633 VDPWR a_4479_n676# a_4585_n676# VDPWR sky130_fd_pr__pfet_01v8_hvt ad=0.14075 pd=1.325 as=0.1092 ps=1.36 w=0.42 l=0.5
X1634 VDPWR VGND VDPWR VDPWR sky130_fd_pr__pfet_01v8_hvt ad=0.2262 pd=2.26 as=0 ps=0 w=0.87 l=0.59
X1635 VDPWR digital_0._116_.Q a_15537_n426# VDPWR sky130_fd_pr__pfet_01v8_hvt ad=0.135 pd=1.27 as=0.28 ps=2.56 w=1 l=0.15
X1636 a_12889_3498# a_12635_3171# VGND VGND sky130_fd_pr__nfet_01v8 ad=0.0693 pd=0.75 as=0.1449 ps=1.11 w=0.42 l=0.15
X1637 VDPWR VGND VDPWR VDPWR sky130_fd_pr__pfet_01v8_hvt ad=0.2262 pd=2.26 as=0 ps=0 w=0.87 l=0.59
X1638 VGND a_7214_n524# digital_0._107_.D VGND sky130_fd_pr__nfet_01v8 ad=0.11285 pd=1.045 as=0.169 ps=1.82 w=0.65 l=0.15
X1639 a_9363_n676# digital_0._060_.B VGND VGND sky130_fd_pr__nfet_01v8 ad=0.0567 pd=0.69 as=0.10187 ps=0.99 w=0.42 l=0.15
X1640 VDPWR a_5661_1260# a_5648_956# VDPWR sky130_fd_pr__pfet_01v8_hvt ad=0.0819 pd=0.81 as=0.0567 ps=0.69 w=0.42 l=0.15
X1641 a_9886_2410# digital_0._111_.D VGND VGND sky130_fd_pr__nfet_01v8 ad=0.066 pd=0.745 as=0.2205 ps=1.89 w=0.42 l=0.15
X1642 LELO_GR01_0.x8.x1.x5.x9<2>.G LELO_GR01_0.x8.x1.x5.x9<2>.G VGND VGND sky130_fd_pr__nfet_01v8_lvt ad=0.3168 pd=1.62 as=0.5088 ps=2.98 w=0.96 l=0.94
X1643 VDPWR a_14175_n702# a_14205_n349# VDPWR sky130_fd_pr__pfet_01v8_hvt ad=0.0693 pd=0.75 as=0.0441 ps=0.63 w=0.42 l=0.15
X1644 VGND clk a_8996_1500# VGND sky130_fd_pr__nfet_01v8 ad=0.0588 pd=0.7 as=0.0588 ps=0.7 w=0.42 l=0.15
X1645 digital_0._108_.D a_6235_3106# VGND VGND sky130_fd_pr__nfet_01v8 ad=0.08775 pd=0.92 as=0.169 ps=1.82 w=0.65 l=0.15
X1646 a_4512_2954# a_4425_2730# a_4108_2840# VDPWR sky130_fd_pr__pfet_01v8_hvt ad=0.12915 pd=1.185 as=0.0588 ps=0.7 w=0.42 l=0.15
X1647 VGND VGND VGND VGND sky130_fd_pr__nfet_01v8 ad=0.468 pd=2.84 as=0 ps=0 w=0.9 l=0.16
X1648 VDPWR VGND VDPWR VDPWR sky130_fd_pr__pfet_01v8_hvt ad=0.2262 pd=2.26 as=0 ps=0 w=0.87 l=0.59
X1649 VDPWR digital_0.load_slew15.X digital_0._107_.RESET_B VDPWR sky130_fd_pr__pfet_01v8_hvt ad=0.26 pd=2.52 as=0.135 ps=1.27 w=1 l=0.15
X1650 VDPWR digital_0._116_.D a_5218_778# VDPWR sky130_fd_pr__pfet_01v8_hvt ad=0.2184 pd=2.2 as=0.12495 ps=1.175 w=0.84 l=0.15
X1651 a_4477_2044# a_3853_2050# a_4369_2422# VDPWR sky130_fd_pr__pfet_01v8_hvt ad=0.1155 pd=0.97 as=0.07245 ps=0.765 w=0.42 l=0.15
X1652 a_8140_412# digital_0._115_.RESET_B VGND VGND sky130_fd_pr__nfet_01v8 ad=0.06405 pd=0.725 as=0.12495 ps=1.015 w=0.42 l=0.15
X1653 LELO_GR01_0.x7.xd1<4>.A LELO_GR01_0.x7.x1.x7.D VDPWR VDPWR sky130_fd_pr__pfet_01v8_lvt ad=0.3168 pd=1.62 as=0.5088 ps=2.98 w=0.96 l=0.94
X1654 VGND a_6315_1474# digital_0.clkbuf_1_0__f_clk.X VGND sky130_fd_pr__nfet_01v8 ad=0.05775 pd=0.695 as=0.0588 ps=0.7 w=0.42 l=0.15
X1655 VDPWR a_14891_930# a_14781_956# VDPWR sky130_fd_pr__pfet_01v8_hvt ad=0.07035 pd=0.755 as=0.1155 ps=0.97 w=0.42 l=0.15
X1656 VGND a_14861_172# a_14795_246# VGND sky130_fd_pr__nfet_01v8 ad=0.12495 pd=1.015 as=0.0669 ps=0.75 w=0.42 l=0.15
X1657 digital_0.input2.X a_8689_n132# VGND VGND sky130_fd_pr__nfet_01v8 ad=0.2079 pd=1.83 as=0.1856 ps=1.26 w=0.42 l=0.15
X1658 a_5942_2404# digital_0._109_.Q a_5870_2404# VGND sky130_fd_pr__nfet_01v8 ad=0.05355 pd=0.675 as=0.0441 ps=0.63 w=0.42 l=0.15
X1659 VGND VDPWR VGND VGND sky130_fd_pr__nfet_01v8 ad=0.143 pd=1.62 as=0 ps=0 w=0.55 l=0.59
X1660 VDPWR a_13481_1474# digital_0._113_.Q VDPWR sky130_fd_pr__pfet_01v8_hvt ad=0.26 pd=2.52 as=0.135 ps=1.27 w=1 l=0.15
X1661 digital_0._060_.A_N a_10997_386# VDPWR VDPWR sky130_fd_pr__pfet_01v8_hvt ad=0.165 pd=1.33 as=0.3 ps=2.6 w=1 l=0.15
X1662 VDPWR digital_0.input1.X a_11673_2588# VDPWR sky130_fd_pr__pfet_01v8_hvt ad=0.0864 pd=0.91 as=0.1664 ps=1.8 w=0.64 l=0.15
X1663 a_8837_2838# digital_0._116_.Q VDPWR VDPWR sky130_fd_pr__pfet_01v8_hvt ad=0.28 pd=2.56 as=0.135 ps=1.27 w=1 l=0.15
X1664 a_11478_412# digital_0._069_.A a_11372_412# VGND sky130_fd_pr__nfet_01v8 ad=0.06195 pd=0.715 as=0.0798 ps=0.8 w=0.42 l=0.15
X1665 VDPWR digital_0._067_.A a_10655_2910# VDPWR sky130_fd_pr__pfet_01v8_hvt ad=0.1664 pd=1.8 as=0.0864 ps=0.91 w=0.64 l=0.15
X1666 a_4658_3510# a_3743_3138# a_4311_3106# VGND sky130_fd_pr__special_nfet_01v8 ad=0.0711 pd=0.755 as=0.0999 ps=0.985 w=0.36 l=0.15
X1667 VDPWR a_7214_n524# digital_0._107_.D VDPWR sky130_fd_pr__pfet_01v8_hvt ad=0.15835 pd=1.395 as=0.26 ps=2.52 w=1 l=0.15
X1668 a_11007_n524# a_11103_n702# VGND VGND sky130_fd_pr__nfet_01v8 ad=0.1092 pd=1.36 as=0.097 ps=0.975 w=0.42 l=0.5
X1669 VGND a_8996_1500# digital_0.clkbuf_1_1__f_clk.A VGND sky130_fd_pr__nfet_01v8 ad=0.05775 pd=0.695 as=0.0588 ps=0.7 w=0.42 l=0.15
X1670 digital_0._118_.RESET_B digital_0.load_slew15.X VDPWR VDPWR sky130_fd_pr__pfet_01v8_hvt ad=0.135 pd=1.27 as=0.26 ps=2.52 w=1 l=0.15
X1671 VDPWR a_15685_386# a_15427_386# VDPWR sky130_fd_pr__pfet_01v8_hvt ad=0.0567 pd=0.69 as=0.1092 ps=1.36 w=0.42 l=0.5
X1672 VGND digital_0._115_.Q a_7375_1276# VGND sky130_fd_pr__nfet_01v8 ad=0.08775 pd=0.92 as=0.08775 ps=0.92 w=0.65 l=0.15
X1673 VDPWR digital_0._069_.A a_11397_1750# VDPWR sky130_fd_pr__pfet_01v8_hvt ad=0.135 pd=1.27 as=0.14 ps=1.28 w=1 l=0.15
X1674 LELO_GR01_0.x8.x3.A LELO_GR01_0.x8.x7.D VDPWR VDPWR sky130_fd_pr__pfet_01v8 ad=0.468 pd=2.84 as=0.468 ps=2.84 w=0.9 l=0.16
X1675 a_4826_1322# digital_0._118_.D VDPWR VDPWR sky130_fd_pr__pfet_01v8_hvt ad=0.0651 pd=0.73 as=0.1092 ps=1.36 w=0.42 l=0.15
X1676 a_4479_n676# a_4243_n676# VDPWR VDPWR sky130_fd_pr__pfet_01v8_hvt ad=0.1092 pd=1.36 as=0.0567 ps=0.69 w=0.42 l=0.5
X1677 VGND a_10066_n524# digital_0._106_.D VGND sky130_fd_pr__nfet_01v8 ad=0.11285 pd=1.045 as=0.169 ps=1.82 w=0.65 l=0.15
X1678 a_4369_1474# digital_0.output13.A VDPWR VDPWR sky130_fd_pr__pfet_01v8_hvt ad=0.1092 pd=1.36 as=0.0567 ps=0.69 w=0.42 l=0.15
X1679 JNWTR_ORX1_CV_0.XA2.A ui_in<1> JNWTR_ORX1_CV_0.XA1.MP1.S VDPWR sky130_fd_pr__pfet_01v8 ad=0.468 pd=2.84 as=0.288 ps=1.54 w=0.9 l=0.16
X1680 a_3717_1528# digital_0.input2.X VGND VGND sky130_fd_pr__nfet_01v8 ad=0.0567 pd=0.69 as=0.1118 ps=1.04 w=0.42 l=0.15
X1681 a_17736_16564# a_17520_14644# VGND sky130_fd_pr__res_high_po w=0.36 l=7.36
X1682 VDPWR digital_0.clkbuf_1_0__f_clk.X a_3577_3138# VDPWR sky130_fd_pr__pfet_01v8_hvt ad=0.0864 pd=0.91 as=0.1664 ps=1.8 w=0.64 l=0.15
X1683 a_20970_16564# a_20754_14644# VGND sky130_fd_pr__res_high_po w=0.36 l=7.36
X1684 a_5144_2954# a_4425_2730# a_4581_2825# VGND sky130_fd_pr__special_nfet_01v8 ad=0.066 pd=0.745 as=0.0594 ps=0.69 w=0.36 l=0.15
X1685 VDPWR a_14319_3828# digital_0.hold24.X VDPWR sky130_fd_pr__pfet_01v8_hvt ad=0.14075 pd=1.325 as=0.26 ps=2.52 w=1 l=0.15
X1686 a_5785_1750# digital_0._116_.Q VDPWR VDPWR sky130_fd_pr__pfet_01v8_hvt ad=0.135 pd=1.27 as=0.135 ps=1.27 w=1 l=0.15
X1687 digital_0._063_.A a_11951_2146# VGND VGND sky130_fd_pr__nfet_01v8 ad=0.08775 pd=0.92 as=0.1304 ps=1.105 w=0.65 l=0.15
X1688 a_4587_2018# a_4369_2422# VGND VGND sky130_fd_pr__nfet_01v8 ad=0.0999 pd=0.985 as=0.1346 ps=1.15 w=0.64 l=0.15
X1689 a_12754_2588# a_11673_2588# a_12407_2830# VDPWR sky130_fd_pr__pfet_01v8_hvt ad=0.0588 pd=0.7 as=0.12915 ps=1.185 w=0.42 l=0.15
X1690 digital_0._109_.D digital_0._069_.B a_7181_3926# VDPWR sky130_fd_pr__pfet_01v8_hvt ad=0.135 pd=1.27 as=0.26 ps=2.52 w=1 l=0.15
X1691 a_7623_2830# a_7405_2588# VGND VGND sky130_fd_pr__nfet_01v8 ad=0.0999 pd=0.985 as=0.1346 ps=1.15 w=0.64 l=0.15
X1692 a_14291_3498# a_14247_3106# a_14125_3510# VGND sky130_fd_pr__nfet_01v8 ad=0.0441 pd=0.63 as=0.1401 ps=1.1 w=0.42 l=0.15
X1693 a_12889_3171# digital_0._110_.Q a_12817_3171# VDPWR sky130_fd_pr__pfet_01v8_hvt ad=0.1932 pd=1.34 as=0.0441 ps=0.63 w=0.42 l=0.15
X1694 digital_0.hold28.A a_4833_3436# VDPWR VDPWR sky130_fd_pr__pfet_01v8_hvt ad=0.135 pd=1.27 as=0.3012 ps=2.66 w=1 l=0.15
X1695 VDPWR a_7643_n702# a_7673_n349# VDPWR sky130_fd_pr__pfet_01v8_hvt ad=0.0693 pd=0.75 as=0.0441 ps=0.63 w=0.42 l=0.15
X1696 VDPWR digital_0.load_slew15.X digital_0._117_.RESET_B VDPWR sky130_fd_pr__pfet_01v8_hvt ad=0.26 pd=2.52 as=0.135 ps=1.27 w=1 l=0.15
X1697 VDPWR LELO_GR01_0.x7.xd1<4>.A LELO_GR01_0.x7.x15.I2 VDPWR sky130_fd_pr__pfet_01v8_lvt ad=0.5088 pd=2.98 as=0.3168 ps=1.62 w=0.96 l=0.94
X1698 VDPWR digital_0._110_.Q a_11431_2382# VDPWR sky130_fd_pr__pfet_01v8_hvt ad=0.16655 pd=1.39 as=0.0567 ps=0.69 w=0.42 l=0.15
X1699 VDPWR a_11388_956# digital_0.clkload0.A VDPWR sky130_fd_pr__pfet_01v8_hvt ad=0.14 pd=1.28 as=0.14 ps=1.28 w=1 l=0.15
X1700 a_14948_3498# digital_0._102_.RESET_B VGND VGND sky130_fd_pr__nfet_01v8 ad=0.06405 pd=0.725 as=0.12495 ps=1.015 w=0.42 l=0.15
X1701 a_13306_412# a_12391_412# a_12959_654# VGND sky130_fd_pr__special_nfet_01v8 ad=0.0711 pd=0.755 as=0.0999 ps=0.985 w=0.36 l=0.15
X1702 a_14673_1334# a_14157_962# a_14578_1322# VGND sky130_fd_pr__special_nfet_01v8 ad=0.0594 pd=0.69 as=0.066 ps=0.745 w=0.36 l=0.15
X1703 digital_0.clkbuf_1_0__f_clk.X a_6315_1474# VGND VGND sky130_fd_pr__nfet_01v8 ad=0.0588 pd=0.7 as=0.0588 ps=0.7 w=0.42 l=0.15
X1704 VDPWR digital_0.clkload0.A a_9465_n126# VDPWR sky130_fd_pr__pfet_01v8_hvt ad=0.0864 pd=0.91 as=0.1664 ps=1.8 w=0.64 l=0.15
X1705 a_22470_13064# a_22254_11144# VGND sky130_fd_pr__res_high_po w=0.36 l=7.36
X1706 VDPWR a_10066_n524# digital_0._106_.D VDPWR sky130_fd_pr__pfet_01v8_hvt ad=0.15835 pd=1.395 as=0.26 ps=2.52 w=1 l=0.15
X1707 VGND digital_0.clkbuf_1_1__f_clk.A a_11388_956# VGND sky130_fd_pr__nfet_01v8 ad=0.0588 pd=0.7 as=0.0588 ps=0.7 w=0.42 l=0.15
X1708 VGND digital_0.load_slew15.A digital_0._114_.RESET_B VGND sky130_fd_pr__nfet_01v8 ad=0.169 pd=1.82 as=0.08775 ps=0.92 w=0.65 l=0.15
X1709 a_5189_1827# digital_0._109_.Q a_4730_1652# VDPWR sky130_fd_pr__pfet_01v8_hvt ad=0.0441 pd=0.63 as=0.1932 ps=1.34 w=0.42 l=0.15
X1710 VDPWR VGND VDPWR VDPWR sky130_fd_pr__pfet_01v8_hvt ad=0.2262 pd=2.26 as=0 ps=0 w=0.87 l=0.59
X1711 a_4609_110# digital_0.clkbuf_1_0__f_clk.X VGND VGND sky130_fd_pr__nfet_01v8 ad=0.1092 pd=1.36 as=0.0567 ps=0.69 w=0.42 l=0.15
X1712 digital_0.clkbuf_1_1__f_clk.A a_8996_1500# VGND VGND sky130_fd_pr__nfet_01v8 ad=0.0588 pd=0.7 as=0.0588 ps=0.7 w=0.42 l=0.15
X1713 a_14121_246# a_13605_n126# a_14026_234# VGND sky130_fd_pr__special_nfet_01v8 ad=0.0594 pd=0.69 as=0.066 ps=0.745 w=0.36 l=0.15
X1714 VGND VDPWR VGND VGND sky130_fd_pr__nfet_01v8 ad=0.143 pd=1.62 as=0 ps=0 w=0.55 l=0.59
X1715 VDPWR VGND VDPWR VDPWR sky130_fd_pr__pfet_01v8_hvt ad=0.2262 pd=2.26 as=0 ps=0 w=0.87 l=0.59
X1716 VDPWR digital_0.clkload0.A a_13605_n126# VDPWR sky130_fd_pr__pfet_01v8_hvt ad=0.0864 pd=0.91 as=0.1664 ps=1.8 w=0.64 l=0.15
X1717 VGND VDPWR VGND VGND sky130_fd_pr__nfet_01v8 ad=0.143 pd=1.62 as=0 ps=0 w=0.55 l=0.59
X1718 VGND a_10997_386# digital_0._060_.A_N VGND sky130_fd_pr__nfet_01v8 ad=0.17515 pd=1.265 as=0.10725 ps=0.98 w=0.65 l=0.15
X1719 a_25942_16564# a_25726_14644# VGND sky130_fd_pr__res_high_po w=0.36 l=7.36
X1720 a_28070_13064# a_28286_11144# VGND sky130_fd_pr__res_high_po w=0.36 l=7.36
X1721 VDPWR digital_0._100_.RESET_B a_4726_2954# VDPWR sky130_fd_pr__pfet_01v8_hvt ad=0.07035 pd=0.755 as=0.1092 ps=1.36 w=0.42 l=0.15
X1722 VDPWR a_10495_n702# a_10525_n349# VDPWR sky130_fd_pr__pfet_01v8_hvt ad=0.0693 pd=0.75 as=0.0441 ps=0.63 w=0.42 l=0.15
X1723 a_11260_3132# a_10183_3138# a_11098_3510# VDPWR sky130_fd_pr__pfet_01v8_hvt ad=0.0567 pd=0.69 as=0.0588 ps=0.7 w=0.42 l=0.15
X1724 a_3821_2562# a_4108_2840# VDPWR VDPWR sky130_fd_pr__pfet_01v8_hvt ad=0.0567 pd=0.69 as=0.1134 ps=1.38 w=0.42 l=0.15
X1725 a_13513_956# digital_0._063_.B digital_0._112_.D VDPWR sky130_fd_pr__pfet_01v8_hvt ad=0.26 pd=2.52 as=0.135 ps=1.27 w=1 l=0.15
X1726 VDPWR a_5787_2146# digital_0._069_.A VDPWR sky130_fd_pr__pfet_01v8_hvt ad=0.26 pd=2.52 as=0.135 ps=1.27 w=1 l=0.15
X1727 a_6315_1474# digital_0.clkbuf_1_1__f_clk.A VGND VGND sky130_fd_pr__nfet_01v8 ad=0.0588 pd=0.7 as=0.0588 ps=0.7 w=0.42 l=0.15
X1728 a_10997_386# digital_0._069_.A VDPWR VDPWR sky130_fd_pr__pfet_01v8_hvt ad=0.07455 pd=0.775 as=0.0777 ps=0.79 w=0.42 l=0.15
X1729 VGND a_4594_3650# a_4354_3834# VGND sky130_fd_pr__nfet_01v8 ad=0.1228 pd=1.065 as=0.17225 ps=1.83 w=0.65 l=0.25
X1730 VDPWR digital_0._063_.A a_12116_n132# VDPWR sky130_fd_pr__pfet_01v8_hvt ad=0.1625 pd=1.325 as=0.135 ps=1.27 w=1 l=0.15
X1731 a_14125_3510# a_13679_3138# a_14029_3510# VGND sky130_fd_pr__special_nfet_01v8 ad=0.1401 pd=1.1 as=0.0594 ps=0.69 w=0.36 l=0.15
X1732 a_10183_3138# a_10017_3138# VDPWR VDPWR sky130_fd_pr__pfet_01v8_hvt ad=0.1664 pd=1.8 as=0.0864 ps=0.91 w=0.64 l=0.15
X1733 VDPWR a_6761_930# a_6503_930# VDPWR sky130_fd_pr__pfet_01v8_hvt ad=0.0567 pd=0.69 as=0.1092 ps=1.36 w=0.42 l=0.5
X1734 a_3290_6824# a_3506_4904# VGND sky130_fd_pr__res_high_po w=0.36 l=7.36
X1735 LELO_GR01_0.x8.x5.XA3.MN1.S uo_out<0> VGND VGND sky130_fd_pr__nfet_01v8 ad=0.288 pd=1.54 as=0.468 ps=2.84 w=0.9 l=0.16
X1736 a_10546_2422# a_9631_2050# a_10199_2018# VGND sky130_fd_pr__special_nfet_01v8 ad=0.0711 pd=0.755 as=0.0999 ps=0.985 w=0.36 l=0.15
X1737 VGND a_4833_3436# a_4767_3510# VGND sky130_fd_pr__nfet_01v8 ad=0.12495 pd=1.015 as=0.0669 ps=0.75 w=0.42 l=0.15
X1738 a_11835_3828# a_11931_3650# VDPWR VDPWR sky130_fd_pr__pfet_01v8_hvt ad=0.1092 pd=1.36 as=0.14075 ps=1.325 w=0.42 l=0.5
X1739 VDPWR a_7961_386# a_7948_778# VDPWR sky130_fd_pr__pfet_01v8_hvt ad=0.0819 pd=0.81 as=0.0567 ps=0.69 w=0.42 l=0.15
X1740 digital_0.clkbuf_1_1__f_clk.A a_8996_1500# VDPWR VDPWR sky130_fd_pr__pfet_01v8_hvt ad=0.14 pd=1.28 as=0.1375 ps=1.275 w=1 l=0.15
X1741 a_11388_956# digital_0.clkbuf_1_1__f_clk.A VGND VGND sky130_fd_pr__nfet_01v8 ad=0.0588 pd=0.7 as=0.1113 ps=1.37 w=0.42 l=0.15
X1742 LELO_GR01_0.x8.x5.XA5.A LELO_GR01_0.x8.x5.XA7.CN LELO_GR01_0.x8.x5.XA3.MP1.S LELO_GR01_0.x8.x8.D sky130_fd_pr__pfet_01v8 ad=0.468 pd=2.84 as=0.288 ps=1.54 w=0.9 l=0.16
X1743 a_4355_3498# a_4311_3106# a_4189_3510# VGND sky130_fd_pr__nfet_01v8 ad=0.0441 pd=0.63 as=0.1401 ps=1.1 w=0.42 l=0.15
X1744 VDPWR digital_0._067_.A a_11949_3132# VDPWR sky130_fd_pr__pfet_01v8_hvt ad=0.135 pd=1.27 as=0.28 ps=2.56 w=1 l=0.15
X1745 a_11772_n702# a_11898_n518# VDPWR VDPWR sky130_fd_pr__pfet_01v8_hvt ad=0.2173 pd=2.17 as=0.2726 ps=1.61 w=0.82 l=0.25
X1746 a_9245_412# a_8895_412# a_9150_412# VDPWR sky130_fd_pr__pfet_01v8_hvt ad=0.07245 pd=0.765 as=0.0651 ps=0.73 w=0.42 l=0.15
X1747 VGND a_6209_386# a_5951_386# VGND sky130_fd_pr__nfet_01v8 ad=0.0567 pd=0.69 as=0.1092 ps=1.36 w=0.42 l=0.5
X1748 VGND a_8996_1500# digital_0.clkbuf_1_1__f_clk.A VGND sky130_fd_pr__nfet_01v8 ad=0.0588 pd=0.7 as=0.0588 ps=0.7 w=0.42 l=0.15
X1749 a_7349_3132# digital_0.output13.A VDPWR VDPWR sky130_fd_pr__pfet_01v8_hvt ad=0.14 pd=1.28 as=0.14 ps=1.28 w=1 l=0.15
X1750 VGND a_6315_1474# digital_0.clkbuf_1_0__f_clk.X VGND sky130_fd_pr__nfet_01v8 ad=0.0588 pd=0.7 as=0.0588 ps=0.7 w=0.42 l=0.15
X1751 digital_0._110_.RESET_B digital_0.load_slew17.A a_12977_2044# VDPWR sky130_fd_pr__pfet_01v8_hvt ad=0.135 pd=1.27 as=0.26 ps=2.52 w=1 l=0.15
X1752 VGND digital_0.clkbuf_1_0__f_clk.X a_3853_2050# VGND sky130_fd_pr__nfet_01v8 ad=0.0567 pd=0.69 as=0.1092 ps=1.36 w=0.42 l=0.15
X1753 LELO_GR01_0.x8.PWRUP_N_1V8 LELO_GR01_0.PWRUP_1V8 VDPWR VDPWR sky130_fd_pr__pfet_01v8 ad=0.468 pd=2.84 as=0.468 ps=2.84 w=0.9 l=0.16
X1754 a_14175_n702# digital_0.hold28.A VGND VGND sky130_fd_pr__nfet_01v8 ad=0.1092 pd=1.36 as=0.1449 ps=1.11 w=0.42 l=0.15
X1755 VDPWR digital_0._115_.Q a_7826_956# VDPWR sky130_fd_pr__pfet_01v8_hvt ad=0.135 pd=1.27 as=0.135 ps=1.27 w=1 l=0.15
X1756 VGND digital_0._069_.A digital_0._109_.D VGND sky130_fd_pr__nfet_01v8 ad=0.182 pd=1.86 as=0.08775 ps=0.92 w=0.65 l=0.15
X1757 digital_0.clkload0.A a_11388_956# VDPWR VDPWR sky130_fd_pr__pfet_01v8_hvt ad=0.14 pd=1.28 as=0.14 ps=1.28 w=1 l=0.15
X1758 a_22266_16564# a_22050_14644# VGND sky130_fd_pr__res_high_po w=0.36 l=7.36
X1759 LELO_GR01_0.x7.x1.x5.x9<2>.G LELO_GR01_0.x7.x1.x5.x8.G LELO_GR01_0.x7.x1.x5.x6.N LELO_GR01_0.x7.x1.x5.x6.N sky130_fd_pr__pfet_01v8_lvt ad=0.3168 pd=1.62 as=0.5088 ps=2.98 w=0.96 l=0.94
X1760 a_14217_246# a_13771_n126# a_14121_246# VGND sky130_fd_pr__special_nfet_01v8 ad=0.1401 pd=1.1 as=0.0594 ps=0.69 w=0.36 l=0.15
X1761 VDPWR a_10751_3106# a_10641_3132# VDPWR sky130_fd_pr__pfet_01v8_hvt ad=0.07035 pd=0.755 as=0.1155 ps=0.97 w=0.42 l=0.15
X1762 VDPWR digital_0._108_.Q a_6179_3132# VDPWR sky130_fd_pr__pfet_01v8_hvt ad=0.1625 pd=1.325 as=0.26 ps=2.52 w=1 l=0.15
X1763 a_13771_n126# a_13605_n126# VGND VGND sky130_fd_pr__nfet_01v8 ad=0.1092 pd=1.36 as=0.0567 ps=0.69 w=0.42 l=0.15
X1764 VGND a_3492_930# uio_out<1> VGND sky130_fd_pr__nfet_01v8 ad=0.1856 pd=1.26 as=0.2079 ps=1.83 w=0.42 l=0.15
X1765 a_7970_2588# a_7055_2588# a_7623_2830# VGND sky130_fd_pr__special_nfet_01v8 ad=0.0711 pd=0.755 as=0.0999 ps=0.985 w=0.36 l=0.15
X1766 digital_0._109_.RESET_B digital_0.load_slew15.A VGND VGND sky130_fd_pr__nfet_01v8 ad=0.08775 pd=0.92 as=0.08775 ps=0.92 w=0.65 l=0.15
X1767 a_5215_3676# a_4979_3676# VGND VGND sky130_fd_pr__nfet_01v8 ad=0.1092 pd=1.36 as=0.0567 ps=0.69 w=0.42 l=0.5
X1768 a_5056_n702# a_5182_n518# VDPWR VDPWR sky130_fd_pr__pfet_01v8_hvt ad=0.2173 pd=2.17 as=0.2726 ps=1.61 w=0.82 l=0.25
X1769 a_7126_412# digital_0._115_.D VDPWR VDPWR sky130_fd_pr__pfet_01v8_hvt ad=0.0651 pd=0.73 as=0.1092 ps=1.36 w=0.42 l=0.15
X1770 VDPWR a_13481_386# digital_0._112_.Q VDPWR sky130_fd_pr__pfet_01v8_hvt ad=0.26 pd=2.52 as=0.135 ps=1.27 w=1 l=0.15
X1771 VDPWR VGND VDPWR VDPWR sky130_fd_pr__pfet_01v8_hvt ad=0.2262 pd=2.26 as=0 ps=0 w=0.87 l=0.59
X1772 a_9650_11154# a_9434_9234# VGND sky130_fd_pr__res_high_po w=0.36 l=7.36
X1773 a_7436_3452# digital_0._108_.Q VGND VGND sky130_fd_pr__nfet_01v8 ad=0.08937 pd=0.925 as=0.18525 ps=1.87 w=0.65 l=0.15
X1774 VGND digital_0.output8.A a_12501_3676# VGND sky130_fd_pr__nfet_01v8 ad=0.1228 pd=1.065 as=0.1134 ps=1.38 w=0.42 l=0.15
X1775 digital_0._110_.Q a_12929_2562# VGND VGND sky130_fd_pr__nfet_01v8 ad=0.08775 pd=0.92 as=0.2087 ps=2.02 w=0.65 l=0.15
X1776 LELO_GR01_0.x7.x1.x5.x6.N a_10472_17784# VGND sky130_fd_pr__res_high_po w=0.36 l=7.36
X1777 VGND LELO_GR01_0.x7.x1.x5.x9<2>.G LELO_GR01_0.x7.x1.x5.IBN VGND sky130_fd_pr__nfet_01v8_lvt ad=0.5088 pd=2.98 as=0.3168 ps=1.62 w=0.96 l=0.94
X1778 VDPWR LELO_GR01_0.x7.xd1<4>.A LELO_GR01_0.x7.x15.I2 VDPWR sky130_fd_pr__pfet_01v8_lvt ad=0.5088 pd=2.98 as=0.3168 ps=1.62 w=0.96 l=0.94
X1779 LELO_GR01_0.x7.xd1<4>.A LELO_GR01_0.x7.x18.D LELO_GR01_0.x7.x6<3>.G VGND sky130_fd_pr__nfet_01v8_lvt ad=0.3168 pd=1.62 as=0.5088 ps=2.98 w=0.96 l=0.94
X1780 a_4189_3510# a_3743_3138# a_4093_3510# VGND sky130_fd_pr__special_nfet_01v8 ad=0.1401 pd=1.1 as=0.0594 ps=0.69 w=0.36 l=0.15
X1781 VDPWR a_14769_3436# digital_0.output7.A VDPWR sky130_fd_pr__pfet_01v8_hvt ad=0.26 pd=2.52 as=0.135 ps=1.27 w=1 l=0.15
X1782 LELO_GR01_0.x8.x5.XA7.C VDPWR LELO_GR01_0.x8.x5.XA1.MN1.S VGND sky130_fd_pr__nfet_01v8 ad=0.468 pd=2.84 as=0.288 ps=1.54 w=0.9 l=0.16
X1783 a_14026_234# digital_0._105_.D VGND VGND sky130_fd_pr__nfet_01v8 ad=0.066 pd=0.745 as=0.2205 ps=1.89 w=0.42 l=0.15
X1784 VGND a_8578_n676# a_8689_n676# VGND sky130_fd_pr__nfet_01v8 ad=0.1856 pd=1.26 as=0.17225 ps=1.83 w=0.65 l=0.25
X1785 a_27238_16564# a_27022_14644# VGND sky130_fd_pr__res_high_po w=0.36 l=7.36
X1786 a_7643_n702# digital_0.hold28.A VGND VGND sky130_fd_pr__nfet_01v8 ad=0.1092 pd=1.36 as=0.1449 ps=1.11 w=0.42 l=0.15
X1787 a_13978_3650# digital_0.output7.A VGND VGND sky130_fd_pr__nfet_01v8 ad=0.1134 pd=1.38 as=0.1228 ps=1.065 w=0.42 l=0.15
X1788 VDPWR a_8996_1500# digital_0.clkbuf_1_1__f_clk.A VDPWR sky130_fd_pr__pfet_01v8_hvt ad=0.14 pd=1.28 as=0.14 ps=1.28 w=1 l=0.15
X1789 VGND a_14990_386# a_14750_570# VGND sky130_fd_pr__nfet_01v8 ad=0.1228 pd=1.065 as=0.17225 ps=1.83 w=0.65 l=0.25
X1790 VGND a_6407_1188# digital_0.hold28.X VGND sky130_fd_pr__nfet_01v8 ad=0.097 pd=0.975 as=0.169 ps=1.82 w=0.65 l=0.15
X1791 digital_0._113_.Q a_13481_1474# VDPWR VDPWR sky130_fd_pr__pfet_01v8_hvt ad=0.135 pd=1.27 as=0.3012 ps=2.66 w=1 l=0.15
X1792 VGND a_7593_2348# digital_0._108_.Q VGND sky130_fd_pr__nfet_01v8 ad=0.169 pd=1.82 as=0.08775 ps=0.92 w=0.65 l=0.15
X1793 a_12116_n132# digital_0._063_.A VDPWR VDPWR sky130_fd_pr__pfet_01v8_hvt ad=0.26 pd=2.52 as=0.1625 ps=1.325 w=1 l=0.15
X1794 VDPWR digital_0._113_.Q a_12903_206# VDPWR sky130_fd_pr__pfet_01v8_hvt ad=0.16655 pd=1.39 as=0.0567 ps=0.69 w=0.42 l=0.15
X1795 a_13888_n349# digital_0.hold28.A VDPWR VDPWR sky130_fd_pr__pfet_01v8_hvt ad=0.07665 pd=0.785 as=0.15835 ps=1.395 w=0.42 l=0.15
X1796 VDPWR a_10253_930# digital_0._060_.B VDPWR sky130_fd_pr__pfet_01v8_hvt ad=0.26 pd=2.52 as=0.135 ps=1.27 w=1 l=0.15
X1797 VDPWR VGND VDPWR VDPWR sky130_fd_pr__pfet_01v8_hvt ad=0.2262 pd=2.26 as=0 ps=0 w=0.87 l=0.59
X1798 VDPWR a_3492_930# uio_out<1> VDPWR sky130_fd_pr__pfet_01v8_hvt ad=0.2726 pd=1.61 as=0.495 ps=2.99 w=1 l=0.15
X1799 digital_0.output7.A a_14769_3436# VGND VGND sky130_fd_pr__nfet_01v8 ad=0.08775 pd=0.92 as=0.2087 ps=2.02 w=0.65 l=0.15
X1800 digital_0._102_.D a_12889_3171# VDPWR VDPWR sky130_fd_pr__pfet_01v8_hvt ad=0.26 pd=2.52 as=0.15835 ps=1.395 w=1 l=0.15
X1801 VGND VDPWR VGND VGND sky130_fd_pr__nfet_01v8 ad=0.143 pd=1.62 as=0 ps=0 w=0.55 l=0.59
X1802 LELO_GR01_0.x8.x1.x7.D LELO_GR01_0.x8.IBP_BG LELO_GR01_0.x8.x1.x5.IBN VGND sky130_fd_pr__nfet_01v8_lvt ad=0.3168 pd=1.62 as=0.5088 ps=2.98 w=0.96 l=0.94
X1803 a_13415_1500# a_12225_1500# a_13306_1500# VGND sky130_fd_pr__special_nfet_01v8 ad=0.0669 pd=0.75 as=0.0711 ps=0.755 w=0.36 l=0.15
X1804 VDPWR LELO_GR01_0.x7.xd1<4>.A LELO_GR01_0.x8.VREF_BG VDPWR sky130_fd_pr__pfet_01v8_lvt ad=0.5088 pd=2.98 as=0.3168 ps=1.62 w=0.96 l=0.94
X1805 LELO_GR01_0.x7.x23.D LELO_GR01_0.x8.PWRUP_N_1V8 LELO_GR01_0.x7.x22.D VDPWR sky130_fd_pr__pfet_01v8_lvt ad=0.5088 pd=2.98 as=0.3168 ps=1.62 w=0.96 l=0.94
X1806 VGND a_4765_n158# a_4696_n132# VGND sky130_fd_pr__nfet_01v8 ad=0.1346 pd=1.15 as=0.0999 ps=0.985 w=0.64 l=0.15
X1807 a_12741_412# a_12391_412# a_12646_412# VDPWR sky130_fd_pr__pfet_01v8_hvt ad=0.07245 pd=0.765 as=0.0651 ps=0.73 w=0.42 l=0.15
X1808 VDPWR digital_0.input1.X a_12225_412# VDPWR sky130_fd_pr__pfet_01v8_hvt ad=0.0864 pd=0.91 as=0.1664 ps=1.8 w=0.64 l=0.15
X1809 a_14624_386# a_14750_570# VDPWR VDPWR sky130_fd_pr__pfet_01v8_hvt ad=0.2173 pd=2.17 as=0.2726 ps=1.61 w=0.82 l=0.25
X1810 a_12626_n676# a_12409_n676# VGND VGND sky130_fd_pr__nfet_01v8 ad=0.17225 pd=1.83 as=0.1228 ps=1.065 w=0.65 l=0.25
X1811 LELO_GR01_0.x7.x1.x5.x9<2>.G LELO_GR01_0.x7.x1.x5.x8.G LELO_GR01_0.x7.x1.x5.x8.G VGND sky130_fd_pr__nfet_01v8_lvt ad=0.5088 pd=2.98 as=0.3168 ps=1.62 w=0.96 l=0.94
X1812 a_5661_1260# digital_0._118_.RESET_B VDPWR VDPWR sky130_fd_pr__pfet_01v8_hvt ad=0.0567 pd=0.69 as=0.0819 ps=0.81 w=0.42 l=0.15
X1813 a_9972_778# a_8895_412# a_9810_412# VDPWR sky130_fd_pr__pfet_01v8_hvt ad=0.0567 pd=0.69 as=0.0588 ps=0.7 w=0.42 l=0.15
X1814 VDPWR digital_0.clkbuf_1_0__f_clk.X a_4405_962# VDPWR sky130_fd_pr__pfet_01v8_hvt ad=0.0864 pd=0.91 as=0.1664 ps=1.8 w=0.64 l=0.15
X1815 a_4477_2044# digital_0._101_.RESET_B VDPWR VDPWR sky130_fd_pr__pfet_01v8_hvt ad=0.1092 pd=1.36 as=0.07035 ps=0.755 w=0.42 l=0.15
X1816 a_12916_2954# a_11839_2588# a_12754_2588# VDPWR sky130_fd_pr__pfet_01v8_hvt ad=0.0567 pd=0.69 as=0.0588 ps=0.7 w=0.42 l=0.15
X1817 VDPWR a_14298_1652# digital_0._104_.D VDPWR sky130_fd_pr__pfet_01v8_hvt ad=0.15835 pd=1.395 as=0.26 ps=2.52 w=1 l=0.15
X1818 VDPWR VGND VDPWR VDPWR sky130_fd_pr__pfet_01v8_hvt ad=0.2262 pd=2.26 as=0 ps=0 w=0.87 l=0.59
X1819 LELO_GR01_0.x8.x5.XA6.MP1.S LELO_GR01_0.x8.x5.XA6.A LELO_GR01_0.x8.x8.D LELO_GR01_0.x8.x8.D sky130_fd_pr__pfet_01v8 ad=0.288 pd=1.54 as=0.468 ps=2.84 w=0.9 l=0.16
X1820 a_10495_n702# digital_0.hold28.A VGND VGND sky130_fd_pr__nfet_01v8 ad=0.1092 pd=1.36 as=0.1449 ps=1.11 w=0.42 l=0.15
X1821 VGND a_8085_1500# digital_0.load_slew15.X VGND sky130_fd_pr__nfet_01v8 ad=0.08775 pd=0.92 as=0.08775 ps=0.92 w=0.65 l=0.15
X1822 VDPWR a_12718_3676# a_12829_3676# VDPWR sky130_fd_pr__pfet_01v8_hvt ad=0.2726 pd=1.61 as=0.2173 ps=2.17 w=0.82 l=0.25
X1823 VDPWR a_14339_n158# a_14229_n132# VDPWR sky130_fd_pr__pfet_01v8_hvt ad=0.07035 pd=0.755 as=0.1155 ps=0.97 w=0.42 l=0.15
X1824 digital_0.output9.A a_15413_1260# VGND VGND sky130_fd_pr__nfet_01v8 ad=0.08775 pd=0.92 as=0.2087 ps=2.02 w=0.65 l=0.15
X1825 VGND a_11388_956# digital_0.clkload0.A VGND sky130_fd_pr__nfet_01v8 ad=0.1113 pd=1.37 as=0.0588 ps=0.7 w=0.42 l=0.15
X1826 a_14440_1500# digital_0.hold28.A VGND VGND sky130_fd_pr__nfet_01v8 ad=0.0693 pd=0.75 as=0.11285 ps=1.045 w=0.42 l=0.15
X1827 a_12138_n702# digital_0.output10.A VGND VGND sky130_fd_pr__nfet_01v8 ad=0.1134 pd=1.38 as=0.1228 ps=1.065 w=0.42 l=0.15
X1828 a_6179_3132# digital_0._108_.Q VDPWR VDPWR sky130_fd_pr__pfet_01v8_hvt ad=0.135 pd=1.27 as=0.1625 ps=1.325 w=1 l=0.15
X1829 VGND VDPWR VGND VGND sky130_fd_pr__nfet_01v8 ad=0.143 pd=1.62 as=0 ps=0 w=0.55 l=0.59
X1830 VDPWR digital_0.input2.X digital_0._080_.A2 VDPWR sky130_fd_pr__pfet_01v8_hvt ad=0.26 pd=2.52 as=0.135 ps=1.27 w=1 l=0.15
X1831 a_4425_2730# digital_0.clkbuf_1_0__f_clk.X VGND VGND sky130_fd_pr__nfet_01v8 ad=0.1092 pd=1.36 as=0.0567 ps=0.69 w=0.42 l=0.15
X1832 VGND a_4730_1652# digital_0._101_.D VGND sky130_fd_pr__nfet_01v8 ad=0.11285 pd=1.045 as=0.169 ps=1.82 w=0.65 l=0.15
X1833 digital_0.clkbuf_1_1__f_clk.A a_8996_1500# VDPWR VDPWR sky130_fd_pr__pfet_01v8_hvt ad=0.14 pd=1.28 as=0.14 ps=1.28 w=1 l=0.15
X1834 LELO_GR01_0.x8.x1.x5.IBN LELO_GR01_0.x8.x1.x5.x9<2>.G VGND VGND sky130_fd_pr__nfet_01v8_lvt ad=0.3168 pd=1.62 as=0.5088 ps=2.98 w=0.96 l=0.94
X1835 a_3492_n702# a_3618_n518# VDPWR VDPWR sky130_fd_pr__pfet_01v8_hvt ad=0.2173 pd=2.17 as=0.2726 ps=1.61 w=0.82 l=0.25
X1836 VDPWR digital_0.output13.A a_5787_2146# VDPWR sky130_fd_pr__pfet_01v8_hvt ad=0.0567 pd=0.69 as=0.1092 ps=1.36 w=0.42 l=0.15
X1837 a_13660_1500# digital_0._113_.RESET_B VGND VGND sky130_fd_pr__nfet_01v8 ad=0.06405 pd=0.725 as=0.12495 ps=1.015 w=0.42 l=0.15
X1838 a_3814_386# a_3982_386# VDPWR VDPWR sky130_fd_pr__pfet_01v8_hvt ad=0.26 pd=2.52 as=0.135 ps=1.27 w=1 l=0.15
X1839 a_7527_2422# a_6337_2050# a_7418_2422# VGND sky130_fd_pr__special_nfet_01v8 ad=0.0669 pd=0.75 as=0.0711 ps=0.755 w=0.36 l=0.15
X1840 VDPWR LELO_GR01_0.x7.xd1<4>.A sky130_fd_pr__cap_mim_m3_1 l=5 w=5
X1841 a_14323_962# a_14157_962# VGND VGND sky130_fd_pr__nfet_01v8 ad=0.1092 pd=1.36 as=0.0567 ps=0.69 w=0.42 l=0.15
X1842 a_3858_930# digital_0.output6.A VGND VGND sky130_fd_pr__nfet_01v8 ad=0.1134 pd=1.38 as=0.1228 ps=1.065 w=0.42 l=0.15
X1843 a_14029_3510# a_13679_3138# a_13934_3498# VDPWR sky130_fd_pr__pfet_01v8_hvt ad=0.07245 pd=0.765 as=0.0651 ps=0.73 w=0.42 l=0.15
X1844 a_15662_2044# a_15445_2044# VGND VGND sky130_fd_pr__nfet_01v8 ad=0.17225 pd=1.83 as=0.1228 ps=1.065 w=0.65 l=0.25
X1845 VGND digital_0._116_.Q digital_0._114_.RESET_B VGND sky130_fd_pr__nfet_01v8 ad=0.08775 pd=0.92 as=0.08775 ps=0.92 w=0.65 l=0.15
X1846 VGND a_6315_1474# digital_0.clkbuf_1_0__f_clk.X VGND sky130_fd_pr__nfet_01v8 ad=0.0588 pd=0.7 as=0.0588 ps=0.7 w=0.42 l=0.15
X1847 LELO_GR01_0.x7.x18.D LELO_GR01_0.x7.xd1<4>.A VGND VGND sky130_fd_pr__nfet_01v8_lvt ad=0.3168 pd=1.62 as=0.5088 ps=2.98 w=0.96 l=0.94
X1848 a_12138_n702# digital_0.output10.A VDPWR VDPWR sky130_fd_pr__pfet_01v8_hvt ad=0.27 pd=2.54 as=0.19265 ps=1.415 w=1 l=0.15
X1849 a_10077_2422# a_9631_2050# a_9981_2422# VGND sky130_fd_pr__special_nfet_01v8 ad=0.1401 pd=1.1 as=0.0594 ps=0.69 w=0.36 l=0.15
X1850 digital_0.clkload0.A a_11388_956# VGND VGND sky130_fd_pr__nfet_01v8 ad=0.0588 pd=0.7 as=0.0588 ps=0.7 w=0.42 l=0.15
X1851 LELO_GR01_0.x7.x1.x5.IBN LELO_GR01_0.x7.x7.G LELO_GR01_0.x7.x1.x7.D VGND sky130_fd_pr__nfet_01v8_lvt ad=0.5088 pd=2.98 as=0.3168 ps=1.62 w=0.96 l=0.94
X1852 VGND digital_0._101_.RESET_B a_4631_2410# VGND sky130_fd_pr__nfet_01v8 ad=0.1346 pd=1.15 as=0.0441 ps=0.63 w=0.42 l=0.15
X1853 a_9116_6824# a_9332_4904# VGND sky130_fd_pr__res_high_po w=0.36 l=7.36
X1854 a_5109_2348# a_4934_2422# a_5288_2410# VGND sky130_fd_pr__nfet_01v8 ad=0.1092 pd=1.36 as=0.06405 ps=0.725 w=0.42 l=0.15
X1855 a_10074_2562# a_10285_2910# VDPWR VDPWR sky130_fd_pr__pfet_01v8_hvt ad=0.0928 pd=0.93 as=0.2272 ps=1.35 w=0.64 l=0.15
X1856 VGND digital_0._113_.Q a_12989_206# VGND sky130_fd_pr__nfet_01v8 ad=0.1118 pd=1.04 as=0.0567 ps=0.69 w=0.42 l=0.15
X1857 LELO_GR01_0.x7.x19.D LELO_GR01_0.x8.PWRUP_N_1V8 LELO_GR01_0.x7.x18.D VDPWR sky130_fd_pr__pfet_01v8_lvt ad=0.5088 pd=2.98 as=0.3168 ps=1.62 w=0.96 l=0.94
X1858 VGND a_8996_1500# digital_0.clkbuf_1_1__f_clk.A VGND sky130_fd_pr__nfet_01v8 ad=0.0588 pd=0.7 as=0.0588 ps=0.7 w=0.42 l=0.15
X1859 VDPWR digital_0._065_.A2_N a_11397_1750# VDPWR sky130_fd_pr__pfet_01v8_hvt ad=0.14 pd=1.28 as=0.28 ps=2.56 w=1 l=0.15
X1860 LELO_GR01_0.x8.VREF_BG a_19248_14644# VGND sky130_fd_pr__res_high_po w=0.36 l=7.36
X1861 VGND VDPWR VGND VGND sky130_fd_pr__nfet_01v8 ad=0.143 pd=1.62 as=0 ps=0 w=0.55 l=0.59
X1862 a_5648_956# a_4571_962# a_5486_1334# VDPWR sky130_fd_pr__pfet_01v8_hvt ad=0.0567 pd=0.69 as=0.0588 ps=0.7 w=0.42 l=0.15
X1863 a_14137_3132# a_13513_3138# a_14029_3510# VDPWR sky130_fd_pr__pfet_01v8_hvt ad=0.1155 pd=0.97 as=0.07245 ps=0.765 w=0.42 l=0.15
X1864 a_14383_234# a_14339_n158# a_14217_246# VGND sky130_fd_pr__nfet_01v8 ad=0.0441 pd=0.63 as=0.1401 ps=1.1 w=0.42 l=0.15
X1865 LELO_GR01_0.x8.x5.XA4.MN1.S LELO_GR01_0.x8.x5.XA6.A VGND VGND sky130_fd_pr__nfet_01v8 ad=0.288 pd=1.54 as=0.468 ps=2.84 w=0.9 l=0.16
X1866 LELO_GR01_0.x7.xd1<4>.A LELO_GR01_0.x7.x18.D LELO_GR01_0.x7.x6<3>.G VGND sky130_fd_pr__nfet_01v8_lvt ad=0.3168 pd=1.62 as=0.5088 ps=2.98 w=0.96 l=0.94
X1867 VGND a_12189_3650# a_11931_3650# VGND sky130_fd_pr__nfet_01v8 ad=0.0567 pd=0.69 as=0.1092 ps=1.36 w=0.42 l=0.5
X1868 digital_0._057_.D a_12903_206# VDPWR VDPWR sky130_fd_pr__pfet_01v8_hvt ad=0.195 pd=1.39 as=0.16655 ps=1.39 w=1 l=0.15
X1869 a_3492_930# a_3618_1194# VDPWR VDPWR sky130_fd_pr__pfet_01v8_hvt ad=0.2173 pd=2.17 as=0.2726 ps=1.61 w=0.82 l=0.25
X1870 VDPWR digital_0._113_.Q a_12116_n132# VDPWR sky130_fd_pr__pfet_01v8_hvt ad=0.135 pd=1.27 as=0.26 ps=2.52 w=1 l=0.15
X1871 digital_0._109_.Q a_8145_2562# VDPWR VDPWR sky130_fd_pr__pfet_01v8_hvt ad=0.135 pd=1.27 as=0.3012 ps=2.66 w=1 l=0.15
X1872 VGND digital_0.input3.X digital_0._113_.RESET_B VGND sky130_fd_pr__nfet_01v8 ad=0.169 pd=1.82 as=0.08775 ps=0.92 w=0.65 l=0.15
C0 LELO_GR01_0.x8.x5.XA7.CN LELO_GR01_0.x8.x5.XA3.MP1.S 0.03112f
C1 LELO_GR01_0.x8.x5.XA7.C a_26090_7333# 0.07292f
C2 a_9985_386# VDPWR 0.40703f
C3 digital_0._105_.D digital_0.output10.A 0.02499f
C4 a_13771_n126# a_14229_n132# 0.02757f
C5 digital_0.load_slew17.A digital_0.output8.A 0.18684f
C6 a_11835_3828# a_11931_3650# 0.41909f
C7 a_14358_17550# LELO_GR01_0.x7.x15.I2 0.01611f
C8 uo_out<1> uio_in<4> 0.01524f
C9 a_4386_2856# a_5144_2954# 0.06121f
C10 a_23346_14644# uio_out<5> 0.01127f
C11 LELO_GR01_0.x8.VREF_BG a_23550_11144# 0.01123f
C12 LELO_GR01_0.x7.x15.I2 a_14358_11540# 0.03213f
C13 a_5234_4904# uio_out<0> 0.0326f
C14 a_5882_6824# VDPWR 0.01812f
C15 a_17508_11144# a_17724_11144# 0.01515f
C16 LELO_GR01_0.x7.x29.N a_19018_11144# 0.03827f
C17 digital_0._114_.RESET_B a_9005_956# 0.15798f
C18 digital_0._113_.RESET_B digital_0._112_.RESET_B 0.12568f
C19 a_6761_930# a_6705_412# 0.01002f
C20 a_14323_962# VDPWR 0.58788f
C21 LELO_GR01_0.x7.x1.x5.x8.S a_6636_17010# 0.45344f
C22 LELO_GR01_0.PWRUP_1V8 a_20412_18378# 0.08019f
C23 a_12138_n702# VDPWR 0.23442f
C24 digital_0._067_.B a_11949_3132# 0.05839f
C25 digital_0._109_.RESET_B a_7623_2830# 0.18284f
C26 digital_0.hold28.A digital_0.input1.X 0.79051f
C27 a_16224_14644# VDPWR 0.01295f
C28 digital_0.clkbuf_1_0__f_clk.X a_5144_2954# 0.01376f
C29 digital_0._118_.RESET_B a_4921_1334# 0.15235f
C30 a_25702_13064# uio_out<7> 0.01243f
C31 LELO_GR01_0.x7.x26.P uo_out<0> 0.0433f
C32 digital_0.input1.X digital_0.input2.X 0.05681f
C33 LELO_GR01_0.x7.x15.I1 LELO_GR01_0.x7.x3.P 0.03541f
C34 LELO_GR01_0.x8.PWRUP_N_1V8 LELO_GR01_0.x8.x7.D 0.35908f
C35 digital_0._117_.RESET_B VDPWR 0.51821f
C36 a_13738_3834# uio_out<2> 0.01636f
C37 digital_0._104_.D a_14157_962# 0.19514f
C38 a_4571_962# a_5486_1334# 0.11842f
C39 digital_0._112_.RESET_B a_14990_386# 0.05598f
C40 a_4369_1474# VDPWR 0.27396f
C41 LELO_GR01_0.x8.x1.x5.x9<2>.G a_21554_7573# 0.07745f
C42 digital_0._105_.D VDPWR 0.63078f
C43 JNWTR_TIEL_CV_0.MP0.G VDPWR 0.58424f
C44 a_3743_3138# a_4311_3106# 0.18639f
C45 LELO_GR01_0.x8.VREF_BG uio_out<4> 0.12189f
C46 JNWTR_ORX1_CV_0.A ui_in<1> 0.24778f
C47 digital_0._103_.RESET_B a_11098_3510# 0.23669f
C48 digital_0._111_.Q a_10183_3138# 0.01035f
C49 a_3577_3138# a_4833_3436# 0.04359f
C50 LELO_GR01_0.x7.x7.S LELO_GR01_0.x7.x7.G 1.15979f
C51 digital_0.load_slew15.X digital_0._060_.A_N 0.15303f
C52 digital_0.output13.A a_5785_1750# 0.01672f
C53 a_27454_14644# a_27886_14644# 0.14233f
C54 a_12225_1500# digital_0._113_.D 0.31715f
C55 digital_0._063_.B a_12391_1500# 0.02126f
C56 a_24508_7487# VDPWR 0.49095f
C57 LELO_GR01_0.x8.x5.XA3.MN1.S uo_out<0> 0.01514f
C58 digital_0._112_.D a_12225_412# 0.28454f
C59 a_7961_386# a_7786_412# 0.23366f
C60 digital_0._113_.Q digital_0._105_.D 0.21485f
C61 a_8468_4904# a_8900_4904# 0.14233f
C62 a_9245_412# VDPWR 0.20352f
C63 a_14121_246# a_14217_246# 0.01379f
C64 digital_0.load_slew17.A a_12189_3650# 0.05435f
C65 digital_0.output5.A digital_0._100_.RESET_B 0.07313f
C66 a_8336_17010# LELO_GR01_0.x7.x1.x5.x9<2>.G 0.01325f
C67 LELO_GR01_0.x8.PWRUP_N_1V8 a_16224_14644# 0.02887f
C68 uo_out<1> uio_in<3> 0.01524f
C69 a_4386_2856# a_4726_2954# 0.03462f
C70 digital_0._116_.Q a_15662_2044# 0.01415f
C71 LELO_GR01_0.x7.x11.N uo_out<0> 0.15211f
C72 digital_0.load_slew17.A digital_0.output9.A 0.03145f
C73 digital_0.hold19.X digital_0.output6.A 0.15532f
C74 digital_0.output13.A a_5109_2348# 0.01895f
C75 JNWTR_ORX1_CV_0.A a_22902_13064# 0.02006f
C76 LELO_GR01_0.x7.x15.I2 a_14358_11680# 0.03213f
C77 LELO_GR01_0.x7.x11.P a_26374_16564# 0.01931f
C78 digital_0._065_.A2_N a_11388_956# 0.01442f
C79 LELO_GR01_0.x7.x29.N a_18156_11144# 0.01879f
C80 digital_0._110_.D VDPWR 0.49027f
C81 a_14157_962# VDPWR 0.44164f
C82 digital_0._107_.RESET_B a_8689_n132# 0.04501f
C83 a_10472_17784# a_8552_17568# 0.01515f
C84 a_11898_n518# VDPWR 0.21806f
C85 digital_0._067_.A a_11949_3132# 0.09606f
C86 digital_0._101_.RESET_B digital_0._118_.RESET_B 0.40332f
C87 digital_0._109_.RESET_B a_7055_2588# 0.05867f
C88 a_18168_16564# a_18600_16564# 0.21349f
C89 digital_0._118_.RESET_B a_5139_930# 0.15956f
C90 digital_0.output13.A digital_0.hold28.X 0.09624f
C91 a_25486_11144# uio_out<7> 0.01272f
C92 a_26350_11144# uo_out<0> 0.04079f
C93 LELO_GR01_0.x7.x15.I1 a_7796_9234# 0.04112f
C94 LELO_GR01_0.x8.IBP_BG LELO_GR01_0.x8.x1.x5.x9<2>.G 0.07382f
C95 JNWTR_ORX1_CV_0.A LELO_GR01_0.x8.x1.x5.x8.G 0.0193f
C96 digital_0._100_.RESET_B VDPWR 0.66751f
C97 a_13612_3650# uio_out<2> 0.10554f
C98 a_4571_962# a_5661_1260# 0.04182f
C99 a_4405_962# a_5486_1334# 0.10236f
C100 a_5139_930# a_4921_1334# 0.20964f
C101 digital_0._112_.RESET_B a_14750_570# 0.05059f
C102 a_13481_386# a_13306_412# 0.23366f
C103 a_4111_1474# VDPWR 0.28624f
C104 LELO_GR01_0.x8.x1.x5.x9<2>.G a_19706_6759# 0.09093f
C105 digital_0.hold18.X a_5974_n676# 0.17687f
C106 a_13605_n126# VDPWR 0.43113f
C107 JNWTR_TIEL_CV_0.Y VDPWR 0.54387f
C108 LELO_GR01_0.x8.VREF_BG uio_out<2> 0.02376f
C109 LELO_GR01_0.x8.IBP_BG uio_out<0> 0.06568f
C110 JNWTR_ORX1_CV_0.A ui_in<0> 4.48662f
C111 digital_0._111_.Q a_10017_3138# 0.0202f
C112 digital_0._103_.RESET_B a_11273_3436# 0.27546f
C113 digital_0._103_.D a_10533_3510# 0.03997f
C114 a_3577_3138# a_4093_3510# 0.11535f
C115 LELO_GR01_0.x8.VREF_BG a_22266_16564# 0.06457f
C116 a_12688_14988# a_12688_14728# 0.05215f
C117 LELO_GR01_0.x7.x23.D a_2478_12370# 0.07916f
C118 digital_0.hold28.A digital_0.input3.X 0.03172f
C119 digital_0._063_.B digital_0._113_.D 0.20707f
C120 a_23138_6685# VDPWR 0.40004f
C121 LELO_GR01_0.x8.x5.XA5.A uio_out<5> 0.026f
C122 digital_0._113_.Q a_13605_n126# 0.25134f
C123 a_14121_246# a_14026_234# 0.04983f
C124 a_9463_654# VDPWR 0.20904f
C125 digital_0.load_slew17.A a_11931_3650# 0.07848f
C126 LELO_GR01_0.x7.x1.x5.x8.G a_8336_16210# 0.0824f
C127 a_4578_16260# a_4578_16120# 0.11733f
C128 LELO_GR01_0.PWRUP_1V8 a_16872_16564# 0.02331f
C129 uo_out<1> uio_in<2> 0.01524f
C130 a_4425_2730# digital_0._100_.D 0.24083f
C131 a_4581_2825# a_4512_2954# 0.20964f
C132 digital_0._111_.Q a_9465_2050# 0.01316f
C133 digital_0._116_.Q a_15445_2044# 0.05468f
C134 digital_0.load_slew17.A a_14762_2018# 0.20835f
C135 LELO_GR01_0.x7.x15.I2 a_14358_12480# 0.03247f
C136 digital_0.input1.X digital_0._080_.A2 0.02508f
C137 digital_0._065_.A2_N digital_0._114_.Q 0.55858f
C138 digital_0._112_.Q a_11951_2146# 0.14687f
C139 a_10641_3132# VDPWR 0.1421f
C140 digital_0._113_.D a_12741_412# 0.01345f
C141 a_11388_956# VDPWR 1.29102f
C142 digital_0._107_.RESET_B a_8578_n132# 0.04795f
C143 a_7157_n158# a_7088_n132# 0.20964f
C144 a_6962_n16# digital_0._107_.D 0.27543f
C145 a_26930_6533# a_26930_6213# 0.01f
C146 a_11772_n702# VDPWR 0.20997f
C147 LELO_GR01_0.x7.x10.P VDPWR 0.34764f
C148 digital_0._109_.RESET_B a_6889_2588# 0.3316f
C149 LELO_GR01_0.x7.x10.P a_21402_16564# 0.02289f
C150 digital_0._118_.RESET_B a_4571_962# 0.02494f
C151 digital_0._113_.Q a_11388_956# 0.11853f
C152 digital_0.hold25.X VDPWR 0.48168f
C153 a_4405_962# a_5661_1260# 0.04359f
C154 a_4571_962# a_4921_1334# 0.21686f
C155 digital_0._112_.RESET_B a_14624_386# 0.055f
C156 a_15773_2044# uio_out<4> 0.09104f
C157 a_4015_1652# VDPWR 0.18342f
C158 LELO_GR01_0.x8.x5.XA6.A a_26930_7813# 0.06533f
C159 LELO_GR01_0.x8.x1.x5.x9<2>.G a_19706_7559# 0.0452f
C160 a_12903_206# VDPWR 0.23899f
C161 digital_0.hold19.X a_3743_3138# 0.27766f
C162 JNWTR_ORX1_CV_0.XA1.MP1.S VDPWR 0.10458f
C163 LELO_GR01_0.x8.VREF_BG uio_out<3> 0.08747f
C164 LELO_GR01_0.x8.IBP_BG uo_out<0> 0.21582f
C165 JNWTR_ORX1_CV_0.A rst_n 0.37242f
C166 a_14673_3650# a_13513_3138# 0.0135f
C167 digital_0._111_.Q digital_0.clkload0.A 0.02186f
C168 digital_0._103_.D a_10751_3106# 0.01402f
C169 digital_0._103_.RESET_B a_10533_3510# 0.157f
C170 a_3577_3138# a_4311_3106# 0.07009f
C171 LELO_GR01_0.x8.IBP_BG a_21834_16564# 0.02548f
C172 digital_0._116_.Q a_5486_1334# 0.01394f
C173 digital_0._111_.RESET_B digital_0._111_.D 0.20385f
C174 digital_0._109_.Q a_5159_1474# 0.13541f
C175 digital_0._063_.B a_12225_1500# 0.12895f
C176 a_23138_7485# VDPWR 0.49026f
C177 digital_0.input1.X a_11673_412# 0.03529f
C178 a_12297_2954# VDPWR 0.1435f
C179 a_7439_654# a_7786_412# 0.05116f
C180 digital_0._113_.Q a_12903_206# 0.19479f
C181 a_8895_412# VDPWR 0.56591f
C182 digital_0.load_slew17.A a_11835_3828# 0.04995f
C183 LELO_GR01_0.x7.xd1<4>.A a_14358_14730# 0.07579f
C184 LELO_GR01_0.x7.x1.x5.x8.G LELO_GR01_0.x7.x1.x5.x9<2>.G 2.09666f
C185 a_2478_16300# a_2478_15790# 0.02417f
C186 LELO_GR01_0.x8.PWRUP_N_1V8 LELO_GR01_0.x7.x10.P 0.06805f
C187 LELO_GR01_0.x7.x20.D LELO_GR01_0.x7.x21.D 0.57307f
C188 uo_out<1> uio_in<1> 0.01524f
C189 a_4425_2730# a_4512_2954# 0.05348f
C190 a_4386_2856# digital_0._100_.D 0.22439f
C191 digital_0._116_.Q digital_0.output9.A 0.19446f
C192 a_23562_16564# uio_out<4> 0.01051f
C193 digital_0.clkbuf_1_0__f_clk.X digital_0.output6.A 0.1337f
C194 LELO_GR01_0.x7.x7.G a_4578_10610# 0.07253f
C195 digital_0._065_.A2_N a_10253_930# 0.07749f
C196 a_9981_2422# a_8996_1500# 0.01201f
C197 a_16646_11144# a_17508_11144# 0.04861f
C198 a_7001_110# digital_0._107_.D 0.16641f
C199 digital_0._107_.RESET_B a_8361_n132# 0.05303f
C200 digital_0._114_.Q VDPWR 0.66737f
C201 a_6962_n16# a_7088_n132# 0.18639f
C202 LELO_GR01_0.x8.x7.D a_26926_4531# 0.06129f
C203 LELO_GR01_0.x8.x5.CK a_26088_5351# 0.01111f
C204 a_11361_n702# VDPWR 0.26066f
C205 digital_0._109_.D a_7055_2588# 0.31112f
C206 digital_0.hold28.A a_6263_2562# 0.22302f
C207 a_12635_3171# digital_0._110_.D 0.0229f
C208 digital_0.load_slew17.A digital_0._111_.D 0.03874f
C209 a_16008_14644# VDPWR 0.06123f
C210 digital_0.clkbuf_1_0__f_clk.X digital_0._100_.D 0.07483f
C211 a_17952_14644# a_18384_14644# 0.14233f
C212 digital_0._118_.RESET_B a_4405_962# 0.29772f
C213 LELO_GR01_0.x8.x8.D LELO_GR01_0.x8.x5.CK 0.39672f
C214 JNWTR_ORX1_CV_0.A a_11060_4904# 0.01947f
C215 digital_0._113_.Q digital_0._114_.Q 0.3881f
C216 a_14415_3650# rst_n 0.01083f
C217 a_14673_3650# VDPWR 0.30936f
C218 a_12829_3676# uio_out<3> 0.0971f
C219 a_4405_962# a_4921_1334# 0.11053f
C220 a_4571_962# a_5139_930# 0.18122f
C221 digital_0._112_.RESET_B a_13306_412# 0.22575f
C222 a_3471_1474# VDPWR 0.26987f
C223 LELO_GR01_0.x8.x5.XA6.A a_26090_7813# 0.05912f
C224 a_5422_n702# digital_0.hold18.X 0.05334f
C225 digital_0._107_.D uio_out<7> 0.01273f
C226 a_11758_188# VDPWR 0.20711f
C227 JNWTR_ORX1_CV_0.A VDPWR 2.19041f
C228 LELO_GR01_0.x8.IBP_BG ui_in<1> 0.02064f
C229 digital_0._069_.A a_6455_3452# 0.01228f
C230 digital_0._103_.D a_10183_3138# 0.23454f
C231 digital_0._103_.RESET_B a_10751_3106# 0.16835f
C232 a_3577_3138# a_3743_3138# 0.88863f
C233 a_2478_13170# LELO_GR01_0.x7.x23.D 0.04279f
C234 LELO_GR01_0.x8.IBP_BG a_21618_14644# 0.01094f
C235 digital_0._116_.Q a_5661_1260# 0.03125f
C236 digital_0._065_.A2_N a_10571_2588# 0.04285f
C237 digital_0._109_.Q digital_0.hold22.X 0.27301f
C238 a_11397_1750# a_12225_1500# 0.01371f
C239 digital_0._104_.RESET_B a_14727_1474# 0.01089f
C240 a_12094_2588# VDPWR 0.08586f
C241 a_6871_412# a_7786_412# 0.11876f
C242 digital_0._113_.Q a_11758_188# 0.45f
C243 digital_0._114_.D VDPWR 0.54679f
C244 digital_0.load_slew17.A a_10986_3828# 0.06939f
C245 LELO_GR01_0.x8.PWRUP_N_1V8 a_16008_14644# 0.034f
C246 LELO_GR01_0.x7.xd1<4>.A a_12688_13928# 0.05702f
C247 LELO_GR01_0.x7.x20.D a_2478_15790# 0.0493f
C248 LELO_GR01_0.x7.x1.x5.x8.G a_8336_17010# 0.07053f
C249 uo_out<1> uio_in<0> 0.01524f
C250 a_23346_14644# uio_out<4> 0.0118f
C251 digital_0.load_slew17.A digital_0._112_.Q 0.10061f
C252 digital_0._116_.Q a_14762_2018# 0.04522f
C253 a_4386_2856# a_4512_2954# 0.17589f
C254 a_4425_2730# a_4581_2825# 0.11082f
C255 a_22698_16564# a_23130_16564# 0.21349f
C256 digital_0.load_slew15.X a_8689_n132# 0.03838f
C257 a_4802_4904# uio_out<0> 0.0326f
C258 a_5450_6824# VDPWR 0.02146f
C259 a_7099_956# a_7826_956# 0.02665f
C260 digital_0._114_.RESET_B digital_0._060_.B 0.01056f
C261 a_3722_6824# a_4154_6824# 0.21349f
C262 a_7001_110# a_7088_n132# 0.07009f
C263 digital_0._107_.RESET_B digital_0._107_.D 0.02736f
C264 a_10253_930# VDPWR 0.27902f
C265 a_6962_n16# a_7157_n158# 0.2298f
C266 LELO_GR01_0.x8.x7.D a_26086_4531# 0.05922f
C267 LELO_GR01_0.x8.x5.CK LELO_GR01_0.x8.x3.A 0.22809f
C268 a_26090_6533# a_26090_6213# 0.01f
C269 LELO_GR01_0.x8.PWRUP_N_1V8 JNWTR_ORX1_CV_0.A 0.24515f
C270 a_11103_n702# VDPWR 0.26761f
C271 digital_0._067_.B digital_0._110_.D 0.29553f
C272 digital_0.load_slew17.A digital_0._111_.RESET_B 0.18865f
C273 a_14358_14730# VDPWR 0.41173f
C274 digital_0._109_.D a_6889_2588# 0.21624f
C275 digital_0.clkbuf_1_0__f_clk.X a_4512_2954# 0.04293f
C276 a_4274_2410# digital_0.output6.A 0.01644f
C277 a_25270_13064# uio_out<7> 0.01991f
C278 a_26134_13064# uo_out<0> 0.04036f
C279 LELO_GR01_0.x7.x15.I1 a_7580_11154# 0.27216f
C280 digital_0._113_.Q a_10253_930# 0.03129f
C281 a_14415_3650# VDPWR 0.27696f
C282 a_4405_962# a_5139_930# 0.07009f
C283 a_12977_2044# VDPWR 0.42042f
C284 a_12959_654# a_13306_412# 0.05116f
C285 digital_0._112_.RESET_B a_13481_386# 0.32475f
C286 LELO_GR01_0.x8.x1.x5.x8.G a_19706_6759# 0.08395f
C287 LELO_GR01_0.x8.x5.XA6.A LELO_GR01_0.x8.x5.XA4.MP1.S 0.01889f
C288 LELO_GR01_0.x8.x1.x7.D a_23816_7741# 0.04055f
C289 a_5182_n518# digital_0.hold18.X 0.04152f
C290 a_10546_246# VDPWR 0.29483f
C291 LELO_GR01_0.x8.VREF_BG uio_out<0> 0.03298f
C292 a_21252_18698# VDPWR 0.28596f
C293 digital_0.hold28.A digital_0.clkload0.A 0.20811f
C294 digital_0._069_.A digital_0._108_.D 0.19325f
C295 digital_0._116_.Q digital_0._118_.RESET_B 0.12979f
C296 digital_0._103_.D a_10017_3138# 0.28907f
C297 digital_0._103_.RESET_B a_10183_3138# 0.02906f
C298 a_3577_3138# digital_0.hold19.X 0.17059f
C299 a_9557_2838# digital_0._111_.RESET_B 0.15292f
C300 a_10074_2562# a_10571_2588# 0.04867f
C301 digital_0.clkload0.A digital_0.input2.X 0.04461f
C302 digital_0.output13.A digital_0.hold22.X 0.02676f
C303 a_11397_1750# digital_0._063_.B 0.09493f
C304 digital_0._116_.Q a_5974_n676# 0.0434f
C305 a_26930_7813# uo_out<0> 0.01006f
C306 digital_0.hold28.A digital_0.output11.A 0.55539f
C307 a_24838_11144# a_25054_11144# 0.01515f
C308 a_7439_654# a_7221_412# 0.20964f
C309 a_6871_412# a_7961_386# 0.04251f
C310 a_6705_412# a_7786_412# 0.10236f
C311 a_13771_n126# a_14026_234# 0.05936f
C312 a_6397_n158# a_6687_n676# 0.01412f
C313 a_8729_412# VDPWR 0.45095f
C314 LELO_GR01_0.x7.xd1<4>.A a_12688_14728# 0.03598f
C315 LELO_GR01_0.x7.x1.x5.x8.G a_6636_16210# 0.13066f
C316 uo_out<1> ui_in<7> 0.01524f
C317 uio_out<5> uio_out<6> 4.65114f
C318 digital_0.output13.A digital_0._101_.D 0.05223f
C319 a_4108_2840# a_4512_2954# 0.05116f
C320 a_4386_2856# a_4581_2825# 0.21963f
C321 LELO_GR01_0.x7.x11.P a_25942_16564# 0.01931f
C322 LELO_GR01_0.x8.IBP_BG a_22686_11144# 0.03845f
C323 digital_0.output6.A digital_0._115_.RESET_B 0.0225f
C324 a_14673_1334# a_14781_956# 0.05722f
C325 digital_0._108_.D clk 0.04255f
C326 digital_0._113_.D a_12391_412# 0.03764f
C327 a_9930_930# VDPWR 0.33244f
C328 digital_0._107_.RESET_B a_7088_n132# 0.16649f
C329 a_7001_110# a_7157_n158# 0.10748f
C330 LELO_GR01_0.x8.x7.D a_26926_4851# 0.05912f
C331 LELO_GR01_0.x8.PWRUP_N_1V8 a_21252_18698# 0.01772f
C332 LELO_GR01_0.x7.xd1<4>.A LELO_GR01_0.x8.IBP_BG 0.45185f
C333 a_15225_n702# a_15537_n426# 0.04406f
C334 a_11007_n524# VDPWR 0.16801f
C335 digital_0.load_slew17.A a_9557_2838# 0.06209f
C336 digital_0._116_.Q digital_0._111_.D 0.15825f
C337 digital_0._067_.A digital_0._110_.D 0.14772f
C338 a_4311_3106# a_3821_2562# 0.0119f
C339 a_12688_13928# VDPWR 0.03231f
C340 digital_0.clkbuf_1_0__f_clk.X a_4581_2825# 0.03349f
C341 a_4934_2422# digital_0.output6.A 0.0553f
C342 a_25054_11144# uio_out<7> 0.01883f
C343 a_25918_11144# uo_out<0> 0.01879f
C344 a_24838_11144# uio_out<6> 0.01539f
C345 digital_0.input1.X a_6315_1474# 0.05359f
C346 LELO_GR01_0.x8.x8.D a_26930_7013# 0.32808f
C347 JNWTR_ORX1_CV_0.A a_10628_4904# 0.02142f
C348 LELO_GR01_0.x7.x15.I1 a_7364_9234# 0.06462f
C349 a_15634_1474# a_15238_1334# 0.01257f
C350 digital_0.input3.X a_15413_1260# 0.03121f
C351 a_14319_3828# VDPWR 0.17734f
C352 a_4405_962# a_4571_962# 0.8999f
C353 a_12517_2044# VDPWR 0.38778f
C354 digital_0.output9.A uio_out<4> 0.10459f
C355 digital_0._112_.RESET_B a_12741_412# 0.15227f
C356 a_12391_412# a_13306_412# 0.11876f
C357 LELO_GR01_0.x8.x1.x5.x8.G a_19706_7559# 0.11889f
C358 a_5182_n518# a_5422_n702# 0.11296f
C359 a_5056_n702# digital_0.hold18.X 0.05247f
C360 a_10721_172# VDPWR 0.40273f
C361 LELO_GR01_0.x8.IBP_BG rst_n 0.01345f
C362 a_20412_18698# VDPWR 0.01383f
C363 digital_0.hold28.A digital_0._109_.Q 0.5474f
C364 digital_0._103_.RESET_B a_10017_3138# 0.30279f
C365 digital_0.load_slew15.X a_6455_3452# 0.05464f
C366 digital_0.clkbuf_1_0__f_clk.X digital_0.hold19.X 0.06948f
C367 LELO_GR01_0.x8.VREF_BG a_21834_16564# 0.06457f
C368 digital_0.load_slew15.X a_5486_1334# 0.01564f
C369 digital_0.hold28.A a_14298_1652# 0.32161f
C370 LELO_GR01_0.x8.x1.x7.D uio_out<5> 0.01237f
C371 digital_0.load_slew17.X digital_0.hold23.X 0.343f
C372 digital_0._116_.Q digital_0.hold18.X 0.10082f
C373 LELO_GR01_0.x8.x5.XA5.A uio_out<4> 0.02077f
C374 a_6705_412# a_7961_386# 0.04359f
C375 a_6871_412# a_7221_412# 0.21686f
C376 digital_0._105_.D a_14026_234# 0.15794f
C377 LELO_GR01_0.PWRUP_1V8 a_16440_16564# 0.05655f
C378 uio_out<7> uio_out<6> 4.43788f
C379 uo_out<1> ui_in<6> 0.01524f
C380 digital_0._116_.Q digital_0._112_.Q 0.16413f
C381 digital_0._069_.A a_11951_2146# 0.12215f
C382 a_4386_2856# a_4425_2730# 0.5826f
C383 LELO_GR01_0.x7.x7.G a_4578_11410# 0.10005f
C384 a_22482_14644# a_22914_14644# 0.14233f
C385 a_9465_2050# a_8996_1500# 0.02154f
C386 LELO_GR01_0.x7.x29.N a_16646_11144# 0.01236f
C387 a_7349_3132# VDPWR 0.43345f
C388 a_14891_930# a_14781_956# 0.09774f
C389 digital_0._118_.RESET_B clk 0.03859f
C390 digital_0._113_.D a_12225_412# 0.03512f
C391 a_3506_4904# a_3938_4904# 0.14233f
C392 a_9690_1194# VDPWR 0.24132f
C393 a_7001_110# a_6962_n16# 0.87924f
C394 digital_0._107_.RESET_B a_7157_n158# 0.17382f
C395 a_6684_0# a_7088_n132# 0.05116f
C396 digital_0._115_.Q ui_in<0> 0.08289f
C397 LELO_GR01_0.x8.x7.D a_26086_4851# 0.0629f
C398 LELO_GR01_0.x8.x5.CK a_26928_5671# 0.02203f
C399 LELO_GR01_0.x8.PWRUP_N_1V8 a_20412_18698# 0.01772f
C400 LELO_GR01_0.x7.xd1<4>.A a_17668_18750# 0.07801f
C401 digital_0.hold21.X a_10495_n702# 0.11721f
C402 a_10066_n524# VDPWR 0.11267f
C403 digital_0._116_.Q digital_0._111_.RESET_B 0.06315f
C404 digital_0._069_.A digital_0._111_.D 0.11545f
C405 a_12688_14728# VDPWR 0.04865f
C406 digital_0.clkbuf_1_0__f_clk.X a_4425_2730# 0.84952f
C407 LELO_GR01_0.x7.x7.G ui_in<0> 0.12474f
C408 LELO_GR01_0.x7.x10.P a_20970_16564# 0.02289f
C409 a_23982_11144# uio_out<6> 0.01889f
C410 digital_0._111_.RESET_B a_10089_2044# 0.0122f
C411 a_5109_2348# digital_0.output6.A 0.14268f
C412 a_7148_9234# a_7364_9234# 0.01515f
C413 digital_0.output7.A VDPWR 0.65628f
C414 digital_0._104_.RESET_B VDPWR 0.63061f
C415 a_12959_654# a_12741_412# 0.20964f
C416 a_12391_412# a_13481_386# 0.04251f
C417 a_12225_412# a_13306_412# 0.10236f
C418 LELO_GR01_0.x8.x5.XA6.A a_26930_8293# 0.01281f
C419 a_23816_8541# LELO_GR01_0.x8.x1.x7.D 0.01242f
C420 a_4585_n676# digital_0.hold18.X 0.13412f
C421 a_9981_246# VDPWR 0.20009f
C422 digital_0.load_slew15.X digital_0._108_.D 0.18257f
C423 LELO_GR01_0.x8.IBP_BG VDPWR 1.99601f
C424 a_13978_3650# a_13513_3138# 0.0146f
C425 digital_0.hold28.A digital_0.output13.A 0.27307f
C426 digital_0.clkbuf_1_0__f_clk.X a_3577_3138# 0.25131f
C427 LELO_GR01_0.x7.x22.D a_2478_12370# 0.01255f
C428 LELO_GR01_0.x8.IBP_BG a_21402_16564# 0.0178f
C429 digital_0.clkload0.A a_8996_1500# 0.03468f
C430 digital_0._110_.Q a_12517_2044# 0.14651f
C431 digital_0.output13.A digital_0.input2.X 0.21738f
C432 a_27238_16564# a_27670_16564# 0.21349f
C433 digital_0.load_slew17.X digital_0._104_.D 0.21508f
C434 digital_0.output6.A digital_0.hold28.X 0.01221f
C435 a_12754_2588# VDPWR 0.30116f
C436 a_6871_412# a_7439_654# 0.18122f
C437 a_6705_412# a_7221_412# 0.11535f
C438 digital_0.load_slew17.X digital_0.output10.A 0.56578f
C439 LELO_GR01_0.x8.x5.XA7.CN LELO_GR01_0.x8.x5.XA3.MN1.S 0.0238f
C440 a_8252_6824# a_8684_6824# 0.21349f
C441 a_13605_n126# a_14026_234# 0.08813f
C442 digital_0._116_.Q digital_0.load_slew17.A 1.44653f
C443 LELO_GR01_0.x7.xd1<4>.A LELO_GR01_0.x7.x7.G 1.12158f
C444 a_6636_17010# LELO_GR01_0.x7.x1.x5.x8.G 0.08382f
C445 clk ena 0.0466f
C446 uio_out<7> uio_out<5> 7.98646f
C447 uo_out<1> ui_in<5> 0.01524f
C448 a_23130_16564# uio_out<4> 0.01986f
C449 digital_0._069_.A digital_0._112_.Q 0.55488f
C450 a_4108_2840# a_4425_2730# 0.10236f
C451 digital_0.clkload0.A a_11673_412# 0.29151f
C452 a_16214_11144# a_16646_11144# 0.01515f
C453 a_6906_3132# VDPWR 0.34656f
C454 a_14323_962# a_14781_956# 0.03462f
C455 digital_0._101_.RESET_B clk 0.04204f
C456 a_9564_930# VDPWR 0.22283f
C457 digital_0._057_.D a_12116_188# 0.06224f
C458 digital_0._107_.RESET_B a_6962_n16# 0.05444f
C459 LELO_GR01_0.x8.x7.D a_24510_4435# 0.01356f
C460 LELO_GR01_0.x8.x5.CK a_26088_5671# 0.04129f
C461 LELO_GR01_0.x7.xd1<4>.A a_16018_17950# 0.07055f
C462 a_10472_18216# a_10472_17784# 0.14233f
C463 a_8552_18648# a_8552_17568# 0.0381f
C464 LELO_GR01_0.x8.PWRUP_N_1V8 LELO_GR01_0.x8.IBP_BG 1.36411f
C465 a_9417_n702# VDPWR 0.23393f
C466 digital_0.hold19.X a_3821_2562# 0.02437f
C467 digital_0._069_.A digital_0._111_.RESET_B 0.40185f
C468 a_11318_13928# VDPWR 0.02717f
C469 digital_0.clkbuf_1_0__f_clk.X a_4386_2856# 0.58826f
C470 LELO_GR01_0.x7.x7.G rst_n 0.08726f
C471 digital_0._116_.Q a_9557_2838# 0.11413f
C472 digital_0.load_slew15.A digital_0._108_.RESET_B 0.34851f
C473 LELO_GR01_0.x7.x23.D clk 0.08209f
C474 digital_0.output13.A a_4826_1322# 0.02486f
C475 a_24838_11144# uio_out<7> 0.02618f
C476 a_23982_11144# uio_out<5> 0.02254f
C477 digital_0._065_.A2_N digital_0._063_.A 0.01725f
C478 a_4369_2422# digital_0.output6.A 0.02996f
C479 LELO_GR01_0.x8.x8.D a_26930_7333# 0.31293f
C480 a_13978_3650# VDPWR 0.24846f
C481 digital_0.load_slew17.A uio_out<1> 0.01139f
C482 a_15394_1658# a_15413_1260# 0.01365f
C483 digital_0.load_slew17.X VDPWR 3.49689f
C484 a_12391_412# a_12741_412# 0.20984f
C485 a_12959_654# digital_0._112_.RESET_B 0.15941f
C486 a_12225_412# a_13481_386# 0.04359f
C487 a_5056_n702# a_5182_n518# 0.34134f
C488 a_4479_n676# digital_0.hold18.X 0.01017f
C489 digital_0._106_.RESET_B VDPWR 0.37845f
C490 digital_0.load_slew15.X digital_0._118_.RESET_B 0.46938f
C491 a_17668_18750# VDPWR 0.4254f
C492 digital_0.hold28.A digital_0._108_.Q 0.11226f
C493 LELO_GR01_0.x7.x22.D LELO_GR01_0.x7.x23.D 0.57781f
C494 a_11318_14986# a_11318_14728# 0.05264f
C495 a_2478_13680# a_2478_13170# 0.02417f
C496 digital_0.output13.A digital_0._118_.D 0.38036f
C497 a_17952_14644# LELO_GR01_0.x7.x29.N 0.01208f
C498 digital_0.load_slew17.X digital_0._113_.Q 0.30514f
C499 LELO_GR01_0.x8.x5.XA4.MN1.S uo_out<0> 0.01154f
C500 a_23982_11144# a_24838_11144# 0.04898f
C501 a_12929_2562# VDPWR 0.42998f
C502 a_6705_412# a_7439_654# 0.07009f
C503 digital_0.load_slew17.X a_14229_n132# 0.03329f
C504 digital_0._113_.Q digital_0._106_.RESET_B 0.01161f
C505 LELO_GR01_0.x8.x5.XA7.C LELO_GR01_0.x8.x5.XA3.MN1.S 0.01857f
C506 digital_0._116_.Q digital_0.load_slew15.A 1.4133f
C507 digital_0._069_.A digital_0.load_slew17.A 0.08367f
C508 LELO_GR01_0.x7.x18.D LELO_GR01_0.x7.x7.G 0.51952f
C509 uo_out<1> ui_in<4> 0.01524f
C510 digital_0._110_.Q a_12754_2588# 0.05048f
C511 digital_0._110_.D digital_0.input1.X 0.03238f
C512 a_4108_2840# a_4386_2856# 0.12532f
C513 a_3821_2562# a_4425_2730# 0.04359f
C514 LELO_GR01_0.x7.x7.G a_4578_11670# 0.0231f
C515 LELO_GR01_0.x8.IBP_BG a_22470_13064# 0.08629f
C516 digital_0.clkload0.A digital_0._057_.D 0.07254f
C517 a_4370_4904# uio_out<0> 0.0326f
C518 a_5018_6824# VDPWR 0.0249f
C519 digital_0._065_.A2_N digital_0._060_.A_N 0.28392f
C520 LELO_GR01_0.x7.x28.e a_17508_11144# 0.04363f
C521 a_6179_3132# VDPWR 0.50191f
C522 digital_0._115_.D a_7099_956# 0.12848f
C523 a_6684_0# a_6962_n16# 0.12532f
C524 digital_0._057_.D digital_0.output11.A 0.01745f
C525 digital_0._115_.Q VDPWR 0.65477f
C526 digital_0._107_.RESET_B a_7001_110# 0.66441f
C527 LELO_GR01_0.x8.x7.D a_24510_5235# 0.03877f
C528 JNWTR_ORX1_CV_0.XA2.A JNWTR_ORX1_CV_0.XA1.MP1.S 0.05059f
C529 LELO_GR01_0.x7.xd1<4>.A LELO_GR01_0.x8.VREF_BG 0.4353f
C530 a_28996_19470# a_28996_19150# 0.01003f
C531 a_9151_n702# VDPWR 0.20143f
C532 digital_0.hold28.A a_5834_2740# 0.31845f
C533 LELO_GR01_0.x7.x7.G VDPWR 3.11013f
C534 digital_0.clkbuf_1_0__f_clk.X a_4108_2840# 0.05828f
C535 digital_0._116_.Q digital_0._108_.RESET_B 0.06544f
C536 digital_0.load_slew15.A a_8837_2838# 0.11178f
C537 digital_0.output13.A digital_0._080_.A2 0.02f
C538 a_25702_13064# uo_out<0> 0.01984f
C539 a_4369_2422# a_4477_2044# 0.05722f
C540 a_4587_2018# digital_0.output6.A 0.01866f
C541 a_7148_9234# LELO_GR01_0.x7.x15.I1 0.09854f
C542 a_13738_3834# VDPWR 0.23391f
C543 digital_0.hold28.A a_14175_n702# 0.23303f
C544 digital_0.load_slew15.A uio_out<1> 0.01106f
C545 digital_0._115_.RESET_B a_7099_956# 0.0164f
C546 digital_0._063_.A VDPWR 0.86185f
C547 a_12391_412# digital_0._112_.RESET_B 0.02394f
C548 a_12225_412# a_12741_412# 0.10756f
C549 LELO_GR01_0.x8.x5.XA6.A LELO_GR01_0.x8.x5.XA5.A 0.21316f
C550 LELO_GR01_0.x8.x1.x5.IBN LELO_GR01_0.x8.x1.x7.D 0.773f
C551 a_10199_n158# VDPWR 0.20834f
C552 digital_0.load_slew15.X digital_0._101_.RESET_B 0.52783f
C553 a_16018_17950# VDPWR 0.40582f
C554 digital_0._109_.RESET_B digital_0._109_.Q 0.05103f
C555 LELO_GR01_0.x7.x22.D a_2478_13170# 0.05206f
C556 LELO_GR01_0.x7.x15.I1 uio_out<1> 0.01153f
C557 digital_0.load_slew15.X a_5139_930# 0.01295f
C558 digital_0._116_.Q a_3858_930# 0.01966f
C559 a_8228_9234# ui_in<0> 0.01693f
C560 digital_0._067_.B a_12517_2044# 0.1551f
C561 digital_0.clkload0.A digital_0.clkbuf_1_1__f_clk.A 0.08502f
C562 a_8837_2838# digital_0._108_.RESET_B 0.15265f
C563 a_27022_14644# a_27454_14644# 0.14233f
C564 digital_0._063_.A digital_0._113_.Q 0.67609f
C565 digital_0.load_slew15.X digital_0.hold18.X 0.01308f
C566 a_6705_412# a_6871_412# 0.88744f
C567 a_12189_2588# VDPWR 0.20843f
C568 a_8036_4904# a_8468_4904# 0.14233f
C569 a_7329_778# VDPWR 0.13239f
C570 digital_0._069_.A digital_0.load_slew15.A 0.14422f
C571 LELO_GR01_0.x8.PWRUP_N_1V8 LELO_GR01_0.x7.x7.G 0.02474f
C572 LELO_GR01_0.PWRUP_1V8 LELO_GR01_0.x7.x10.P 0.91069f
C573 uo_out<1> ui_in<3> 0.01524f
C574 digital_0._067_.A a_10571_2588# 0.05273f
C575 digital_0._110_.Q a_12929_2562# 0.15429f
C576 digital_0.hold28.A a_6503_2050# 0.02569f
C577 a_3821_2562# a_4386_2856# 0.04251f
C578 LELO_GR01_0.x7.x11.P a_25510_16564# 0.01931f
C579 LELO_GR01_0.x8.IBP_BG a_22254_11144# 0.03642f
C580 digital_0.hold28.A JNWTR_IVX1_CV_0.Y 0.03303f
C581 digital_0.clkload0.A a_10997_386# 0.07585f
C582 digital_0.input1.X a_11388_956# 0.04636f
C583 LELO_GR01_0.x7.x28.e a_16646_11144# 0.07609f
C584 a_6397_n158# a_6962_n16# 0.04251f
C585 digital_0._060_.A_N VDPWR 1.08595f
C586 a_6684_0# a_7001_110# 0.10236f
C587 JNWTR_ORX1_CV_0.XA2.A JNWTR_ORX1_CV_0.A 0.03177f
C588 LELO_GR01_0.x7.xd1<4>.A a_16018_18750# 0.08612f
C589 a_8689_n676# VDPWR 0.217f
C590 a_10533_3510# a_10641_3132# 0.05722f
C591 a_11318_14728# VDPWR 0.04219f
C592 digital_0.clkbuf_1_0__f_clk.X a_3821_2562# 0.08211f
C593 digital_0._069_.A digital_0._108_.RESET_B 0.1311f
C594 digital_0._116_.Q a_8837_2838# 0.09992f
C595 digital_0.hold25.X digital_0.input1.X 0.01397f
C596 a_17736_16564# a_18168_16564# 0.21349f
C597 LELO_GR01_0.x7.x10.P LELO_GR01_0.x7.x11.P 0.63589f
C598 a_23550_11144# uio_out<5> 0.02269f
C599 a_25486_11144# uo_out<0> 0.01266f
C600 a_4019_2050# digital_0.output6.A 0.5521f
C601 a_4587_2018# a_4477_2044# 0.09774f
C602 LELO_GR01_0.x8.x8.D LELO_GR01_0.x8.x5.XA3.MP1.S 0.07376f
C603 JNWTR_ORX1_CV_0.A a_10196_4904# 0.02142f
C604 a_13612_3650# VDPWR 0.22323f
C605 digital_0.input2.X a_9005_956# 0.01646f
C606 digital_0.hold28.A digital_0.hold27.X 0.06978f
C607 a_3618_1194# a_3858_930# 0.11296f
C608 digital_0.load_slew15.A clk 0.26639f
C609 digital_0._114_.Q a_12116_n132# 0.04965f
C610 a_12225_412# digital_0._112_.RESET_B 0.29503f
C611 a_12391_412# a_12959_654# 0.17513f
C612 LELO_GR01_0.x8.x5.XA6.A a_26930_8613# 0.09795f
C613 a_4585_n676# a_5056_n702# 0.01251f
C614 a_9631_n126# VDPWR 0.57626f
C615 a_24210_19024# ui_in<1> 0.05912f
C616 LELO_GR01_0.x8.VREF_BG VDPWR 2.39592f
C617 LELO_GR01_0.x8.VREF_BG a_21402_16564# 0.06457f
C618 digital_0._116_.Q a_3618_1194# 0.02312f
C619 digital_0.load_slew15.X a_4571_962# 0.03636f
C620 digital_0.hold28.A digital_0._113_.RESET_B 0.06194f
C621 a_11107_2562# a_11673_2588# 0.01758f
C622 a_4425_2730# a_5109_2348# 0.01127f
C623 digital_0.clkbuf_1_0__f_clk.X digital_0._115_.RESET_B 0.47971f
C624 digital_0._110_.Q digital_0._063_.A 0.05077f
C625 LELO_GR01_0.x8.x1.x7.D uio_out<4> 0.03662f
C626 digital_0.input1.X a_8895_412# 0.01523f
C627 digital_0._108_.RESET_B clk 0.14285f
C628 digital_0._110_.RESET_B VDPWR 0.26963f
C629 a_7126_412# VDPWR 0.07762f
C630 a_11758_188# a_12116_n132# 0.27101f
C631 digital_0._069_.A digital_0._116_.Q 0.40126f
C632 LELO_GR01_0.x7.xd1<4>.A a_14358_14870# 0.07585f
C633 uio_out<4> uio_out<5> 4.31608f
C634 uo_out<1> ui_in<2> 0.01109f
C635 digital_0.hold28.A a_6337_2050# 0.03836f
C636 a_3821_2562# a_4108_2840# 0.23366f
C637 digital_0.hold28.A a_14990_386# 0.01066f
C638 digital_0.clkload0.A a_9810_412# 0.06764f
C639 a_15998_11144# a_16646_11144# 0.06667f
C640 a_14673_1334# a_14769_1334# 0.01379f
C641 digital_0._115_.D a_7375_1276# 0.08512f
C642 a_7155_930# VDPWR 0.22113f
C643 a_6397_n158# a_7001_110# 0.04359f
C644 a_6684_0# digital_0._107_.RESET_B 0.2366f
C645 LELO_GR01_0.x8.x5.CK a_26090_6213# 0.04105f
C646 LELO_GR01_0.PWRUP_1V8 JNWTR_ORX1_CV_0.A 0.12649f
C647 LELO_GR01_0.x7.xd1<4>.A a_12688_18180# 0.04612f
C648 a_28996_19470# JNWTR_TIEL_CV_0.MP0.G 0.08348f
C649 a_28156_19470# a_28156_19150# 0.01003f
C650 LELO_GR01_0.x8.PWRUP_N_1V8 LELO_GR01_0.x8.VREF_BG 0.1353f
C651 a_8578_n676# VDPWR 0.22792f
C652 a_6687_n676# uo_out<0> 0.03345f
C653 digital_0._069_.A a_8837_2838# 0.01183f
C654 a_10751_3106# a_10641_3132# 0.09774f
C655 digital_0._116_.Q a_6209_386# 0.01249f
C656 a_4019_2050# a_4477_2044# 0.02761f
C657 digital_0._101_.D digital_0.output6.A 0.04718f
C658 a_12829_3676# VDPWR 0.22119f
C659 digital_0._116_.Q clk 0.19453f
C660 digital_0._115_.RESET_B a_7375_1276# 0.01688f
C661 a_12225_412# a_12959_654# 0.06225f
C662 LELO_GR01_0.x8.x5.XA6.A a_26090_8613# 0.07684f
C663 LELO_GR01_0.x8.x1.x5.IBN a_21554_7825# 0.03033f
C664 digital_0.output11.A a_12409_n676# 0.2312f
C665 digital_0._106_.D VDPWR 0.81819f
C666 a_16018_18750# VDPWR 0.43757f
C667 a_23370_19024# ui_in<1> 0.06589f
C668 digital_0.hold28.A a_4833_3436# 0.10128f
C669 digital_0._109_.D digital_0._109_.Q 0.02f
C670 digital_0._109_.RESET_B digital_0._108_.Q 0.08246f
C671 JNWTR_ORX1_CV_0.A LELO_GR01_0.x7.x11.P 0.15482f
C672 LELO_GR01_0.x8.IBP_BG a_20970_16564# 0.01309f
C673 digital_0.input1.X a_12094_2588# 0.02185f
C674 digital_0.load_slew15.X a_4405_962# 0.03052f
C675 LELO_GR01_0.x7.x3.P ui_in<0> 0.03519f
C676 LELO_GR01_0.x8.x1.x7.D uio_out<2> 0.01731f
C677 LELO_GR01_0.x8.x1.x5.IBN uio_out<1> 0.06217f
C678 LELO_GR01_0.x8.x5.XA5.A uo_out<0> 0.28203f
C679 a_23550_11144# a_23982_11144# 0.01515f
C680 a_6209_386# a_6705_412# 0.02525f
C681 a_12407_2830# VDPWR 0.21706f
C682 a_15413_1260# a_15427_386# 0.01412f
C683 LELO_GR01_0.x8.x5.XA7.CN a_26930_7813# 0.08626f
C684 a_11758_188# a_11673_n132# 0.15521f
C685 digital_0.load_slew15.X digital_0.load_slew15.A 0.2211f
C686 uo_out<1> ena 0.01524f
C687 clk uio_out<1> 0.2303f
C688 digital_0._110_.Q digital_0._110_.RESET_B 0.30578f
C689 digital_0.clkbuf_1_0__f_clk.X a_5109_2348# 0.0143f
C690 LELO_GR01_0.x7.x7.G a_11988_12620# 0.05469f
C691 LELO_GR01_0.x8.IBP_BG a_22038_11144# 0.03219f
C692 digital_0.hold28.A a_14750_570# 0.02259f
C693 digital_0.clkload0.A a_9985_386# 0.06264f
C694 LELO_GR01_0.x7.x28.e LELO_GR01_0.x7.x29.N 0.91898f
C695 a_14673_1334# a_14578_1322# 0.04983f
C696 a_10438_3498# VDPWR 0.08323f
C697 JNWTR_IVX1_CV_0.Y a_14861_172# 0.02095f
C698 a_3492_930# uio_out<1> 0.09445f
C699 a_6761_930# VDPWR 0.27217f
C700 a_6397_n158# digital_0._107_.RESET_B 0.27892f
C701 LELO_GR01_0.PWRUP_1V8 a_21252_18698# 0.06393f
C702 a_28156_19470# JNWTR_TIEL_CV_0.MP0.G 0.06129f
C703 a_14871_n524# digital_0.hold27.X 0.13553f
C704 a_8361_n676# VDPWR 0.33128f
C705 a_6451_n676# uo_out<0> 0.04495f
C706 a_14358_14870# VDPWR 0.41237f
C707 digital_0.load_slew15.X digital_0._108_.RESET_B 0.0316f
C708 a_10183_3138# a_10641_3132# 0.03462f
C709 a_17520_14644# a_17952_14644# 0.14233f
C710 LELO_GR01_0.x7.x10.P a_19680_14644# 0.05858f
C711 digital_0._116_.Q a_5951_386# 0.03522f
C712 a_3853_2050# digital_0.output6.A 0.03779f
C713 digital_0._111_.D a_9886_2410# 0.16138f
C714 digital_0.clkbuf_1_0__f_clk.X digital_0.hold28.X 0.28879f
C715 a_12718_3676# VDPWR 0.22878f
C716 a_3492_930# a_3618_1194# 0.34134f
C717 digital_0.load_slew17.A uio_out<3> 0.07861f
C718 digital_0._069_.A clk 0.15221f
C719 digital_0._115_.RESET_B digital_0._115_.D 0.0605f
C720 a_29150_11144# a_29582_11144# 0.01515f
C721 a_15773_2044# VDPWR 0.24441f
C722 a_12225_412# a_12391_412# 0.69088f
C723 a_4479_n676# a_4585_n676# 0.41909f
C724 digital_0.output11.A a_12138_n702# 0.05536f
C725 a_9465_n126# VDPWR 0.45014f
C726 a_12688_18180# VDPWR 0.42653f
C727 digital_0._109_.D digital_0.output13.A 0.09898f
C728 LELO_GR01_0.x7.x15.I2 LELO_GR01_0.x7.x10.P 0.03015f
C729 LELO_GR01_0.x7.x22.D a_2478_13680# 0.0773f
C730 digital_0._065_.A2_N a_11673_2588# 0.02135f
C731 digital_0._067_.B digital_0._063_.A 0.05164f
C732 a_7796_9234# ui_in<0> 0.02359f
C733 LELO_GR01_0.x7.x30.N clk 0.07536f
C734 digital_0._109_.Q a_4730_1652# 0.19077f
C735 a_17520_14644# LELO_GR01_0.x7.x29.N 0.01466f
C736 LELO_GR01_0.x8.x1.x7.D uio_out<3> 0.08916f
C737 digital_0.input1.X a_8729_412# 0.27488f
C738 LELO_GR01_0.x8.x5.XA6.A uio_out<6> 0.0428f
C739 a_11839_2588# VDPWR 0.58715f
C740 LELO_GR01_0.x8.x5.XA7.CN a_26090_7813# 0.02602f
C741 a_4696_n132# a_5056_n702# 0.01068f
C742 digital_0.load_slew15.X digital_0._116_.Q 0.44422f
C743 digital_0._069_.B digital_0._069_.A 0.17689f
C744 LELO_GR01_0.x7.x6<3>.G LELO_GR01_0.x7.x7.G 0.18658f
C745 digital_0._109_.D a_6853_2422# 0.01073f
C746 digital_0._110_.Q a_12407_2830# 0.01009f
C747 digital_0.hold28.A digital_0.output6.A 0.47557f
C748 digital_0._067_.B a_12189_2588# 0.0178f
C749 LELO_GR01_0.x7.x11.P LELO_GR01_0.x7.x11.N 0.16262f
C750 a_22266_16564# a_22698_16564# 0.21349f
C751 a_6853_2422# a_6315_1474# 0.01141f
C752 digital_0.output6.A digital_0.input2.X 0.13132f
C753 digital_0.load_slew15.X digital_0._107_.RESET_B 0.2566f
C754 digital_0.hold28.A a_14624_386# 0.01997f
C755 digital_0.clkload0.A a_9245_412# 0.04177f
C756 a_3938_4904# uio_out<0> 0.0326f
C757 a_4586_6824# VDPWR 0.03764f
C758 LELO_GR01_0.x7.x28.e a_16214_11144# 0.20525f
C759 a_14157_962# a_13513_956# 0.0129f
C760 a_3290_6824# a_3722_6824# 0.21349f
C761 a_6503_930# VDPWR 0.30119f
C762 a_6397_n158# a_6684_0# 0.23366f
C763 digital_0._116_.D a_6451_n676# 0.01657f
C764 LELO_GR01_0.x8.x7.D LELO_GR01_0.x8.x3.A 0.06152f
C765 LELO_GR01_0.PWRUP_1V8 a_20412_18698# 0.08922f
C766 a_28156_19470# JNWTR_TIEL_CV_0.Y 0.02509f
C767 a_13746_n524# digital_0.hold27.X 0.05505f
C768 a_7214_n524# VDPWR 0.08888f
C769 a_5974_n676# uo_out<0> 0.05898f
C770 digital_0.hold28.A digital_0._100_.D 0.05039f
C771 LELO_GR01_0.x7.x22.D clk 0.08265f
C772 digital_0.hold25.X a_6263_2562# 0.03829f
C773 digital_0._116_.Q a_5855_564# 0.02974f
C774 a_23334_13064# uio_out<5> 0.0128f
C775 a_25270_13064# uo_out<0> 0.01238f
C776 digital_0.clkload0.A a_14157_962# 0.2481f
C777 a_4369_2422# a_4465_2422# 0.01379f
C778 a_2478_9240# LELO_GR01_0.x7.x30.N 0.04279f
C779 digital_0.load_slew15.X uio_out<1> 0.0166f
C780 a_12501_3676# VDPWR 0.24663f
C781 a_15662_2044# VDPWR 0.24525f
C782 a_21554_8625# LELO_GR01_0.x8.x1.x5.IBN 0.01243f
C783 a_8361_n132# ui_in<0> 0.20084f
C784 digital_0.output11.A a_11898_n518# 0.04489f
C785 a_8689_n132# VDPWR 0.21541f
C786 digital_0._105_.RESET_B a_14175_n702# 0.01405f
C787 a_24210_19024# VDPWR 0.31133f
C788 digital_0._109_.D digital_0._108_.Q 0.28004f
C789 a_9734_15074# a_9738_14810# 0.05091f
C790 LELO_GR01_0.x7.x7.S a_4578_14070# 0.08918f
C791 LELO_GR01_0.x7.x15.I1 uio_out<3> 0.05552f
C792 digital_0.output13.A a_4730_1652# 0.01941f
C793 digital_0.clkload0.A a_13605_n126# 0.25797f
C794 a_5785_1750# digital_0._115_.RESET_B 0.1524f
C795 LELO_GR01_0.x8.x5.XA6.A uio_out<5> 0.02194f
C796 a_14358_10740# a_14358_10600# 0.11733f
C797 a_5951_386# a_6209_386# 0.22264f
C798 digital_0.load_slew17.X a_14026_234# 0.01781f
C799 a_11673_2588# VDPWR 0.4584f
C800 LELO_GR01_0.x8.x5.XA7.C a_26090_7813# 0.06535f
C801 LELO_GR01_0.x8.x5.XA7.CN LELO_GR01_0.x8.x5.XA4.MP1.S 0.02318f
C802 digital_0.load_slew15.X digital_0._069_.A 0.06805f
C803 uio_out<2> uio_out<1> 4.35378f
C804 ui_in<1> ui_in<2> 0.02717f
C805 digital_0._110_.Q a_11839_2588# 0.04463f
C806 digital_0._067_.B digital_0._110_.RESET_B 0.04137f
C807 digital_0.clkload0.A a_9463_654# 0.05511f
C808 digital_0.output6.A digital_0._118_.D 0.10602f
C809 a_15998_11144# a_16214_11144# 0.01515f
C810 a_14323_962# a_14578_1322# 0.06418f
C811 a_6407_1188# VDPWR 0.20852f
C812 digital_0._116_.D a_5974_n676# 0.20373f
C813 LELO_GR01_0.PWRUP_1V8 LELO_GR01_0.x8.IBP_BG 0.29925f
C814 LELO_GR01_0.x7.xd1<4>.A a_12688_18980# 0.05114f
C815 a_8552_18648# a_10472_18216# 0.01515f
C816 a_6793_n676# VDPWR 0.18262f
C817 digital_0.hold18.X uo_out<0> 0.2661f
C818 a_23550_11144# uio_out<4> 0.01479f
C819 digital_0.clkload0.A a_11388_956# 1.63614f
C820 a_4369_2422# a_4274_2410# 0.04983f
C821 a_5109_2348# a_4934_2422# 0.23366f
C822 digital_0.hold28.A digital_0._060_.B 0.22298f
C823 JNWTR_ORX1_CV_0.A a_9764_4904# 0.02142f
C824 digital_0.load_slew15.X clk 0.23503f
C825 digital_0._104_.RESET_B a_14781_956# 0.0122f
C826 digital_0.output8.A VDPWR 0.35483f
C827 a_15445_2044# VDPWR 0.34451f
C828 digital_0.clkload0.X a_12225_412# 0.01846f
C829 a_4243_n676# a_4479_n676# 0.22264f
C830 digital_0.output11.A a_11772_n702# 0.06953f
C831 a_8578_n132# VDPWR 0.22691f
C832 digital_0._105_.RESET_B digital_0.hold27.X 0.04646f
C833 digital_0._109_.D a_6235_3106# 0.01436f
C834 digital_0.load_slew17.A digital_0._102_.RESET_B 0.12537f
C835 LELO_GR01_0.x8.IBP_BG LELO_GR01_0.x7.x11.P 0.16839f
C836 LELO_GR01_0.x8.VREF_BG a_20970_16564# 0.06457f
C837 a_2478_14480# LELO_GR01_0.x7.x22.D 0.04278f
C838 LELO_GR01_0.x7.x15.I2 a_14358_14730# 0.03295f
C839 digital_0.clkbuf_1_0__f_clk.X a_5159_1474# 0.04734f
C840 digital_0.output13.A a_4369_1474# 0.29895f
C841 LELO_GR01_0.x8.x1.x5.IBN uio_out<2> 0.16593f
C842 digital_0.clkload0.A a_12903_206# 0.03663f
C843 digital_0.hold28.A a_7720_n132# 0.01372f
C844 LELO_GR01_0.x7.x30.N a_3290_6824# 0.22921f
C845 digital_0.load_slew17.X a_12116_n132# 0.14202f
C846 LELO_GR01_0.x8.x5.XA7.CN LELO_GR01_0.x8.x5.XA4.MN1.S 0.03049f
C847 a_7786_412# ui_in<0> 0.02017f
C848 a_4609_110# a_5182_n518# 0.01087f
C849 a_11758_188# a_12116_188# 0.01892f
C850 digital_0.load_slew15.X digital_0._069_.B 0.19832f
C851 uio_out<3> uio_out<1> 0.10111f
C852 uo_out<0> uio_out<6> 3.12883f
C853 digital_0._110_.Q a_11673_2588# 0.0417f
C854 digital_0.hold19.X a_3853_2050# 0.03043f
C855 digital_0._067_.B a_12407_2830# 0.01661f
C856 a_22050_14644# a_22482_14644# 0.14233f
C857 LELO_GR01_0.x7.x11.P a_24210_14644# 0.06053f
C858 digital_0.clkload0.A a_8895_412# 0.34733f
C859 a_6503_2050# a_6315_1474# 0.02009f
C860 digital_0.load_slew15.X a_6397_n158# 0.01065f
C861 a_3290_6824# clk 0.01273f
C862 a_14157_962# a_14578_1322# 0.09313f
C863 a_3074_4904# a_3506_4904# 0.14233f
C864 a_5486_1334# VDPWR 0.28202f
C865 a_14990_386# digital_0._105_.RESET_B 0.01301f
C866 a_6687_n676# VDPWR 0.283f
C867 a_5422_n702# uo_out<0> 0.19224f
C868 digital_0.input1.X digital_0.load_slew17.X 0.03512f
C869 digital_0.load_slew15.X a_5951_386# 0.02179f
C870 digital_0.clkload0.A digital_0._114_.Q 0.2557f
C871 digital_0.hold28.A a_7826_956# 0.01254f
C872 digital_0.input2.X a_7826_956# 0.01419f
C873 digital_0._116_.Q uo_out<1> 0.26078f
C874 a_12189_3650# VDPWR 0.26218f
C875 digital_0._114_.Q digital_0.output11.A 0.0114f
C876 digital_0.output9.A VDPWR 0.75992f
C877 a_8361_n132# VDPWR 0.3265f
C878 digital_0.output11.A a_11361_n702# 0.30019f
C879 digital_0.hold25.X digital_0._109_.Q 0.14024f
C880 a_12688_18980# VDPWR 0.39884f
C881 LELO_GR01_0.x7.x15.I2 a_12688_13928# 0.09916f
C882 LELO_GR01_0.x7.x15.I1 uio_out<0> 0.82378f
C883 a_7580_11154# ui_in<0> 0.0227f
C884 digital_0.clkbuf_1_0__f_clk.X digital_0.hold22.X 0.25958f
C885 digital_0.output13.A a_4111_1474# 0.06875f
C886 digital_0.hold19.X digital_0.input2.X 0.03513f
C887 a_26806_16564# a_27238_16564# 0.21349f
C888 digital_0._104_.RESET_B digital_0.input3.X 0.01169f
C889 LELO_GR01_0.x8.x5.XA5.A VDPWR 0.07548f
C890 digital_0._112_.Q a_14727_1474# 0.10179f
C891 LELO_GR01_0.x8.x1.x5.IBN uio_out<3> 0.01379f
C892 a_5855_564# a_5951_386# 0.41909f
C893 digital_0.load_slew17.X a_11673_n132# 0.1139f
C894 digital_0._063_.A a_12116_n132# 0.03053f
C895 LELO_GR01_0.x8.x5.XA7.CN a_26930_8293# 0.02605f
C896 a_7820_6824# a_8252_6824# 0.21349f
C897 a_7961_386# ui_in<0> 0.0489f
C898 LELO_GR01_0.x7.x20.D a_2478_16300# 0.07916f
C899 uo_out<1> uio_out<1> 0.03485f
C900 uo_out<0> uio_out<5> 0.0605f
C901 digital_0.clkbuf_1_0__f_clk.X digital_0._101_.D 0.02324f
C902 digital_0._067_.B a_11839_2588# 0.04654f
C903 LELO_GR01_0.x7.x7.G a_11988_13420# 0.01283f
C904 digital_0.clkload0.A digital_0._114_.D 0.02722f
C905 a_6337_2050# a_6315_1474# 0.0213f
C906 digital_0.load_slew15.X a_4696_n132# 0.04311f
C907 digital_0.input1.X digital_0._115_.Q 0.13125f
C908 a_3074_4904# clk 0.01301f
C909 a_15998_11144# LELO_GR01_0.x7.x28.e 0.30444f
C910 digital_0._108_.D VDPWR 0.48344f
C911 a_14157_962# digital_0._112_.D 0.01008f
C912 a_3618_1194# uo_out<1> 0.02462f
C913 a_5661_1260# VDPWR 0.42081f
C914 digital_0._116_.D a_5422_n702# 0.02506f
C915 LELO_GR01_0.x8.x5.CK a_26930_6533# 0.06181f
C916 LELO_GR01_0.x8.x8.D JNWTR_ORX1_CV_0.A 0.01602f
C917 a_6451_n676# VDPWR 0.33039f
C918 digital_0.hold28.A a_4425_2730# 0.031f
C919 digital_0._065_.A2_N a_11951_2146# 0.23344f
C920 digital_0.input1.X digital_0._063_.A 0.66668f
C921 digital_0._108_.RESET_B a_6961_2044# 0.0122f
C922 a_4019_2050# a_4274_2410# 0.05639f
C923 digital_0.hold28.A a_7099_956# 0.12518f
C924 a_4587_2018# a_4934_2422# 0.05116f
C925 digital_0.hold28.A a_10495_n702# 0.24806f
C926 digital_0.input2.X a_7099_956# 0.01707f
C927 a_11931_3650# VDPWR 0.27114f
C928 a_14762_2018# VDPWR 0.30819f
C929 LELO_GR01_0.x8.x1.x5.x9<2>.G a_21554_7825# 0.07795f
C930 digital_0.output12.A a_7643_n702# 0.05081f
C931 digital_0._107_.D VDPWR 0.90224f
C932 a_3858_n702# a_4243_n676# 0.0425f
C933 digital_0.output11.A a_11103_n702# 0.01211f
C934 digital_0.load_slew17.A a_13679_3138# 0.01236f
C935 digital_0.hold25.X digital_0.output13.A 0.05899f
C936 a_8552_17568# VDPWR 0.22552f
C937 LELO_GR01_0.x7.x15.I2 a_12688_14728# 0.07212f
C938 digital_0.clkload0.A a_12977_2044# 0.01228f
C939 a_7364_9234# ui_in<0> 0.01422f
C940 digital_0.load_slew17.A a_14727_1474# 0.09843f
C941 digital_0._065_.A2_N digital_0._111_.D 0.01862f
C942 digital_0.input1.X a_12189_2588# 0.01298f
C943 a_10285_2910# digital_0._111_.RESET_B 0.01417f
C944 digital_0.output13.A a_4015_1652# 0.03631f
C945 a_17088_14644# LELO_GR01_0.x7.x29.N 0.01466f
C946 digital_0.input1.X a_7329_778# 0.02646f
C947 LELO_GR01_0.x8.x1.x5.x9<2>.G uio_out<1> 0.26348f
C948 digital_0.load_slew17.X digital_0.input3.X 0.07283f
C949 digital_0._116_.Q a_15537_n132# 0.10988f
C950 digital_0._112_.Q digital_0.hold23.X 0.29752f
C951 digital_0._063_.A a_11673_n132# 0.01995f
C952 LELO_GR01_0.x8.x5.XA7.C a_26930_8293# 0.067f
C953 LELO_GR01_0.x8.x5.XA7.CN a_26090_8293# 0.08881f
C954 a_7786_412# VDPWR 0.27604f
C955 a_7221_412# ui_in<0> 0.0122f
C956 digital_0.output4.A digital_0._116_.Q 0.02618f
C957 a_5321_3676# digital_0.load_slew15.X 0.01599f
C958 LELO_GR01_0.x7.xd1<4>.A LELO_GR01_0.x7.x23.D 0.0959f
C959 uio_out<0> uio_out<1> 7.03238f
C960 uio_out<3> uio_out<4> 3.5573f
C961 uo_out<0> uio_out<7> 2.77232f
C962 uo_out<1> clk 1.85831f
C963 digital_0.clkbuf_1_0__f_clk.X a_3853_2050# 0.26359f
C964 digital_0._067_.B a_11673_2588# 0.03952f
C965 a_22266_16564# uio_out<2> 0.01699f
C966 LELO_GR01_0.x7.x23.D a_2478_11060# 0.01256f
C967 JNWTR_ORX1_CV_0.A LELO_GR01_0.x7.x29.P 0.22856f
C968 digital_0.clkload0.A a_8729_412# 0.32466f
C969 digital_0.load_slew15.X a_4765_n158# 0.0342f
C970 a_3506_4904# uio_out<0> 0.0326f
C971 a_4154_6824# VDPWR 0.12007f
C972 digital_0.hold28.A digital_0._112_.RESET_B 0.02994f
C973 digital_0._118_.RESET_B VDPWR 0.77402f
C974 a_11388_956# digital_0._112_.D 0.01208f
C975 digital_0._113_.D digital_0._057_.D 0.05052f
C976 a_3492_930# uo_out<1> 0.01512f
C977 a_4921_1334# VDPWR 0.19977f
C978 a_4765_n158# a_4696_n132# 0.20964f
C979 digital_0._116_.D a_5182_n518# 0.03341f
C980 LELO_GR01_0.x8.x7.D a_24508_5627# 0.03796f
C981 LELO_GR01_0.x8.x5.CK a_26090_6533# 0.07991f
C982 LELO_GR01_0.PWRUP_1V8 LELO_GR01_0.x8.VREF_BG 0.88591f
C983 a_5974_n676# VDPWR 0.25346f
C984 digital_0.hold28.A a_4386_2856# 0.03581f
C985 a_2478_12370# VDPWR 0.36615f
C986 digital_0._069_.A a_7513_2954# 0.02672f
C987 LELO_GR01_0.x7.x10.P a_19032_16564# 0.21365f
C988 digital_0._065_.A2_N digital_0._112_.Q 0.29321f
C989 a_23334_13064# uio_out<4> 0.01467f
C990 a_4019_2050# a_4934_2422# 0.11876f
C991 digital_0._101_.D a_4274_2410# 0.17124f
C992 digital_0.clkload0.A a_9930_930# 0.02558f
C993 a_2478_9750# a_2478_9240# 0.02417f
C994 digital_0.hold28.A digital_0.hold21.X 0.2375f
C995 digital_0._116_.Q uo_out<0> 0.12463f
C996 a_11835_3828# VDPWR 0.17909f
C997 digital_0.hold28.X a_5328_n132# 0.15761f
C998 a_11951_2146# VDPWR 0.29348f
C999 LELO_GR01_0.x8.x1.x5.x9<2>.G LELO_GR01_0.x8.x1.x5.IBN 0.96053f
C1000 digital_0.output12.A digital_0.hold26.X 0.30982f
C1001 a_7088_n132# VDPWR 0.20734f
C1002 digital_0.load_slew17.A digital_0._102_.D 0.01949f
C1003 digital_0.output8.A digital_0._067_.B 0.05923f
C1004 digital_0.hold25.X digital_0._108_.Q 0.29922f
C1005 digital_0._117_.RESET_B a_4658_3510# 0.24269f
C1006 digital_0.hold28.A digital_0.clkbuf_1_0__f_clk.X 0.29616f
C1007 LELO_GR01_0.x8.VREF_BG LELO_GR01_0.x7.x11.P 0.63118f
C1008 digital_0.clkbuf_1_0__f_clk.X digital_0.input2.X 0.3598f
C1009 a_7364_9234# rst_n 0.01422f
C1010 digital_0.input1.X digital_0._110_.RESET_B 0.01407f
C1011 digital_0._108_.D a_6758_2410# 0.15797f
C1012 digital_0._065_.A2_N digital_0._111_.RESET_B 0.13394f
C1013 a_10074_2562# digital_0._111_.D 0.13689f
C1014 a_26590_14644# a_27022_14644# 0.14233f
C1015 LELO_GR01_0.x7.x11.N a_28750_14644# 0.10442f
C1016 digital_0.input1.X a_7126_412# 0.01824f
C1017 digital_0._112_.Q digital_0._104_.D 0.09994f
C1018 LELO_GR01_0.x7.x30.N a_2858_4904# 0.01888f
C1019 a_23118_11144# a_23550_11144# 0.14233f
C1020 JNWTR_ORX1_CV_0.A digital_0.output13.A 0.03674f
C1021 digital_0._111_.D VDPWR 0.39819f
C1022 digital_0._114_.RESET_B a_9353_778# 0.02006f
C1023 LELO_GR01_0.x8.x5.XA7.CN LELO_GR01_0.x8.x5.XA5.A 0.38708f
C1024 a_7604_4904# a_8036_4904# 0.14233f
C1025 a_7961_386# VDPWR 0.38786f
C1026 a_7439_654# ui_in<0> 0.01316f
C1027 a_4609_110# a_4479_n676# 0.01346f
C1028 a_10721_172# digital_0.output11.A 0.10199f
C1029 a_2478_17100# LELO_GR01_0.x7.x20.D 0.04279f
C1030 LELO_GR01_0.x8.PWRUP_N_1V8 a_2478_12370# 0.07785f
C1031 uio_out<3> uio_out<2> 2.1337f
C1032 uo_out<0> uio_out<1> 0.02119f
C1033 uio_out<0> clk 0.16381f
C1034 a_21834_16564# uio_out<1> 0.01492f
C1035 a_22050_14644# uio_out<2> 0.02687f
C1036 a_22266_16564# uio_out<3> 0.01539f
C1037 digital_0.load_slew15.X a_4570_n16# 0.6009f
C1038 a_2858_4904# clk 0.01938f
C1039 digital_0.output6.A a_6315_1474# 0.02082f
C1040 digital_0._101_.RESET_B VDPWR 0.50608f
C1041 a_5139_930# VDPWR 0.20552f
C1042 a_4570_n16# a_4696_n132# 0.17589f
C1043 digital_0._116_.D a_5056_n702# 0.01954f
C1044 digital_0.hold18.X VDPWR 0.21734f
C1045 digital_0.output10.A uio_out<6> 0.04386f
C1046 LELO_GR01_0.x7.x23.D VDPWR 0.46956f
C1047 digital_0._069_.A a_7310_2588# 0.01733f
C1048 digital_0.hold25.X a_5834_2740# 0.11401f
C1049 a_10533_3510# a_10629_3510# 0.01379f
C1050 a_14769_3436# a_14594_3510# 0.23366f
C1051 a_17304_16564# a_17736_16564# 0.21349f
C1052 digital_0._116_.Q digital_0._116_.D 0.02774f
C1053 a_23118_11144# uio_out<4> 0.02646f
C1054 a_4019_2050# a_5109_2348# 0.04242f
C1055 a_3853_2050# a_4274_2410# 0.09016f
C1056 digital_0.clkload0.A a_9690_1194# 0.01896f
C1057 a_4587_2018# a_4369_2422# 0.20964f
C1058 JNWTR_ORX1_CV_0.A a_9332_4904# 0.02142f
C1059 LELO_GR01_0.x7.x25.D LELO_GR01_0.x7.x30.N 0.54315f
C1060 digital_0.output4.A clk 0.0423f
C1061 a_10986_3828# VDPWR 0.10339f
C1062 digital_0.load_slew17.A rst_n 0.0152f
C1063 a_28718_11144# a_29150_11144# 0.14233f
C1064 digital_0._112_.D a_11758_188# 0.01104f
C1065 digital_0._112_.Q VDPWR 3.16593f
C1066 LELO_GR01_0.x8.x1.x5.x9<2>.G a_21554_8625# 0.07164f
C1067 a_7001_110# ui_in<0> 0.02292f
C1068 a_7157_n158# VDPWR 0.20209f
C1069 a_3618_n518# a_3858_n702# 0.11296f
C1070 digital_0.output8.A digital_0._067_.A 0.12235f
C1071 a_12189_3650# digital_0._067_.B 0.02069f
C1072 digital_0._100_.RESET_B a_4658_3510# 0.02939f
C1073 digital_0._117_.RESET_B a_4833_3436# 0.34077f
C1074 digital_0.hold28.A digital_0.hold24.X 0.12063f
C1075 a_10472_17784# VDPWR 0.04403f
C1076 a_4580_14870# LELO_GR01_0.x7.x7.S 0.04272f
C1077 LELO_GR01_0.x7.x15.I2 LELO_GR01_0.x7.x7.G 0.02302f
C1078 LELO_GR01_0.x7.x1.x7.D a_11318_13928# 0.01243f
C1079 uio_oe<6> uio_oe<7> 0.04157f
C1080 LELO_GR01_0.x7.x15.I1 ui_in<0> 0.50995f
C1081 digital_0._110_.Q a_11951_2146# 0.06036f
C1082 LELO_GR01_0.x7.x25.D clk 0.07644f
C1083 a_10074_2562# digital_0._111_.RESET_B 0.01815f
C1084 a_3821_2562# a_3853_2050# 0.01127f
C1085 digital_0.clkbuf_1_0__f_clk.X digital_0._118_.D 0.39504f
C1086 LELO_GR01_0.x8.IBP_BG a_20372_9267# 0.01653f
C1087 a_23816_7741# VDPWR 0.51143f
C1088 digital_0._104_.RESET_B a_15268_1474# 0.01467f
C1089 digital_0._112_.Q digital_0._113_.Q 0.60249f
C1090 LELO_GR01_0.x7.x30.N a_2478_8440# 0.07269f
C1091 digital_0._111_.RESET_B VDPWR 0.26191f
C1092 LELO_GR01_0.x8.x5.XA7.CN a_26930_8613# 0.026f
C1093 LELO_GR01_0.x8.x5.XA7.C LELO_GR01_0.x8.x5.XA5.A 0.09018f
C1094 a_7221_412# VDPWR 0.1928f
C1095 a_6871_412# ui_in<0> 0.05784f
C1096 a_5215_3676# a_5321_3676# 0.41909f
C1097 LELO_GR01_0.x8.PWRUP_N_1V8 LELO_GR01_0.x7.x23.D 1.01794f
C1098 ui_in<1> uio_out<1> 0.06652f
C1099 VDPWR uio_out<6> 2.62568f
C1100 digital_0.clkload0.A a_12754_2588# 0.01422f
C1101 a_21618_14644# uio_out<1> 0.02209f
C1102 digital_0.input1.X a_6761_930# 0.03798f
C1103 digital_0.load_slew15.X a_4609_110# 0.64569f
C1104 a_4201_3132# VDPWR 0.1421f
C1105 a_4571_962# VDPWR 0.26229f
C1106 a_4609_110# a_4696_n132# 0.05348f
C1107 a_4570_n16# a_4765_n158# 0.21963f
C1108 a_24508_6687# a_24508_6427# 0.05215f
C1109 LELO_GR01_0.PWRUP_1V8 a_12688_18180# 0.07212f
C1110 JNWTR_ORX1_CV_0.XA2.A a_24210_19024# 0.07954f
C1111 digital_0.hold26.X a_7643_n702# 0.04056f
C1112 a_5422_n702# VDPWR 0.32557f
C1113 digital_0.output10.A uio_out<5> 0.02633f
C1114 a_2478_13170# VDPWR 0.36634f
C1115 digital_0._069_.A a_11107_2562# 0.18407f
C1116 digital_0.load_slew17.A a_10074_2562# 0.01558f
C1117 digital_0._100_.RESET_B a_4726_2954# 0.02f
C1118 digital_0._109_.Q a_7349_3132# 0.15831f
C1119 a_10533_3510# a_10438_3498# 0.04983f
C1120 LELO_GR01_0.x7.xd1<4>.A LELO_GR01_0.x7.x15.I1 0.36005f
C1121 a_3853_2050# a_4934_2422# 0.10236f
C1122 a_4019_2050# a_4369_2422# 0.20984f
C1123 digital_0.hold28.A digital_0._115_.D 0.23905f
C1124 digital_0.clkload0.A a_9564_930# 0.01027f
C1125 digital_0.clkbuf_1_0__f_clk.X digital_0._080_.A2 0.43503f
C1126 LELO_GR01_0.x7.x25.D a_2478_9240# 0.04975f
C1127 digital_0._116_.Q ui_in<0> 0.0649f
C1128 digital_0.load_slew17.A VDPWR 3.49192f
C1129 digital_0.hold22.X digital_0.hold28.X 0.01557f
C1130 digital_0.input2.X digital_0._115_.D 0.04459f
C1131 LELO_GR01_0.x8.x1.x5.x9<2>.G a_20156_7909# 0.04123f
C1132 digital_0._107_.RESET_B ui_in<0> 0.08022f
C1133 a_6962_n16# VDPWR 0.58333f
C1134 LELO_GR01_0.x8.PWRUP_N_1V8 uio_out<6> 0.02039f
C1135 digital_0.load_slew17.A a_12889_3171# 0.02246f
C1136 digital_0._100_.RESET_B a_4833_3436# 0.02119f
C1137 digital_0._117_.RESET_B a_4093_3510# 0.15327f
C1138 LELO_GR01_0.x7.x1.x7.D LELO_GR01_0.x7.x7.G 0.32129f
C1139 LELO_GR01_0.x7.x1.x5.IBN a_12688_13928# 0.04366f
C1140 LELO_GR01_0.x8.VREF_BG a_19680_14644# 0.01441f
C1141 LELO_GR01_0.x7.x15.I1 rst_n 2.32655f
C1142 digital_0._110_.Q digital_0._112_.Q 0.0282f
C1143 digital_0.input1.X a_11839_2588# 0.03384f
C1144 digital_0.clkload0.A digital_0.load_slew17.X 0.48212f
C1145 digital_0.hold28.A digital_0._115_.RESET_B 0.19886f
C1146 LELO_GR01_0.x8.x1.x5.x9<2>.G uio_out<2> 0.18841f
C1147 digital_0.input2.X digital_0._115_.RESET_B 0.03306f
C1148 digital_0.output4.A a_4243_n676# 0.29967f
C1149 LELO_GR01_0.x8.x1.x5.x8.G uio_out<1> 0.02644f
C1150 LELO_GR01_0.x8.x1.x7.D VDPWR 7.25163f
C1151 a_9557_2838# VDPWR 0.46834f
C1152 digital_0.load_slew17.X digital_0.output11.A 0.13483f
C1153 digital_0._063_.A a_12116_188# 0.03973f
C1154 LELO_GR01_0.x8.x5.XA7.CN a_26090_8613# 0.02661f
C1155 a_7439_654# VDPWR 0.20151f
C1156 a_6705_412# ui_in<0> 0.05158f
C1157 digital_0._119_.RESET_B a_4243_n676# 0.01234f
C1158 a_9981_246# a_10089_n132# 0.05722f
C1159 digital_0._106_.RESET_B digital_0.output11.A 0.05555f
C1160 digital_0.output4.A digital_0.load_slew15.X 0.06758f
C1161 LELO_GR01_0.x8.PWRUP_N_1V8 a_2478_13170# 0.08238f
C1162 ui_in<0> uio_out<1> 0.02504f
C1163 VDPWR uio_out<5> 1.37734f
C1164 uo_out<0> uio_out<4> 0.05934f
C1165 digital_0.hold28.A a_4934_2422# 0.02285f
C1166 a_11273_3436# a_11673_2588# 0.01052f
C1167 LELO_GR01_0.x7.x11.P a_23562_16564# 0.19088f
C1168 LELO_GR01_0.x8.IBP_BG LELO_GR01_0.x7.x29.P 0.1622f
C1169 LELO_GR01_0.x7.x7.S a_4578_10610# 0.04269f
C1170 digital_0.input1.X a_6503_930# 0.02391f
C1171 digital_0.load_slew15.X digital_0._119_.RESET_B 0.37097f
C1172 a_10253_930# a_10555_956# 0.06889f
C1173 a_4405_962# VDPWR 0.45399f
C1174 digital_0._113_.Q uio_out<5> 0.01692f
C1175 a_4609_110# a_4765_n158# 0.10599f
C1176 digital_0._119_.RESET_B a_4696_n132# 0.16487f
C1177 a_14750_570# a_13605_n126# 0.0107f
C1178 LELO_GR01_0.x8.x7.D a_24508_6427# 0.03513f
C1179 JNWTR_ORX1_CV_0.XA2.A a_23370_19024# 0.08887f
C1180 a_5182_n518# VDPWR 0.2188f
C1181 digital_0._116_.Q digital_0._065_.A2_N 0.41011f
C1182 digital_0._069_.A a_10285_2910# 0.07268f
C1183 digital_0._102_.RESET_B a_14594_3510# 0.23803f
C1184 digital_0._109_.Q a_6906_3132# 0.16825f
C1185 digital_0.output13.A a_7349_3132# 0.02555f
C1186 a_17088_14644# a_17520_14644# 0.14233f
C1187 digital_0._101_.D a_4369_2422# 0.03056f
C1188 a_3853_2050# a_5109_2348# 0.04359f
C1189 a_4019_2050# a_4587_2018# 0.17513f
C1190 a_4578_10610# a_4578_10200# 0.03078f
C1191 digital_0._116_.Q rst_n 0.01058f
C1192 digital_0.load_slew15.A VDPWR 1.3447f
C1193 digital_0._063_.A a_13513_956# 0.08935f
C1194 LELO_GR01_0.x7.x15.I1 a_11060_4904# 0.01942f
C1195 digital_0.load_slew17.X a_15537_n426# 0.09045f
C1196 a_7001_110# VDPWR 0.48002f
C1197 a_3492_n702# a_3618_n518# 0.34134f
C1198 digital_0.output8.A a_11273_3436# 0.10334f
C1199 digital_0.load_slew17.A digital_0._110_.Q 0.14159f
C1200 a_11931_3650# digital_0._067_.A 0.01288f
C1201 digital_0._117_.RESET_B a_4311_3106# 0.16612f
C1202 LELO_GR01_0.x8.PWRUP_N_1V8 uio_out<5> 0.04392f
C1203 LELO_GR01_0.x7.x1.x5.IBN a_12688_14728# 0.04351f
C1204 LELO_GR01_0.x7.x1.x7.D a_11318_14728# 0.03662f
C1205 uio_oe<5> uio_oe<6> 0.04157f
C1206 LELO_GR01_0.x7.x15.I1 VDPWR 0.18351f
C1207 digital_0.input1.X a_11673_2588# 0.58278f
C1208 digital_0.clkload0.A digital_0._063_.A 0.57774f
C1209 digital_0.hold28.A a_5785_1750# 0.0425f
C1210 LELO_GR01_0.x8.IBP_BG a_22292_9483# 0.05119f
C1211 a_16656_14644# LELO_GR01_0.x7.x29.N 0.01466f
C1212 LELO_GR01_0.x8.x1.x5.x9<2>.G uio_out<3> 0.01563f
C1213 digital_0.load_slew17.X a_14298_1652# 0.02193f
C1214 digital_0.hold28.A digital_0.output12.A 0.37337f
C1215 digital_0.output4.A a_3858_n702# 0.02365f
C1216 digital_0._116_.Q digital_0.output10.A 0.15667f
C1217 a_23816_8541# VDPWR 0.46055f
C1218 digital_0._060_.B a_9985_386# 0.02474f
C1219 digital_0._108_.RESET_B VDPWR 0.29391f
C1220 a_6871_412# VDPWR 0.26037f
C1221 a_6209_386# ui_in<0> 0.02115f
C1222 digital_0._106_.RESET_B a_10089_n132# 0.0122f
C1223 a_4979_3676# a_5215_3676# 0.22264f
C1224 uio_out<0> uio_out<3> 0.07605f
C1225 VDPWR uio_out<7> 0.98361f
C1226 rst_n uio_out<1> 1.64785f
C1227 uo_out<0> uio_out<2> 0.02119f
C1228 ui_in<1> uio_out<4> 0.03263f
C1229 ui_in<0> clk 0.16862f
C1230 digital_0.hold28.A a_5109_2348# 0.02428f
C1231 a_21834_16564# uio_out<2> 0.01733f
C1232 a_21834_16564# a_22266_16564# 0.21349f
C1233 LELO_GR01_0.x8.x5.XA7.CN uio_out<6> 0.03124f
C1234 digital_0.load_slew15.X a_4292_0# 0.0571f
C1235 a_3074_4904# uio_out<0> 0.03266f
C1236 a_3722_6824# VDPWR 0.10318f
C1237 digital_0.input1.X a_6793_n676# 0.01254f
C1238 a_2858_4904# a_3074_4904# 0.01515f
C1239 a_3858_930# VDPWR 0.32382f
C1240 a_4292_0# a_4696_n132# 0.05116f
C1241 digital_0._119_.RESET_B a_4765_n158# 0.15235f
C1242 a_4609_110# a_4570_n16# 0.57903f
C1243 a_24210_19344# a_24210_19024# 0.01f
C1244 a_5056_n702# VDPWR 0.20741f
C1245 digital_0._069_.A digital_0._065_.A2_N 1.54719f
C1246 a_14247_3106# a_14594_3510# 0.05116f
C1247 digital_0._102_.RESET_B a_14769_3436# 0.28095f
C1248 digital_0._109_.Q a_6179_3132# 0.12604f
C1249 digital_0._108_.Q a_7349_3132# 0.19481f
C1250 digital_0.output13.A a_6906_3132# 0.03096f
C1251 a_10183_3138# a_10438_3498# 0.06418f
C1252 LELO_GR01_0.x7.x10.P a_18600_16564# 0.21325f
C1253 digital_0.clkload0.A digital_0._060_.A_N 0.44309f
C1254 a_22902_13064# uio_out<4> 0.01292f
C1255 digital_0._101_.D a_4587_2018# 0.03284f
C1256 a_3853_2050# a_4369_2422# 0.11238f
C1257 digital_0.load_slew15.X digital_0._116_.D 0.12639f
C1258 LELO_GR01_0.x8.x8.D a_26930_7813# 0.31342f
C1259 LELO_GR01_0.x8.x1.x5.x6.N a_19706_7559# 0.03679f
C1260 digital_0._116_.Q VDPWR 5.51691f
C1261 digital_0.load_slew17.X a_14578_1322# 0.0127f
C1262 a_12391_1500# a_11388_956# 0.01142f
C1263 digital_0.input2.X digital_0.hold28.X 0.04255f
C1264 digital_0.output5.A uio_out<1> 0.0148f
C1265 a_10089_2044# VDPWR 0.1435f
C1266 digital_0._107_.RESET_B VDPWR 0.44087f
C1267 a_6397_n158# ui_in<0> 0.01036f
C1268 LELO_GR01_0.x7.xd1<4>.A clk 0.22346f
C1269 digital_0._111_.Q a_11415_3650# 0.10192f
C1270 digital_0._117_.RESET_B a_3743_3138# 0.02691f
C1271 a_8552_18000# VDPWR 0.19563f
C1272 a_8552_18648# ui_in<1> 0.01164f
C1273 LELO_GR01_0.x7.x1.x5.IBN a_11318_13928# 0.04924f
C1274 LELO_GR01_0.x7.x15.I2 a_14358_14870# 0.03279f
C1275 digital_0.output13.A digital_0.load_slew17.X 0.23645f
C1276 digital_0.hold22.X a_5159_1474# 0.03965f
C1277 LELO_GR01_0.x8.x5.XA6.MP1.S uo_out<0> 0.04839f
C1278 a_8837_2838# VDPWR 0.45973f
C1279 a_6705_412# VDPWR 0.40896f
C1280 a_5951_386# ui_in<0> 0.02448f
C1281 a_10199_n158# a_10089_n132# 0.09774f
C1282 LELO_GR01_0.x7.xd1<4>.A LELO_GR01_0.x7.x22.D 0.09541f
C1283 VDPWR uio_out<1> 1.62695f
C1284 uio_out<0> uo_out<1> 0.0194f
C1285 uo_out<0> uio_out<3> 0.03126f
C1286 ui_in<1> uio_out<2> 0.06692f
C1287 rst_n clk 0.17063f
C1288 digital_0.clkload0.A digital_0._110_.RESET_B 0.06392f
C1289 a_21402_16564# uio_out<1> 0.02214f
C1290 a_21618_14644# uio_out<2> 0.01532f
C1291 LELO_GR01_0.x7.x23.D LELO_GR01_0.x7.x24.D 0.57215f
C1292 a_2478_12370# a_2478_11860# 0.02417f
C1293 LELO_GR01_0.x8.x5.XA7.C uio_out<6> 0.11916f
C1294 LELO_GR01_0.x8.x5.XA7.CN uio_out<5> 0.01979f
C1295 digital_0.load_slew15.X a_4005_n158# 0.08554f
C1296 LELO_GR01_0.x8.x5.XA7.MP1.S uio_out<7> 0.01109f
C1297 digital_0.output6.A a_4015_1652# 0.01227f
C1298 a_14358_11680# a_14358_11540# 0.11733f
C1299 digital_0.input1.X a_6687_n676# 0.03886f
C1300 a_3618_1194# VDPWR 0.23773f
C1301 digital_0._119_.RESET_B a_4570_n16# 0.02491f
C1302 a_13481_386# digital_0._105_.D 0.0117f
C1303 LELO_GR01_0.PWRUP_1V8 a_12688_18980# 0.0709f
C1304 LELO_GR01_0.x8.x8.D LELO_GR01_0.x8.VREF_BG 0.24928f
C1305 a_4585_n676# VDPWR 0.18878f
C1306 digital_0._102_.RESET_B a_14029_3510# 0.16585f
C1307 digital_0.hold28.A a_14137_3132# 0.02687f
C1308 digital_0.load_slew15.A a_8145_2562# 0.01629f
C1309 digital_0._069_.A a_10074_2562# 0.1628f
C1310 a_2478_13680# VDPWR 0.36615f
C1311 a_13679_3138# a_14594_3510# 0.11876f
C1312 a_10017_3138# a_10438_3498# 0.08968f
C1313 digital_0.hold25.X digital_0._100_.D 0.05078f
C1314 digital_0._100_.RESET_B a_4512_2954# 0.17454f
C1315 a_6235_3106# a_7349_3132# 0.01166f
C1316 digital_0._108_.Q a_6906_3132# 0.025f
C1317 digital_0.output13.A a_6179_3132# 0.03156f
C1318 a_3853_2050# a_4587_2018# 0.06225f
C1319 digital_0._101_.D a_4019_2050# 0.56437f
C1320 JNWTR_ORX1_CV_0.A a_8900_4904# 0.02142f
C1321 LELO_GR01_0.x7.x25.D a_2478_9750# 0.07869f
C1322 digital_0.load_slew15.X ui_in<0> 0.12154f
C1323 digital_0._069_.A VDPWR 3.76096f
C1324 digital_0.output5.A clk 0.04539f
C1325 digital_0._113_.D a_11388_956# 0.03541f
C1326 digital_0.hold28.A a_7643_n702# 0.23801f
C1327 digital_0.output4.A uo_out<1> 0.0734f
C1328 digital_0._116_.D a_4765_n158# 0.01864f
C1329 LELO_GR01_0.x8.x1.x5.x8.G a_20156_7909# 0.0824f
C1330 a_6684_0# VDPWR 0.29839f
C1331 LELO_GR01_0.x7.x18.D clk 0.05353f
C1332 LELO_GR01_0.x8.PWRUP_N_1V8 uio_out<1> 0.13887f
C1333 digital_0.hold20.X a_11415_3650# 0.22687f
C1334 digital_0._100_.RESET_B a_3743_3138# 0.02208f
C1335 a_10472_18216# VDPWR 0.0182f
C1336 LELO_GR01_0.x7.x1.x5.IBN LELO_GR01_0.x7.x7.G 0.71167f
C1337 uio_oe<4> uio_oe<5> 0.04126f
C1338 digital_0._069_.A digital_0._113_.Q 0.44561f
C1339 LELO_GR01_0.x7.x30.N VDPWR 0.24305f
C1340 digital_0.clkbuf_1_0__f_clk.X a_6315_1474# 1.62377f
C1341 LELO_GR01_0.x8.x1.x5.x9<2>.G uio_out<0> 0.26511f
C1342 LELO_GR01_0.x8.x5.XA6.A uo_out<0> 0.23322f
C1343 digital_0.clkload0.A digital_0._106_.D 0.02166f
C1344 LELO_GR01_0.x8.x1.x5.x8.G uio_out<2> 0.03449f
C1345 LELO_GR01_0.x8.x1.x5.IBN VDPWR 0.20497f
C1346 digital_0._116_.D a_5218_778# 0.15108f
C1347 digital_0._113_.D a_12903_206# 0.01671f
C1348 digital_0._114_.RESET_B a_9810_412# 0.21442f
C1349 a_6209_386# VDPWR 0.34653f
C1350 a_9631_n126# a_10089_n132# 0.03462f
C1351 a_5855_564# ui_in<0> 0.01682f
C1352 LELO_GR01_0.x8.PWRUP_N_1V8 a_2478_13680# 0.07785f
C1353 uo_out<0> uo_out<1> 0.16793f
C1354 ui_in<1> uio_out<3> 0.06778f
C1355 rst_n uio_out<4> 0.29494f
C1356 VDPWR clk 3.73804f
C1357 a_21186_14644# uio_out<1> 0.01857f
C1358 digital_0._108_.D digital_0.input1.X 0.13216f
C1359 a_21618_14644# a_22050_14644# 0.14233f
C1360 LELO_GR01_0.x8.VREF_BG LELO_GR01_0.x7.x29.P 0.14162f
C1361 LELO_GR01_0.x7.x23.D a_2478_11860# 0.04931f
C1362 LELO_GR01_0.x7.x7.S a_4578_11410# 0.06641f
C1363 a_2858_4904# uio_out<0> 0.0116f
C1364 a_11431_2382# digital_0._112_.Q 0.02786f
C1365 LELO_GR01_0.x8.x5.XA7.C uio_out<5> 0.02407f
C1366 a_10253_930# a_10723_1276# 0.01408f
C1367 digital_0.input1.X a_6451_n676# 0.05261f
C1368 digital_0._080_.A2 digital_0.hold28.X 0.10369f
C1369 a_3492_930# VDPWR 0.22844f
C1370 a_4292_0# a_4570_n16# 0.12532f
C1371 digital_0._119_.RESET_B a_4609_110# 0.29549f
C1372 a_23370_19344# a_23370_19024# 0.01f
C1373 LELO_GR01_0.x7.xd1<4>.A a_8552_18648# 0.03101f
C1374 a_4479_n676# VDPWR 0.29259f
C1375 a_14247_3106# a_14029_3510# 0.20964f
C1376 digital_0._069_.A a_7970_2588# 0.08736f
C1377 LELO_GR01_0.x7.x22.D VDPWR 0.47437f
C1378 a_13679_3138# a_14769_3436# 0.04251f
C1379 digital_0._100_.RESET_B a_4581_2825# 0.16654f
C1380 a_6235_3106# a_6906_3132# 0.142f
C1381 digital_0._108_.Q a_6179_3132# 0.03666f
C1382 LELO_GR01_0.x7.xd1<4>.A a_4578_9400# 0.07043f
C1383 LELO_GR01_0.x8.PWRUP_N_1V8 LELO_GR01_0.x7.x30.N 0.53533f
C1384 a_22902_13064# uio_out<3> 0.01021f
C1385 a_3853_2050# a_4019_2050# 0.72353f
C1386 LELO_GR01_0.x8.PWRUP_N_1V8 LELO_GR01_0.x8.x1.x5.IBN 0.16671f
C1387 LELO_GR01_0.x8.x8.D LELO_GR01_0.x8.x5.XA4.MP1.S 0.09448f
C1388 digital_0._069_.B VDPWR 0.12249f
C1389 digital_0._063_.A digital_0._112_.D 0.06733f
C1390 digital_0._113_.D digital_0._114_.Q 0.1414f
C1391 a_12225_1500# a_11388_956# 0.0151f
C1392 digital_0.hold28.A digital_0.hold26.X 0.04233f
C1393 digital_0._116_.D a_4570_n16# 0.04133f
C1394 a_11673_412# digital_0.clkload0.X 0.3277f
C1395 digital_0.load_slew17.X a_14175_n702# 0.0388f
C1396 a_20156_8709# LELO_GR01_0.x8.x1.x5.x9<2>.G 0.01325f
C1397 a_6397_n158# VDPWR 0.43116f
C1398 LELO_GR01_0.x8.PWRUP_N_1V8 clk 0.67584f
C1399 digital_0._069_.A digital_0._110_.Q 0.84039f
C1400 digital_0._117_.RESET_B a_3577_3138# 0.29634f
C1401 digital_0.output5.A a_3998_3498# 0.01496f
C1402 digital_0.hold28.A a_11415_3650# 0.23122f
C1403 digital_0.hold20.X digital_0._111_.Q 0.33141f
C1404 LELO_GR01_0.x7.x1.x5.IBN a_11318_14728# 0.04626f
C1405 a_14358_15810# a_14358_15670# 0.11733f
C1406 a_2478_9240# VDPWR 0.36721f
C1407 digital_0.clkbuf_1_0__f_clk.X a_4730_1652# 0.05431f
C1408 digital_0.hold28.A a_5159_1474# 0.23278f
C1409 a_26374_16564# a_26806_16564# 0.21349f
C1410 digital_0.input1.X a_7786_412# 0.05798f
C1411 digital_0.output9.A digital_0.input3.X 0.28586f
C1412 a_15445_2044# a_15634_1474# 0.01067f
C1413 digital_0._104_.RESET_B digital_0._113_.RESET_B 0.02895f
C1414 digital_0.clkload0.A a_9465_n126# 0.26106f
C1415 a_21554_8625# VDPWR 0.01321f
C1416 a_22902_13064# a_23334_13064# 0.21349f
C1417 digital_0._113_.D a_11758_188# 0.20193f
C1418 digital_0._114_.RESET_B a_9985_386# 0.26934f
C1419 a_7970_2588# clk 0.01477f
C1420 a_7388_4904# a_7604_4904# 0.01515f
C1421 a_5951_386# VDPWR 0.31503f
C1422 a_4594_3650# a_4979_3676# 0.0425f
C1423 LELO_GR01_0.x8.PWRUP_N_1V8 LELO_GR01_0.x7.x22.D 1.03144f
C1424 uo_out<0> uio_out<0> 0.02551f
C1425 ui_in<1> uo_out<1> 3.41298f
C1426 rst_n uio_out<2> 0.17232f
C1427 VDPWR uio_out<4> 1.08473f
C1428 digital_0._069_.A a_6758_2410# 0.02907f
C1429 LELO_GR01_0.x7.x11.P a_23130_16564# 0.19038f
C1430 digital_0.output4.A digital_0._119_.RESET_B 0.14082f
C1431 LELO_GR01_0.x8.x5.XA7.C uio_out<7> 0.08288f
C1432 a_3998_3498# VDPWR 0.08228f
C1433 digital_0._114_.Q digital_0._060_.B 0.34891f
C1434 digital_0._104_.RESET_B a_14990_386# 0.01226f
C1435 digital_0.input1.X a_5974_n676# 0.0517f
C1436 digital_0._080_.A2 a_5029_956# 0.02662f
C1437 a_4292_0# a_4609_110# 0.10236f
C1438 a_4005_n158# a_4570_n16# 0.04251f
C1439 a_23138_6685# a_23138_6427# 0.05264f
C1440 LELO_GR01_0.x7.xd1<4>.A a_4578_17200# 0.02715f
C1441 a_4243_n676# VDPWR 0.28366f
C1442 a_14247_3106# digital_0._102_.RESET_B 0.17703f
C1443 a_13679_3138# a_14029_3510# 0.21686f
C1444 a_2478_14480# VDPWR 0.36633f
C1445 digital_0._069_.A a_8145_2562# 0.07637f
C1446 a_13513_3138# a_14594_3510# 0.10236f
C1447 digital_0._100_.RESET_B a_4425_2730# 0.32537f
C1448 a_6235_3106# a_6179_3132# 0.27101f
C1449 LELO_GR01_0.x7.xd1<4>.A a_4578_10200# 0.07078f
C1450 LELO_GR01_0.x7.x18.D a_4578_9400# 0.05066f
C1451 LELO_GR01_0.x8.PWRUP_N_1V8 a_2478_9240# 0.08228f
C1452 digital_0._116_.Q digital_0._116_.SET_B 0.04016f
C1453 digital_0.input1.X a_11951_2146# 0.05464f
C1454 digital_0._111_.RESET_B a_10546_2422# 0.23459f
C1455 digital_0.load_slew15.X a_4438_386# 0.04021f
C1456 a_3853_2050# digital_0._101_.D 0.45211f
C1457 digital_0.load_slew15.X VDPWR 2.81313f
C1458 a_28502_13064# a_28934_13064# 0.21349f
C1459 digital_0._116_.D a_4609_110# 0.04048f
C1460 digital_0.load_slew17.X digital_0.hold27.X 0.21125f
C1461 a_4696_n132# VDPWR 0.20676f
C1462 LELO_GR01_0.x7.x19.D clk 0.08461f
C1463 digital_0._100_.RESET_B a_3577_3138# 0.01208f
C1464 digital_0.hold28.A digital_0._111_.Q 0.09371f
C1465 a_8552_18648# VDPWR 0.05463f
C1466 LELO_GR01_0.x8.PWRUP_N_1V8 uio_out<4> 0.03297f
C1467 LELO_GR01_0.x8.VREF_BG a_19032_16564# 0.54196f
C1468 LELO_GR01_0.x7.x1.x5.IBN a_9738_14010# 0.01549f
C1469 uio_oe<3> uio_oe<4> 0.04126f
C1470 digital_0.input1.X digital_0._111_.D 0.02973f
C1471 digital_0.clkbuf_1_0__f_clk.X a_4369_1474# 0.06171f
C1472 digital_0.hold19.X a_4015_1652# 0.13065f
C1473 digital_0.hold28.A digital_0.hold22.X 0.03679f
C1474 LELO_GR01_0.x8.IBP_BG a_22292_9915# 0.03977f
C1475 a_6315_1474# digital_0._115_.RESET_B 0.1198f
C1476 digital_0.input1.X a_7961_386# 0.05806f
C1477 digital_0.output9.A a_15634_1474# 0.01758f
C1478 digital_0.load_slew17.X digital_0._113_.RESET_B 0.02542f
C1479 digital_0.input2.X digital_0.hold22.X 0.05323f
C1480 digital_0.clkload0.A a_8689_n132# 0.04768f
C1481 LELO_GR01_0.x7.x25.D a_2478_8440# 0.01257f
C1482 a_4610_386# a_5218_778# 0.03558f
C1483 digital_0._060_.B digital_0._114_.D 0.03251f
C1484 digital_0._114_.RESET_B a_9245_412# 0.16228f
C1485 a_8145_2562# clk 0.02838f
C1486 a_5855_564# VDPWR 0.19415f
C1487 a_9981_246# a_10077_246# 0.01379f
C1488 a_4594_3650# digital_0.output4.A 0.22908f
C1489 LELO_GR01_0.x7.x18.D LELO_GR01_0.x7.x7.S 0.42102f
C1490 LELO_GR01_0.x8.PWRUP_N_1V8 a_2478_14480# 0.08228f
C1491 LELO_GR01_0.x7.x6<3>.G a_4578_14070# 0.17405f
C1492 VDPWR uio_out<2> 1.05377f
C1493 ui_in<0> uo_out<1> 1.72549f
C1494 ui_in<1> uio_out<0> 0.06863f
C1495 rst_n uio_out<3> 0.44214f
C1496 digital_0.hold28.A digital_0._101_.D 0.04388f
C1497 LELO_GR01_0.x7.x7.S a_4578_11670# 0.06807f
C1498 digital_0.output4.A a_4292_0# 0.01981f
C1499 a_3290_6824# VDPWR 0.01927f
C1500 a_14594_3510# VDPWR 0.28596f
C1501 a_10253_930# digital_0._060_.B 0.14334f
C1502 digital_0.input1.X digital_0.hold18.X 0.79772f
C1503 a_4005_n158# a_4609_110# 0.04359f
C1504 a_4292_0# digital_0._119_.RESET_B 0.23197f
C1505 a_4578_18140# a_4578_18000# 0.11733f
C1506 LELO_GR01_0.x7.x18.D a_4578_17200# 0.0785f
C1507 a_3858_n702# VDPWR 0.26991f
C1508 a_13679_3138# digital_0._102_.RESET_B 0.06095f
C1509 LELO_GR01_0.x7.x7.S VDPWR 0.2479f
C1510 digital_0._069_.A a_7405_2588# 0.03092f
C1511 digital_0.load_slew15.X a_7970_2588# 0.01651f
C1512 a_13513_3138# a_14769_3436# 0.04359f
C1513 LELO_GR01_0.x8.x5.CK a_26146_2651# 0.07043f
C1514 digital_0._100_.RESET_B a_4386_2856# 0.05687f
C1515 LELO_GR01_0.x7.x18.D a_4578_10200# 0.02079f
C1516 LELO_GR01_0.x7.x10.P a_18168_16564# 0.21304f
C1517 digital_0.input1.X digital_0._112_.Q 0.27047f
C1518 digital_0._111_.RESET_B a_10721_2348# 0.27934f
C1519 digital_0.load_slew15.X a_4530_626# 0.01606f
C1520 digital_0.output4.A digital_0._116_.D 0.02714f
C1521 LELO_GR01_0.PWRUP_1V8 a_23816_7741# 0.07044f
C1522 LELO_GR01_0.x8.x8.D a_26930_8293# 0.31059f
C1523 a_2478_10550# LELO_GR01_0.x7.x25.D 0.04279f
C1524 a_5321_3676# VDPWR 0.18692f
C1525 a_4228_3650# uo_out<1> 0.09047f
C1526 LELO_GR01_0.x7.x15.I1 a_10412_6824# 0.01628f
C1527 LELO_GR01_0.x8.x1.x5.x8.G LELO_GR01_0.x8.x1.x5.x9<2>.G 2.14916f
C1528 a_4765_n158# VDPWR 0.20598f
C1529 a_4609_110# ui_in<0> 0.01111f
C1530 digital_0._103_.RESET_B a_11415_3650# 0.01104f
C1531 digital_0._103_.D digital_0._111_.Q 0.03409f
C1532 digital_0._069_.A digital_0._067_.B 0.24686f
C1533 digital_0.hold28.A digital_0.hold20.X 0.07362f
C1534 digital_0._100_.RESET_B digital_0.clkbuf_1_0__f_clk.X 0.13573f
C1535 LELO_GR01_0.x7.xd1<4>.A uo_out<1> 0.1702f
C1536 LELO_GR01_0.x8.PWRUP_N_1V8 uio_out<2> 0.06711f
C1537 JNWTR_ORX1_CV_0.XA2.A uio_out<5> 0.01036f
C1538 LELO_GR01_0.PWRUP_1V8 uio_out<6> 0.01328f
C1539 digital_0.clkbuf_1_0__f_clk.X a_4111_1474# 0.01406f
C1540 digital_0.input1.X digital_0._111_.RESET_B 0.09595f
C1541 digital_0.hold19.X a_3471_1474# 0.0384f
C1542 a_4578_10200# VDPWR 0.01413f
C1543 a_26158_14644# a_26590_14644# 0.14233f
C1544 digital_0.input1.X a_7221_412# 0.03134f
C1545 digital_0._112_.Q a_12646_1500# 0.01373f
C1546 digital_0.clkload0.A a_8578_n132# 0.04945f
C1547 LELO_GR01_0.x8.x1.x5.x8.G uio_out<0> 0.20302f
C1548 a_22686_11144# a_23118_11144# 0.14233f
C1549 a_4438_386# a_5218_778# 0.06473f
C1550 digital_0._114_.RESET_B a_9463_654# 0.16893f
C1551 a_7405_2588# clk 0.0127f
C1552 LELO_GR01_0.x7.x31.N a_7820_6824# 0.22899f
C1553 digital_0._116_.D uo_out<0> 0.03251f
C1554 a_5218_778# VDPWR 0.1013f
C1555 a_9981_246# a_9886_234# 0.04983f
C1556 a_4354_3834# digital_0.output4.A 0.05307f
C1557 LELO_GR01_0.x7.xd1<4>.A a_14358_15670# 0.07584f
C1558 VDPWR uio_out<3> 1.10517f
C1559 ui_in<0> uio_out<0> 0.01268f
C1560 rst_n uo_out<1> 0.17644f
C1561 ui_in<1> uo_out<0> 0.17552f
C1562 digital_0._108_.D a_6263_2562# 0.01251f
C1563 LELO_GR01_0.x7.x11.P uio_out<6> 0.09563f
C1564 LELO_GR01_0.x8.x5.XA7.CN uio_out<4> 0.02749f
C1565 digital_0.output4.A a_4005_n158# 0.13076f
C1566 LELO_GR01_0.x8.x5.XA6.MN1.S uo_out<0> 0.06967f
C1567 a_2858_4904# ui_in<0> 0.02437f
C1568 a_14769_3436# VDPWR 0.42614f
C1569 a_9930_930# digital_0._060_.B 0.0123f
C1570 digital_0.input1.X a_5422_n702# 0.02833f
C1571 digital_0._060_.A_N a_9005_956# 0.06276f
C1572 digital_0._114_.Q a_10495_n702# 0.10785f
C1573 a_4005_n158# digital_0._119_.RESET_B 0.33236f
C1574 LELO_GR01_0.x7.xd1<4>.A a_4578_18000# 0.02741f
C1575 a_3618_n518# VDPWR 0.24122f
C1576 digital_0.load_slew15.X a_8145_2562# 0.0302f
C1577 digital_0._069_.A a_7623_2830# 0.02093f
C1578 LELO_GR01_0.x8.x5.CK a_26146_3451# 0.07681f
C1579 digital_0._100_.RESET_B a_4108_2840# 0.23049f
C1580 digital_0.hold28.A a_13103_3171# 0.01002f
C1581 a_13513_3138# a_14029_3510# 0.11535f
C1582 a_13679_3138# a_14247_3106# 0.18122f
C1583 a_16872_16564# a_17304_16564# 0.21349f
C1584 a_22470_13064# uio_out<2> 0.01049f
C1585 digital_0._116_.Q a_3814_386# 0.12158f
C1586 digital_0._111_.RESET_B a_9981_2422# 0.15779f
C1587 a_22038_11144# uio_out<1> 0.01733f
C1588 LELO_GR01_0.PWRUP_1V8 LELO_GR01_0.x8.x1.x7.D 0.31323f
C1589 JNWTR_ORX1_CV_0.A a_8468_4904# 0.02142f
C1590 a_23346_14644# LELO_GR01_0.x7.x29.P 0.01299f
C1591 a_5215_3676# VDPWR 0.29162f
C1592 digital_0.hold22.X digital_0._080_.A2 0.05558f
C1593 digital_0.output4.A ui_in<0> 0.03944f
C1594 digital_0.output5.A uo_out<1> 0.17996f
C1595 a_28286_11144# a_28718_11144# 0.14233f
C1596 LELO_GR01_0.x8.x1.x5.x8.G a_20156_8709# 0.07053f
C1597 a_4570_n16# VDPWR 0.57918f
C1598 digital_0._119_.RESET_B ui_in<0> 0.01381f
C1599 digital_0._103_.RESET_B digital_0._111_.Q 0.05597f
C1600 LELO_GR01_0.x8.PWRUP_N_1V8 uio_out<3> 0.1926f
C1601 a_6636_17810# VDPWR 0.40448f
C1602 LELO_GR01_0.PWRUP_1V8 uio_out<5> 0.06182f
C1603 digital_0._069_.A digital_0._067_.A 0.27725f
C1604 LELO_GR01_0.x7.x1.x5.IBN a_9738_14810# 0.0318f
C1605 uio_oe<2> uio_oe<3> 0.04219f
C1606 a_7405_2588# a_7501_2588# 0.01379f
C1607 LELO_GR01_0.x7.x24.D clk 0.08233f
C1608 digital_0.hold28.A digital_0.input2.X 0.08662f
C1609 a_2478_9750# VDPWR 0.36615f
C1610 LELO_GR01_0.x8.IBP_BG a_20372_10347# 0.02366f
C1611 digital_0.input1.X a_7439_654# 0.01907f
C1612 LELO_GR01_0.x8.x5.XA6.A VDPWR 0.04131f
C1613 digital_0.clkload0.A a_8361_n132# 0.0679f
C1614 a_4530_626# a_5218_778# 0.15365f
C1615 digital_0._114_.RESET_B a_8895_412# 0.05072f
C1616 a_7623_2830# clk 0.01451f
C1617 a_6530_4904# a_7388_4904# 0.04885f
C1618 a_4228_3650# digital_0.output4.A 0.04929f
C1619 a_4354_3834# a_4594_3650# 0.11296f
C1620 digital_0.output5.A a_4979_3676# 0.2875f
C1621 LELO_GR01_0.x7.xd1<4>.A a_12688_14988# 0.03591f
C1622 VDPWR uo_out<1> 2.2553f
C1623 rst_n uio_out<0> 1.08247f
C1624 digital_0._069_.A a_11431_2382# 0.08146f
C1625 LELO_GR01_0.x7.x11.P uio_out<5> 0.05238f
C1626 LELO_GR01_0.x8.x5.XA7.C uio_out<4> 0.03519f
C1627 a_26930_9093# uo_out<0> 0.02156f
C1628 digital_0.output6.A digital_0.load_slew17.X 0.04071f
C1629 LELO_GR01_0.x8.x5.Q uio_out<7> 0.02865f
C1630 LELO_GR01_0.x8.VREF_BG a_24508_5627# 0.08035f
C1631 digital_0.input1.X a_5182_n518# 0.02675f
C1632 a_14029_3510# VDPWR 0.18853f
C1633 digital_0._060_.B a_10066_n524# 0.03878f
C1634 digital_0._114_.Q digital_0.hold21.X 0.33446f
C1635 digital_0._080_.A2 a_5785_n426# 0.03996f
C1636 a_4005_n158# a_4292_0# 0.23366f
C1637 LELO_GR01_0.x7.x18.D a_4578_18000# 0.0784f
C1638 LELO_GR01_0.x8.PWRUP_N_1V8 a_6636_17810# 0.08178f
C1639 a_14967_n702# a_15225_n702# 0.22264f
C1640 a_3492_n702# VDPWR 0.23185f
C1641 a_14358_15670# VDPWR 0.4124f
C1642 digital_0._069_.A a_7055_2588# 0.57366f
C1643 digital_0._100_.RESET_B a_3821_2562# 0.27799f
C1644 digital_0.load_slew15.A digital_0.input1.X 0.0333f
C1645 a_13513_3138# digital_0._102_.RESET_B 0.33077f
C1646 LELO_GR01_0.x8.PWRUP_N_1V8 a_2478_9750# 0.07785f
C1647 a_22254_11144# uio_out<2> 0.01924f
C1648 a_22470_13064# uio_out<3> 0.01138f
C1649 digital_0.load_slew15.X digital_0._116_.SET_B 0.17291f
C1650 digital_0._111_.RESET_B a_10199_2018# 0.17458f
C1651 digital_0._111_.D a_9631_2050# 0.21216f
C1652 a_21176_11144# uio_out<1> 0.01789f
C1653 LELO_GR01_0.PWRUP_1V8 a_23816_8541# 0.07606f
C1654 LELO_GR01_0.x8.x8.D LELO_GR01_0.x8.x5.XA5.A 0.65561f
C1655 a_3858_3650# uo_out<1> 0.19376f
C1656 a_4979_3676# VDPWR 0.27789f
C1657 a_9886_2410# VDPWR 0.0848f
C1658 digital_0._116_.SET_B a_4696_n132# 0.01389f
C1659 digital_0._060_.B a_9981_246# 0.01098f
C1660 LELO_GR01_0.x8.x1.x5.x8.G a_18456_7909# 0.13066f
C1661 a_4609_110# VDPWR 0.45473f
C1662 LELO_GR01_0.x8.PWRUP_N_1V8 uo_out<1> 0.26645f
C1663 LELO_GR01_0.x7.xd1<4>.A uo_out<0> 0.63651f
C1664 a_2478_14990# a_2478_14480# 0.02417f
C1665 digital_0.clkbuf_1_0__f_clk.X a_3471_1474# 0.0174f
C1666 digital_0.input1.X digital_0._108_.RESET_B 0.48039f
C1667 a_4578_10610# VDPWR 0.3588f
C1668 digital_0._116_.Q a_12849_1866# 0.0283f
C1669 LELO_GR01_0.x8.x1.x5.x9<2>.G VDPWR 0.02304f
C1670 a_11060_4904# uio_out<0> 0.01009f
C1671 digital_0._118_.D digital_0.input2.X 0.13337f
C1672 digital_0.hold28.A a_14686_246# 0.02767f
C1673 digital_0.load_slew17.X digital_0._113_.D 0.01383f
C1674 digital_0._063_.A a_12391_1500# 0.01642f
C1675 digital_0.input1.X a_6871_412# 0.55733f
C1676 a_11388_956# a_12391_412# 0.01118f
C1677 a_7055_2588# clk 0.05579f
C1678 a_7513_2954# VDPWR 0.13343f
C1679 LELO_GR01_0.x8.x5.XA7.CN LELO_GR01_0.x8.x5.XA6.MP1.S 0.02377f
C1680 digital_0._116_.D ui_in<0> 0.01751f
C1681 digital_0.output5.A digital_0.output4.A 0.81276f
C1682 LELO_GR01_0.x7.xd1<4>.A a_14358_15810# 0.07582f
C1683 VDPWR uio_out<0> 0.62863f
C1684 ui_in<0> ui_in<1> 0.11526f
C1685 LELO_GR01_0.x7.x11.P uio_out<7> 0.11272f
C1686 LELO_GR01_0.x7.x11.P a_22698_16564# 0.19013f
C1687 a_26090_9093# uo_out<0> 0.03083f
C1688 LELO_GR01_0.x8.IBP_BG a_23138_5627# 0.08725f
C1689 digital_0.output9.A a_15685_386# 0.29644f
C1690 digital_0.input1.X a_5056_n702# 0.11328f
C1691 digital_0._102_.RESET_B VDPWR 0.81347f
C1692 digital_0._060_.B a_9417_n702# 0.12037f
C1693 LELO_GR01_0.x7.x18.D a_2478_17610# 0.01495f
C1694 a_15537_n132# VDPWR 0.42922f
C1695 a_12688_14988# VDPWR 0.40785f
C1696 digital_0.output13.A a_6455_3452# 0.10609f
C1697 digital_0._116_.Q digital_0.input1.X 0.16959f
C1698 digital_0._069_.A a_6889_2588# 0.06108f
C1699 digital_0._109_.Q digital_0._108_.D 0.26787f
C1700 a_13513_3138# a_14247_3106# 0.07009f
C1701 digital_0._102_.D a_13679_3138# 0.22772f
C1702 a_16656_14644# a_17088_14644# 0.14233f
C1703 a_22254_11144# uio_out<3> 0.01813f
C1704 digital_0.output13.A a_5486_1334# 0.04112f
C1705 digital_0._111_.RESET_B a_9631_2050# 0.02764f
C1706 digital_0._111_.D a_9465_2050# 0.16301f
C1707 LELO_GR01_0.x8.x8.D a_26930_8613# 0.31063f
C1708 a_2478_11060# a_2478_10550# 0.02417f
C1709 LELO_GR01_0.x8.PWRUP_N_1V8 LELO_GR01_0.x8.x1.x5.x9<2>.G 0.46803f
C1710 digital_0.input2.X digital_0._080_.A2 0.16724f
C1711 digital_0.hold23.X a_14727_1474# 0.03924f
C1712 digital_0.input1.X digital_0._107_.RESET_B 0.0466f
C1713 digital_0.load_slew17.X digital_0._060_.B 0.27403f
C1714 digital_0.hold28.A a_14871_n524# 0.01114f
C1715 a_3618_3834# uo_out<1> 0.04771f
C1716 digital_0._118_.D a_4826_1322# 0.1576f
C1717 digital_0.output4.A VDPWR 0.78485f
C1718 a_6961_2044# VDPWR 0.14264f
C1719 digital_0._116_.SET_B a_4765_n158# 0.04178f
C1720 digital_0._060_.B digital_0._106_.RESET_B 0.03316f
C1721 digital_0._119_.RESET_B VDPWR 0.41285f
C1722 a_4005_n158# ui_in<0> 0.01004f
C1723 LELO_GR01_0.PWRUP_1V8 uio_out<1> 0.0455f
C1724 LELO_GR01_0.x8.PWRUP_N_1V8 uio_out<0> 1.53571f
C1725 a_2478_17610# VDPWR 0.36654f
C1726 LELO_GR01_0.x7.xd1<4>.A ui_in<1> 0.37536f
C1727 LELO_GR01_0.x8.VREF_BG a_18600_16564# 0.32824f
C1728 uio_oe<1> uio_oe<2> 0.04126f
C1729 LELO_GR01_0.x7.x25.D VDPWR 0.46588f
C1730 digital_0._116_.Q a_12646_1500# 0.01625f
C1731 digital_0._065_.A2_N a_11107_2562# 0.04936f
C1732 digital_0.hold28.A a_14861_172# 0.01504f
C1733 digital_0._063_.A digital_0._113_.D 0.26285f
C1734 digital_0.input1.X a_6705_412# 0.32439f
C1735 digital_0._114_.RESET_B a_8729_412# 0.31949f
C1736 a_11388_956# a_12225_412# 0.01925f
C1737 a_6889_2588# clk 0.04809f
C1738 a_7310_2588# VDPWR 0.0798f
C1739 LELO_GR01_0.x8.x5.XA7.C LELO_GR01_0.x8.x5.XA6.MP1.S 0.02158f
C1740 LELO_GR01_0.x8.x5.XA7.CN LELO_GR01_0.x8.x5.XA6.A 0.65975f
C1741 LELO_GR01_0.x7.x31.N a_7388_4904# 0.0187f
C1742 a_4746_412# ui_in<0> 0.01209f
C1743 a_9631_n126# a_9886_234# 0.06418f
C1744 a_18068_556# a_18068_236# 0.01f
C1745 digital_0.output5.A a_4594_3650# 0.06395f
C1746 a_4228_3650# a_4354_3834# 0.34134f
C1747 LELO_GR01_0.x7.xd1<4>.A a_12688_15788# 0.0373f
C1748 LELO_GR01_0.x7.x6<3>.G LELO_GR01_0.x7.x7.S 4.34539f
C1749 VDPWR uo_out<0> 3.49216f
C1750 digital_0._069_.A a_10721_2348# 0.02029f
C1751 LELO_GR01_0.x7.x11.P uio_out<1> 0.05511f
C1752 a_21186_14644# uio_out<0> 0.01888f
C1753 digital_0.clkload0.A digital_0._111_.D 0.09416f
C1754 a_21402_16564# a_21834_16564# 0.21349f
C1755 a_9981_2422# a_10089_2044# 0.05722f
C1756 a_2478_8440# VDPWR 0.35724f
C1757 LELO_GR01_0.x8.x5.XA7.MN0.S uo_out<0> 0.01881f
C1758 LELO_GR01_0.x8.x5.XA7.C uio_out<3> 0.03533f
C1759 a_10730_9234# a_11162_9234# 0.01515f
C1760 LELO_GR01_0.x8.IBP_BG a_23138_6427# 0.07231f
C1761 digital_0._080_.A2 a_4826_1322# 0.01626f
C1762 a_14247_3106# VDPWR 0.19913f
C1763 digital_0._112_.Q a_12849_778# 0.02638f
C1764 digital_0._060_.B a_9151_n702# 0.20723f
C1765 a_26930_7333# a_26930_7013# 0.01f
C1766 LELO_GR01_0.x8.PWRUP_N_1V8 a_2478_17610# 0.07797f
C1767 LELO_GR01_0.x7.xd1<4>.A a_4578_18140# 0.02747f
C1768 LELO_GR01_0.x7.x6<3>.G a_4578_17200# 0.06102f
C1769 a_11007_n524# digital_0.hold21.X 0.1356f
C1770 a_14871_n524# a_14967_n702# 0.41909f
C1771 a_18068_236# rst_n 0.06129f
C1772 a_14358_15810# VDPWR 0.4122f
C1773 digital_0._108_.Q a_6455_3452# 0.02841f
C1774 digital_0._069_.A digital_0.input1.X 0.74263f
C1775 digital_0.hold28.A a_13934_3498# 0.01625f
C1776 digital_0._109_.Q digital_0._118_.RESET_B 0.20949f
C1777 digital_0.output13.A digital_0._108_.D 0.0461f
C1778 a_13513_3138# a_13679_3138# 0.90347f
C1779 LELO_GR01_0.x8.PWRUP_N_1V8 LELO_GR01_0.x7.x25.D 1.02027f
C1780 LELO_GR01_0.x7.x10.P a_17736_16564# 0.21306f
C1781 digital_0.output13.A a_5661_1260# 0.16783f
C1782 digital_0.load_slew15.X a_3814_386# 0.0115f
C1783 digital_0._111_.RESET_B a_9465_2050# 0.30569f
C1784 a_22038_11144# uio_out<2> 0.02318f
C1785 LELO_GR01_0.PWRUP_1V8 LELO_GR01_0.x8.x1.x5.IBN 0.0123f
C1786 digital_0.input1.X a_6684_0# 0.024f
C1787 digital_0.hold28.A a_13746_n524# 0.36904f
C1788 a_3492_3650# uo_out<1> 0.02405f
C1789 digital_0._118_.D digital_0._080_.A2 0.04205f
C1790 a_4594_3650# VDPWR 0.25542f
C1791 LELO_GR01_0.x7.x15.I1 a_9980_6824# 0.01064f
C1792 digital_0._116_.SET_B a_4570_n16# 0.01992f
C1793 a_18456_8709# LELO_GR01_0.x8.x1.x5.x8.G 0.08382f
C1794 a_4292_0# VDPWR 0.29105f
C1795 a_6636_18610# VDPWR 0.4456f
C1796 LELO_GR01_0.x7.xd1<4>.A ui_in<0> 0.09929f
C1797 digital_0._103_.RESET_B digital_0._103_.D 0.2639f
C1798 digital_0.clkload0.A digital_0._112_.Q 0.59782f
C1799 digital_0._065_.A2_N a_10285_2910# 0.17239f
C1800 a_2478_10550# VDPWR 0.36657f
C1801 digital_0._116_.Q digital_0.input3.X 0.50477f
C1802 LELO_GR01_0.x8.PWRUP_N_1V8 a_2478_8440# 0.07043f
C1803 a_10628_4904# uio_out<0> 0.0326f
C1804 digital_0._063_.A a_12225_1500# 0.03888f
C1805 LELO_GR01_0.x7.x29.P a_25270_13064# 0.22899f
C1806 digital_0.input1.X clk 0.06462f
C1807 a_11107_2562# VDPWR 0.24913f
C1808 a_4610_386# a_4746_412# 0.25769f
C1809 a_4438_386# digital_0._116_.D 0.10248f
C1810 a_23824_9183# a_23816_8541# 0.01862f
C1811 LELO_GR01_0.x8.x5.XA7.C LELO_GR01_0.x8.x5.XA6.A 0.58167f
C1812 LELO_GR01_0.x7.x31.N a_6530_4904# 0.0187f
C1813 a_4610_386# ui_in<0> 0.01523f
C1814 digital_0._106_.D a_9886_234# 0.16124f
C1815 digital_0._116_.D VDPWR 0.95735f
C1816 a_14861_172# a_14686_246# 0.23366f
C1817 digital_0.output5.A a_4354_3834# 0.03614f
C1818 LELO_GR01_0.x7.x6<3>.G a_4580_14870# 0.13443f
C1819 VDPWR ui_in<1> 0.58122f
C1820 rst_n ui_in<0> 2.39646f
C1821 digital_0.clkload0.A digital_0._111_.RESET_B 0.0905f
C1822 LELO_GR01_0.x7.x15.I2 LELO_GR01_0.x7.x15.I1 6.22f
C1823 a_10199_2018# a_10089_2044# 0.09774f
C1824 LELO_GR01_0.x8.x5.XA7.MP1.S uo_out<0> 0.33641f
C1825 LELO_GR01_0.x8.VREF_BG a_24508_6427# 0.08053f
C1826 LELO_GR01_0.x7.x11.N a_29582_11144# 0.01976f
C1827 a_13679_3138# VDPWR 0.25956f
C1828 digital_0._112_.Q a_12646_412# 0.01619f
C1829 digital_0._060_.A_N digital_0._060_.B 0.23709f
C1830 digital_0._115_.Q a_7826_956# 0.03064f
C1831 a_14727_1474# VDPWR 0.15359f
C1832 a_21554_6773# a_21558_6509# 0.05091f
C1833 LELO_GR01_0.x7.x18.D a_4578_18140# 0.07839f
C1834 LELO_GR01_0.x8.PWRUP_N_1V8 a_6636_18610# 0.07579f
C1835 LELO_GR01_0.x7.x19.D a_2478_17610# 0.07959f
C1836 a_10066_n524# digital_0.hold21.X 0.0578f
C1837 a_18068_236# VDPWR 0.29467f
C1838 a_17228_236# rst_n 0.06183f
C1839 digital_0.output11.A uio_out<6> 0.05469f
C1840 a_12688_15788# VDPWR 0.48955f
C1841 a_6235_3106# a_6455_3452# 0.01892f
C1842 digital_0.output13.A digital_0._118_.RESET_B 0.44902f
C1843 digital_0._108_.Q digital_0._108_.D 0.1312f
C1844 a_13513_3138# digital_0._102_.D 0.25021f
C1845 LELO_GR01_0.x8.PWRUP_N_1V8 a_2478_10550# 0.08238f
C1846 digital_0.output13.A a_4921_1334# 0.03568f
C1847 digital_0.output4.A a_4118_412# 0.02373f
C1848 LELO_GR01_0.PWRUP_1V8 a_21554_8625# 0.01037f
C1849 JNWTR_ORX1_CV_0.A a_8036_4904# 0.02142f
C1850 a_22914_14644# LELO_GR01_0.x7.x29.P 0.0199f
C1851 a_4578_11670# a_4578_11410# 0.05215f
C1852 LELO_GR01_0.x7.x24.D a_2478_9750# 0.01255f
C1853 digital_0._104_.D digital_0.hold23.X 0.01575f
C1854 digital_0.input1.X a_6397_n158# 0.03252f
C1855 digital_0.hold28.A a_12737_n676# 0.04085f
C1856 a_3492_3650# uio_out<0> 0.09517f
C1857 a_4354_3834# VDPWR 0.22681f
C1858 a_9245_412# a_9341_412# 0.01379f
C1859 digital_0._060_.B a_9631_n126# 0.02586f
C1860 digital_0._116_.SET_B a_4609_110# 0.14997f
C1861 a_4005_n158# VDPWR 0.40313f
C1862 a_18068_556# rst_n 0.05952f
C1863 a_14319_3828# digital_0.hold24.X 0.13051f
C1864 LELO_GR01_0.x8.x8.D uio_out<6> 0.59995f
C1865 LELO_GR01_0.PWRUP_1V8 uio_out<4> 0.08377f
C1866 LELO_GR01_0.x7.xd1<4>.A rst_n 0.10238f
C1867 LELO_GR01_0.x8.PWRUP_N_1V8 ui_in<1> 0.06323f
C1868 digital_0.load_slew17.A digital_0.clkload0.A 0.60112f
C1869 LELO_GR01_0.x8.PWRUP_N_1V8 a_21618_14644# 0.01686f
C1870 LELO_GR01_0.x7.x1.x5.x9<2>.G a_9738_14010# 0.07064f
C1871 uio_oe<0> uio_oe<1> 0.04126f
C1872 digital_0.load_slew17.A a_15268_1474# 0.09342f
C1873 a_10074_2562# a_10285_2910# 0.27272f
C1874 a_4578_11410# VDPWR 0.35714f
C1875 digital_0._116_.Q a_15634_1474# 0.01381f
C1876 a_7405_2588# a_7513_2954# 0.05722f
C1877 digital_0.hold28.A digital_0._105_.RESET_B 0.21906f
C1878 digital_0._112_.Q a_14298_1652# 0.22896f
C1879 digital_0._063_.A digital_0._063_.B 0.10792f
C1880 a_4730_1652# digital_0.hold22.X 0.06567f
C1881 digital_0._114_.Q digital_0.clkload0.X 0.05621f
C1882 a_10285_2910# VDPWR 0.13534f
C1883 a_4530_626# digital_0._116_.D 0.12989f
C1884 a_4438_386# a_4746_412# 0.18443f
C1885 a_6098_4904# a_6530_4904# 0.01515f
C1886 a_4438_386# ui_in<0> 0.05995f
C1887 a_9465_n126# a_9886_234# 0.09313f
C1888 a_4746_412# VDPWR 0.2464f
C1889 a_17228_556# a_17228_236# 0.01f
C1890 digital_0.output5.A a_4228_3650# 0.06236f
C1891 VDPWR ui_in<0> 1.25922f
C1892 digital_0._116_.Q a_9631_2050# 0.03574f
C1893 digital_0._110_.Q a_11107_2562# 0.09101f
C1894 LELO_GR01_0.x7.x11.P uio_out<4> 0.04147f
C1895 a_21186_14644# a_21618_14644# 0.14233f
C1896 LELO_GR01_0.x8.IBP_BG LELO_GR01_0.x7.x29.N 0.06106f
C1897 LELO_GR01_0.x7.x7.S a_4578_12470# 0.0891f
C1898 a_26930_9093# VDPWR 0.06129f
C1899 digital_0._101_.D a_4730_1652# 0.08082f
C1900 LELO_GR01_0.x8.x5.XA7.CN uo_out<0> 0.42983f
C1901 a_9631_2050# a_10089_2044# 0.03462f
C1902 digital_0._115_.Q a_7099_956# 0.03928f
C1903 digital_0._102_.D VDPWR 0.43291f
C1904 digital_0.load_slew17.X digital_0._112_.RESET_B 0.22865f
C1905 a_9564_930# digital_0._114_.RESET_B 0.02681f
C1906 digital_0._060_.A_N a_7826_956# 0.07193f
C1907 digital_0.output9.A JNWTR_IVX1_CV_0.Y 0.01235f
C1908 digital_0.hold23.X VDPWR 0.69749f
C1909 a_26090_7333# a_26090_7013# 0.01f
C1910 LELO_GR01_0.x8.x7.D LELO_GR01_0.x8.x5.CK 0.19224f
C1911 LELO_GR01_0.x7.x18.D LELO_GR01_0.x7.xd1<4>.A 2.45274f
C1912 LELO_GR01_0.x7.x6<3>.G a_4578_18000# 0.06102f
C1913 LELO_GR01_0.x7.x1.x5.x6.N a_8552_17568# 0.03752f
C1914 digital_0.output11.A uio_out<5> 0.16995f
C1915 a_11318_14986# VDPWR 0.40021f
C1916 digital_0.load_slew15.X digital_0.input1.X 0.06421f
C1917 digital_0.output13.A digital_0._101_.RESET_B 0.01338f
C1918 a_6235_3106# digital_0._108_.D 0.22729f
C1919 a_12889_3171# digital_0._102_.D 0.08097f
C1920 digital_0.output13.A a_5139_930# 0.02199f
C1921 LELO_GR01_0.x7.x29.P uio_out<6> 0.05194f
C1922 digital_0.output4.A digital_0._116_.SET_B 0.0386f
C1923 digital_0.hold28.A a_14673_1334# 0.0243f
C1924 LELO_GR01_0.x8.PWRUP_N_1V8 LELO_GR01_0.x8.x1.x5.x8.G 0.10125f
C1925 LELO_GR01_0.x8.x8.D LELO_GR01_0.x8.x1.x7.D 0.01324f
C1926 digital_0.load_slew17.X digital_0._114_.RESET_B 0.10871f
C1927 digital_0.hold28.A a_12626_n676# 0.03853f
C1928 a_4228_3650# VDPWR 0.21567f
C1929 a_4530_626# a_4005_n158# 0.01137f
C1930 digital_0._060_.B digital_0._106_.D 0.23259f
C1931 digital_0._116_.SET_B digital_0._119_.RESET_B 0.1434f
C1932 a_18068_556# VDPWR 0.2706f
C1933 a_17228_556# rst_n 0.1132f
C1934 digital_0._105_.RESET_B a_14967_n702# 0.01499f
C1935 digital_0.output7.A digital_0.hold24.X 0.11322f
C1936 LELO_GR01_0.PWRUP_1V8 uio_out<2> 0.04065f
C1937 LELO_GR01_0.x7.xd1<4>.A VDPWR 57.9767f
C1938 LELO_GR01_0.x8.x8.D uio_out<5> 0.85254f
C1939 LELO_GR01_0.x8.PWRUP_N_1V8 ui_in<0> 0.31747f
C1940 a_4578_15320# a_4580_14870# 0.02767f
C1941 digital_0._108_.D a_6503_2050# 0.20518f
C1942 digital_0.load_slew17.A a_14298_1652# 0.03657f
C1943 digital_0.hold28.A a_6315_1474# 0.07006f
C1944 digital_0.clkbuf_1_0__f_clk.X digital_0.load_slew17.X 0.08061f
C1945 a_10074_2562# digital_0._065_.A2_N 0.03186f
C1946 a_2478_11060# VDPWR 0.36637f
C1947 digital_0._116_.Q a_15394_1658# 0.02863f
C1948 a_7405_2588# a_7310_2588# 0.04983f
C1949 a_7623_2830# a_7513_2954# 0.09774f
C1950 a_25942_16564# a_26374_16564# 0.21349f
C1951 digital_0.hold28.A a_14339_n158# 0.01124f
C1952 digital_0.output6.A a_6503_930# 0.02703f
C1953 digital_0._112_.Q a_13306_1500# 0.05762f
C1954 digital_0.output9.A digital_0._113_.RESET_B 0.45713f
C1955 digital_0.clkload0.A a_7001_110# 0.2453f
C1956 a_22470_13064# a_22902_13064# 0.21349f
C1957 digital_0._065_.A2_N VDPWR 0.98649f
C1958 a_4530_626# a_4746_412# 0.07694f
C1959 a_4438_386# a_4610_386# 0.20518f
C1960 a_4610_386# VDPWR 0.26764f
C1961 a_4530_626# ui_in<0> 0.0269f
C1962 digital_0._105_.RESET_B a_14686_246# 0.23846f
C1963 a_3814_386# uo_out<1> 0.0101f
C1964 VDPWR rst_n 1.43262f
C1965 digital_0._116_.Q a_9465_2050# 0.04863f
C1966 a_20970_16564# uio_out<0> 0.02002f
C1967 LELO_GR01_0.x7.x11.P uio_out<2> 0.05301f
C1968 LELO_GR01_0.x7.x11.P a_22266_16564# 0.19042f
C1969 a_26090_9093# VDPWR 0.06709f
C1970 digital_0._101_.D a_4369_1474# 0.09178f
C1971 LELO_GR01_0.x8.x5.XA7.C uo_out<0> 0.61174f
C1972 digital_0._060_.A_N a_7099_956# 0.02998f
C1973 a_13513_3138# VDPWR 0.4604f
C1974 a_7155_930# a_7826_956# 0.15745f
C1975 LELO_GR01_0.x8.x5.XA7.MP1.S a_26930_9093# 0.0183f
C1976 LELO_GR01_0.x8.x5.XA7.CN LELO_GR01_0.x8.x5.XA6.MN1.S 0.03056f
C1977 digital_0._104_.D VDPWR 0.42293f
C1978 LELO_GR01_0.x8.PWRUP_N_1V8 LELO_GR01_0.x7.xd1<4>.A 1.91859f
C1979 digital_0.output10.A VDPWR 0.66275f
C1980 digital_0._111_.Q digital_0._110_.D 0.01381f
C1981 a_11318_15786# VDPWR 0.49163f
C1982 LELO_GR01_0.x7.xd1<4>.A a_14358_12620# 0.07579f
C1983 LELO_GR01_0.x8.PWRUP_N_1V8 a_2478_11060# 0.07785f
C1984 LELO_GR01_0.x7.x29.P uio_out<5> 0.07113f
C1985 digital_0.output13.A a_4571_962# 0.0224f
C1986 digital_0._108_.RESET_B a_7418_2422# 0.21671f
C1987 digital_0.output4.A a_3982_386# 0.01877f
C1988 digital_0.hold28.A a_14891_930# 0.01837f
C1989 LELO_GR01_0.x7.x24.D LELO_GR01_0.x7.x25.D 0.56743f
C1990 digital_0._113_.Q digital_0._104_.D 0.02179f
C1991 digital_0._112_.Q digital_0._112_.D 0.05172f
C1992 digital_0.hold28.A a_12409_n676# 0.03941f
C1993 digital_0.output5.A VDPWR 0.85999f
C1994 a_28070_13064# a_28502_13064# 0.21349f
C1995 digital_0._113_.Q digital_0.output10.A 0.17074f
C1996 digital_0._060_.B a_9465_n126# 0.02059f
C1997 digital_0._116_.SET_B a_4292_0# 0.01513f
C1998 a_13978_3650# digital_0.hold24.X 0.19269f
C1999 LELO_GR01_0.x8.x8.D uio_out<7> 0.56618f
C2000 digital_0._116_.Q digital_0.clkload0.A 0.2873f
C2001 LELO_GR01_0.PWRUP_1V8 uio_out<3> 0.04436f
C2002 LELO_GR01_0.x7.x18.D VDPWR 2.59337f
C2003 LELO_GR01_0.x8.PWRUP_N_1V8 rst_n 0.38593f
C2004 digital_0.load_slew15.A digital_0._109_.Q 0.04547f
C2005 LELO_GR01_0.x7.x1.x5.x9<2>.G a_9738_14810# 0.07542f
C2006 LELO_GR01_0.x8.VREF_BG a_18168_16564# 0.31368f
C2007 digital_0._108_.D a_6337_2050# 0.1615f
C2008 digital_0.hold28.A a_4730_1652# 0.32286f
C2009 a_4578_11670# VDPWR 0.03731f
C2010 digital_0._116_.Q a_15268_1474# 0.01631f
C2011 a_7055_2588# a_7513_2954# 0.02761f
C2012 digital_0.hold28.A a_13771_n126# 0.02941f
C2013 digital_0.output6.A a_6407_1188# 0.03182f
C2014 digital_0._112_.Q a_13481_1474# 0.073f
C2015 digital_0.clkbuf_1_1__f_clk.A a_8996_1500# 1.7641f
C2016 a_11060_4904# VDPWR 0.09073f
C2017 digital_0.clkload0.A digital_0._107_.RESET_B 0.27625f
C2018 LELO_GR01_0.x7.x29.P a_24838_11144# 0.0187f
C2019 a_6263_2562# clk 0.01109f
C2020 a_10074_2562# VDPWR 0.32965f
C2021 digital_0._116_.SET_B digital_0._116_.D 0.06808f
C2022 a_4530_626# a_4610_386# 0.2094f
C2023 LELO_GR01_0.x8.x5.Q LELO_GR01_0.x8.x5.XA6.A 0.01049f
C2024 a_4438_386# VDPWR 0.58152f
C2025 digital_0._105_.RESET_B a_14861_172# 0.27927f
C2026 a_14339_n158# a_14686_246# 0.05116f
C2027 a_4118_412# ui_in<0> 0.01252f
C2028 a_3858_3650# digital_0.output5.A 0.22457f
C2029 a_20754_14644# uio_out<0> 0.01998f
C2030 LELO_GR01_0.x7.x11.P uio_out<3> 0.02848f
C2031 digital_0._109_.Q digital_0._108_.RESET_B 0.02202f
C2032 digital_0._110_.Q digital_0._065_.A2_N 0.28222f
C2033 digital_0._101_.D a_4111_1474# 0.01079f
C2034 a_3853_2050# a_4369_1474# 0.0112f
C2035 a_26930_9733# uo_out<0> 0.08161f
C2036 a_15413_1260# a_15238_1334# 0.23366f
C2037 digital_0._060_.A_N digital_0._114_.RESET_B 0.56493f
C2038 digital_0._115_.Q a_7375_1276# 0.10697f
C2039 a_7155_930# a_7099_956# 0.27101f
C2040 a_12889_3171# VDPWR 0.09188f
C2041 LELO_GR01_0.x8.x5.XA7.C LELO_GR01_0.x8.x5.XA6.MN1.S 0.01224f
C2042 LELO_GR01_0.x8.x5.XA7.CN a_26930_9093# 0.02572f
C2043 digital_0._113_.Q VDPWR 1.06118f
C2044 LELO_GR01_0.x8.PWRUP_N_1V8 LELO_GR01_0.x7.x18.D 0.42659f
C2045 LELO_GR01_0.x7.x19.D LELO_GR01_0.x7.xd1<4>.A 0.09695f
C2046 a_14229_n132# VDPWR 0.13243f
C2047 LELO_GR01_0.x7.xd1<4>.A a_14358_13420# 0.07873f
C2048 LELO_GR01_0.x7.x10.P a_17304_16564# 0.21331f
C2049 digital_0._108_.RESET_B a_7593_2348# 0.31857f
C2050 digital_0.output13.A a_4405_962# 0.15748f
C2051 digital_0.hold28.A a_14323_962# 0.03705f
C2052 a_21176_11144# uio_out<0> 0.02299f
C2053 LELO_GR01_0.x7.x29.P uio_out<7> 0.0497f
C2054 LELO_GR01_0.x7.x24.D a_2478_10550# 0.05011f
C2055 digital_0._112_.Q a_10555_956# 0.05323f
C2056 digital_0.load_slew17.X digital_0._115_.D 0.02542f
C2057 digital_0._116_.Q a_15537_n426# 0.10493f
C2058 digital_0.hold28.A a_12138_n702# 0.02815f
C2059 a_3858_3650# VDPWR 0.2492f
C2060 LELO_GR01_0.x7.x15.I1 a_9548_6824# 0.01064f
C2061 LELO_GR01_0.x8.IBP_BG a_17850_3465# 0.03728f
C2062 a_10997_386# a_11673_412# 0.03366f
C2063 a_13738_3834# digital_0.hold24.X 0.04731f
C2064 digital_0._069_.A digital_0.clkload0.A 0.19013f
C2065 LELO_GR01_0.x8.PWRUP_N_1V8 VDPWR 27.9244f
C2066 digital_0._116_.Q digital_0._109_.Q 0.15483f
C2067 a_7717_3926# digital_0._109_.RESET_B 0.15333f
C2068 digital_0._117_.RESET_B digital_0.hold28.A 0.04061f
C2069 LELO_GR01_0.x8.PWRUP_N_1V8 a_21402_16564# 0.02214f
C2070 LELO_GR01_0.x7.x1.x5.x9<2>.G a_8336_14010# 0.08521f
C2071 a_14358_12620# VDPWR 0.4112f
C2072 a_7055_2588# a_7310_2588# 0.05562f
C2073 a_25726_14644# a_26158_14644# 0.14233f
C2074 digital_0.hold28.A digital_0._105_.D 0.19054f
C2075 digital_0._112_.Q a_12741_1500# 0.03367f
C2076 digital_0.load_slew17.X digital_0._115_.RESET_B 0.2603f
C2077 a_10196_4904# uio_out<0> 0.0326f
C2078 a_10628_4904# rst_n 0.01842f
C2079 digital_0.clkbuf_1_1__f_clk.A a_8085_1500# 0.081f
C2080 a_22254_11144# a_22686_11144# 0.14233f
C2081 LELO_GR01_0.x7.x29.P a_23982_11144# 0.0187f
C2082 a_7970_2588# VDPWR 0.2918f
C2083 digital_0._116_.SET_B a_4746_412# 0.16104f
C2084 a_4530_626# a_4438_386# 0.55766f
C2085 a_4530_626# VDPWR 0.28066f
C2086 a_13771_n126# a_14686_246# 0.12532f
C2087 a_7088_n132# a_7302_n132# 0.09774f
C2088 digital_0._105_.RESET_B a_14121_246# 0.15995f
C2089 digital_0._116_.SET_B ui_in<0> 0.03283f
C2090 a_8552_17568# a_9734_16926# 0.01541f
C2091 digital_0._067_.A a_11107_2562# 0.17951f
C2092 LELO_GR01_0.x8.x5.XA7.MP1.S VDPWR 0.04378f
C2093 a_26090_9733# uo_out<0> 0.11444f
C2094 digital_0._116_.Q a_15685_386# 0.01071f
C2095 a_9981_2422# a_10077_2422# 0.01379f
C2096 digital_0._060_.A_N a_7375_1276# 0.05172f
C2097 a_6761_930# a_7099_956# 0.02816f
C2098 digital_0._110_.Q VDPWR 0.87544f
C2099 digital_0._063_.A a_12391_412# 0.01705f
C2100 LELO_GR01_0.x8.x5.XA7.MP1.S LELO_GR01_0.x8.x5.XA7.MN0.S 0.05173f
C2101 LELO_GR01_0.x8.x5.XA7.CN a_26090_9093# 0.06325f
C2102 LELO_GR01_0.x8.x5.XA7.C a_26930_9093# 0.06949f
C2103 LELO_GR01_0.x7.x6<3>.G a_4578_18140# 0.061f
C2104 LELO_GR01_0.x7.x19.D LELO_GR01_0.x7.x18.D 0.52197f
C2105 digital_0._110_.Q a_12889_3171# 0.19068f
C2106 LELO_GR01_0.x7.xd1<4>.A a_11988_12620# 0.08893f
C2107 a_16440_16564# a_16872_16564# 0.21349f
C2108 digital_0._108_.RESET_B a_6853_2422# 0.15327f
C2109 digital_0.output13.A a_3858_930# 0.02978f
C2110 digital_0.input1.X a_9886_2410# 0.01378f
C2111 digital_0.hold28.A a_14157_962# 0.03214f
C2112 LELO_GR01_0.x7.x29.P uio_out<1> 0.0571f
C2113 JNWTR_ORX1_CV_0.A a_7604_4904# 0.02142f
C2114 a_22482_14644# LELO_GR01_0.x7.x29.P 0.0199f
C2115 LELO_GR01_0.PWRUP_1V8 LELO_GR01_0.x8.x1.x5.x9<2>.G 0.06327f
C2116 digital_0.hold28.A a_11898_n518# 0.02479f
C2117 digital_0._115_.RESET_B digital_0._115_.Q 0.61892f
C2118 a_3618_3834# VDPWR 0.23077f
C2119 a_27854_11144# a_28286_11144# 0.14233f
C2120 a_10997_386# digital_0._057_.D 0.10953f
C2121 a_9245_412# a_9353_778# 0.05722f
C2122 a_6758_2410# VDPWR 0.08569f
C2123 a_3982_386# a_4005_n158# 0.01027f
C2124 a_10628_4904# a_11060_4904# 0.01515f
C2125 JNWTR_IVX1_CV_0.Y uio_out<6> 0.02201f
C2126 a_13612_3650# digital_0.hold24.X 0.04161f
C2127 LELO_GR01_0.x8.x1.x5.x6.N uio_out<1> 0.01283f
C2128 LELO_GR01_0.PWRUP_1V8 uio_out<0> 0.13397f
C2129 LELO_GR01_0.x7.x19.D VDPWR 0.5179f
C2130 JNWTR_ORX1_CV_0.XA2.A uo_out<0> 0.07652f
C2131 digital_0._116_.Q digital_0.output13.A 0.51717f
C2132 digital_0._069_.A digital_0._109_.Q 0.09364f
C2133 digital_0._109_.D digital_0._109_.RESET_B 0.01991f
C2134 digital_0._100_.RESET_B digital_0.hold28.A 0.05884f
C2135 LELO_GR01_0.x8.PWRUP_N_1V8 a_21186_14644# 0.03733f
C2136 LELO_GR01_0.x7.x1.x5.x9<2>.G a_8336_14810# 0.12529f
C2137 uo_out<6> uo_out<7> 0.04002f
C2138 digital_0._118_.RESET_B a_5787_2146# 0.01146f
C2139 digital_0._108_.D digital_0.output6.A 0.03091f
C2140 a_6889_2588# a_7310_2588# 0.0858f
C2141 a_14358_13420# VDPWR 0.43103f
C2142 digital_0.hold28.A a_13605_n126# 0.02312f
C2143 digital_0._112_.Q digital_0._113_.RESET_B 0.61482f
C2144 digital_0.load_slew17.X a_5785_1750# 0.0452f
C2145 a_6315_1474# a_8085_1500# 0.01896f
C2146 a_4111_1474# digital_0.input2.X 0.04949f
C2147 a_8145_2562# VDPWR 0.4351f
C2148 a_4118_412# a_4438_386# 0.06363f
C2149 digital_0._116_.SET_B a_4610_386# 0.21194f
C2150 a_20372_9267# a_21554_8625# 0.01541f
C2151 a_13771_n126# a_14861_172# 0.04251f
C2152 a_4118_412# VDPWR 0.24191f
C2153 a_7157_n158# a_7302_n132# 0.05722f
C2154 a_14339_n158# a_14121_246# 0.20964f
C2155 a_3982_386# ui_in<0> 0.0242f
C2156 a_3618_3834# a_3858_3650# 0.11296f
C2157 a_28996_19150# a_28996_18831# 0.01003f
C2158 LELO_GR01_0.x7.x11.P uio_out<0> 0.07616f
C2159 digital_0._108_.Q digital_0._108_.RESET_B 0.43139f
C2160 LELO_GR01_0.x7.x7.S a_4578_13270# 0.0891f
C2161 LELO_GR01_0.x8.x5.Q uo_out<0> 0.23988f
C2162 LELO_GR01_0.x8.x5.XA7.CN VDPWR 0.11174f
C2163 digital_0._116_.Q a_15427_386# 0.03753f
C2164 a_9981_2422# a_9886_2410# 0.04983f
C2165 a_10298_9234# a_10730_9234# 0.14233f
C2166 LELO_GR01_0.x7.x11.N a_28934_13064# 0.2307f
C2167 digital_0._060_.A_N digital_0._115_.D 0.06145f
C2168 a_7155_930# a_7375_1276# 0.01892f
C2169 a_14891_930# a_15238_1334# 0.05116f
C2170 digital_0._109_.Q clk 0.09772f
C2171 a_12635_3171# VDPWR 0.17332f
C2172 digital_0._063_.A a_12225_412# 0.04705f
C2173 digital_0._115_.RESET_B a_7329_778# 0.01838f
C2174 LELO_GR01_0.x8.x5.XA7.C a_26090_9093# 0.01225f
C2175 LELO_GR01_0.x7.x19.D LELO_GR01_0.x8.PWRUP_N_1V8 1.01963f
C2176 a_2478_18410# LELO_GR01_0.x7.x18.D 0.03962f
C2177 LELO_GR01_0.x7.x6<3>.G LELO_GR01_0.x7.xd1<4>.A 2.42153f
C2178 a_12626_n676# a_12737_n676# 0.34134f
C2179 LELO_GR01_0.x7.xd1<4>.A LELO_GR01_0.x7.x24.D 0.09098f
C2180 digital_0._108_.RESET_B a_7071_2018# 0.16185f
C2181 a_20744_11144# uio_out<0> 0.01963f
C2182 LELO_GR01_0.x7.x24.D a_2478_11060# 0.0791f
C2183 digital_0.load_slew17.X digital_0.hold28.X 0.01551f
C2184 digital_0.hold28.A a_11772_n702# 0.02315f
C2185 digital_0._115_.RESET_B digital_0._060_.A_N 0.04698f
C2186 a_3492_3650# VDPWR 0.23336f
C2187 a_9463_654# a_9353_778# 0.09774f
C2188 a_9245_412# a_9150_412# 0.04983f
C2189 digital_0._115_.Q digital_0.output12.A 0.08304f
C2190 JNWTR_IVX1_CV_0.Y uio_out<5> 0.01614f
C2191 a_12829_3676# digital_0.hold24.X 0.01182f
C2192 digital_0.load_slew15.X digital_0.clkload0.A 0.16115f
C2193 a_2478_18410# VDPWR 0.37812f
C2194 LELO_GR01_0.x8.x8.D uio_out<4> 0.07548f
C2195 LELO_GR01_0.PWRUP_1V8 uo_out<0> 0.94218f
C2196 JNWTR_ORX1_CV_0.XA2.A ui_in<1> 0.20137f
C2197 digital_0._069_.A digital_0.output13.A 0.39387f
C2198 digital_0._069_.B digital_0._109_.Q 0.15126f
C2199 digital_0.hold25.X digital_0.hold28.A 0.05966f
C2200 LELO_GR01_0.x7.x1.x5.x9<2>.G a_6936_14010# 0.07336f
C2201 digital_0._118_.RESET_B digital_0.output6.A 0.03979f
C2202 digital_0.load_slew17.A digital_0._113_.RESET_B 0.11366f
C2203 a_8145_2562# a_7970_2588# 0.23366f
C2204 a_11988_12620# VDPWR 0.39903f
C2205 digital_0._112_.Q a_12959_1742# 0.04302f
C2206 a_6315_1474# digital_0.clkbuf_1_1__f_clk.A 0.33032f
C2207 a_4015_1652# digital_0.input2.X 0.05384f
C2208 digital_0.input1.X uo_out<0> 0.07221f
C2209 digital_0._115_.D a_7126_412# 0.16052f
C2210 a_7405_2588# VDPWR 0.20095f
C2211 digital_0._116_.SET_B a_4438_386# 0.04315f
C2212 a_4118_412# a_4530_626# 0.07272f
C2213 a_5882_6824# LELO_GR01_0.x7.x31.N 0.22923f
C2214 a_13605_n126# a_14686_246# 0.10236f
C2215 digital_0._116_.SET_B VDPWR 0.42786f
C2216 a_6962_n16# a_7302_n132# 0.03462f
C2217 a_13771_n126# a_14121_246# 0.21772f
C2218 a_14339_n158# digital_0._105_.RESET_B 0.17615f
C2219 a_3814_386# ui_in<0> 0.01436f
C2220 digital_0._067_.A digital_0._065_.A2_N 0.05698f
C2221 digital_0._111_.Q a_10571_2588# 0.0635f
C2222 a_20538_14644# uio_out<0> 0.01674f
C2223 digital_0._118_.RESET_B digital_0._100_.D 0.02835f
C2224 LELO_GR01_0.x7.x11.P uo_out<0> 0.11068f
C2225 LELO_GR01_0.x7.x11.P a_21834_16564# 0.19131f
C2226 a_26930_10053# uo_out<0> 0.06533f
C2227 LELO_GR01_0.x8.x5.XA7.C VDPWR 0.48819f
C2228 digital_0._116_.Q a_15331_564# 0.02336f
C2229 a_7155_930# digital_0._115_.D 0.19915f
C2230 a_14323_962# a_15238_1334# 0.12532f
C2231 digital_0._067_.B VDPWR 0.29223f
C2232 digital_0.output13.A clk 0.09547f
C2233 digital_0.input2.X a_8895_412# 0.02778f
C2234 LELO_GR01_0.x8.x5.XA7.CN LELO_GR01_0.x8.x5.XA7.MP1.S 0.07161f
C2235 LELO_GR01_0.x7.x1.x5.x6.N a_8552_18000# 0.22481f
C2236 LELO_GR01_0.x7.x6<3>.G LELO_GR01_0.x7.x18.D 3.48833f
C2237 a_2478_18410# LELO_GR01_0.x8.PWRUP_N_1V8 0.08598f
C2238 a_4578_18940# LELO_GR01_0.x7.xd1<4>.A 0.05431f
C2239 a_2478_14990# VDPWR 0.36615f
C2240 a_12635_3171# digital_0._110_.Q 0.10396f
C2241 LELO_GR01_0.x7.x6<3>.G a_4578_11670# 0.0833f
C2242 a_16224_14644# a_16656_14644# 0.14233f
C2243 digital_0._108_.RESET_B a_6503_2050# 0.02352f
C2244 digital_0.load_slew15.A a_9005_956# 0.10021f
C2245 digital_0.hold28.A digital_0._114_.Q 0.24425f
C2246 digital_0._065_.A2_N a_11431_2382# 0.18087f
C2247 LELO_GR01_0.x7.x29.P uio_out<4> 0.05836f
C2248 JNWTR_ORX1_CV_0.A a_7388_4904# 0.01991f
C2249 digital_0.hold28.A a_11361_n702# 0.04551f
C2250 digital_0._115_.RESET_B a_7155_930# 0.01615f
C2251 a_26926_4531# VDPWR 0.2841f
C2252 LELO_GR01_0.x8.x3.A uio_out<4> 0.02432f
C2253 digital_0.input3.X a_15537_n132# 0.0498f
C2254 a_8895_412# a_9353_778# 0.03462f
C2255 digital_0._105_.D a_13746_n524# 0.08812f
C2256 a_7181_3926# a_7717_3926# 0.03302f
C2257 LELO_GR01_0.x7.x6<3>.G VDPWR 0.49558f
C2258 LELO_GR01_0.PWRUP_1V8 ui_in<1> 0.20747f
C2259 digital_0._069_.A digital_0._108_.Q 0.21107f
C2260 digital_0._069_.B digital_0.output13.A 0.06911f
C2261 digital_0.load_slew15.X digital_0._109_.Q 0.3838f
C2262 LELO_GR01_0.x8.VREF_BG a_17736_16564# 0.31305f
C2263 LELO_GR01_0.x7.x15.I2 a_14358_15670# 0.03213f
C2264 LELO_GR01_0.x7.x21.D a_2478_13680# 0.01254f
C2265 uo_out<5> uo_out<6> 0.04002f
C2266 digital_0._101_.RESET_B digital_0.output6.A 0.12575f
C2267 LELO_GR01_0.x7.x24.D VDPWR 0.47401f
C2268 digital_0._116_.Q a_12741_1500# 0.0357f
C2269 digital_0._112_.Q a_12391_1500# 0.58748f
C2270 digital_0.input1.X digital_0._116_.D 0.56277f
C2271 a_3471_1474# digital_0.input2.X 0.19057f
C2272 a_7623_2830# VDPWR 0.20832f
C2273 digital_0._116_.SET_B a_4530_626# 0.20931f
C2274 a_3982_386# a_4438_386# 0.18432f
C2275 a_13605_n126# a_14861_172# 0.04359f
C2276 a_3982_386# VDPWR 0.4054f
C2277 a_13771_n126# digital_0._105_.RESET_B 0.0568f
C2278 digital_0._107_.D a_7720_n132# 0.15794f
C2279 a_3492_3650# a_3618_3834# 0.34134f
C2280 a_28156_19150# a_28156_18831# 0.01003f
C2281 a_21252_18698# a_21252_18378# 0.01f
C2282 a_8552_17568# a_8336_17010# 0.01519f
C2283 LELO_GR01_0.x8.PWRUP_N_1V8 a_2478_14990# 0.07785f
C2284 LELO_GR01_0.x7.xd1<4>.A a_4578_15320# 0.01267f
C2285 digital_0._101_.RESET_B digital_0._100_.D 0.02215f
C2286 a_20970_16564# a_21402_16564# 0.21349f
C2287 digital_0.hold28.A digital_0._114_.D 0.05847f
C2288 a_26090_10053# uo_out<0> 0.10164f
C2289 digital_0._116_.Q JNWTR_IVX1_CV_0.Y 0.0844f
C2290 a_9631_2050# a_9886_2410# 0.06121f
C2291 a_6761_930# digital_0._115_.D 0.03034f
C2292 a_14891_930# a_14673_1334# 0.20964f
C2293 a_14157_962# a_15238_1334# 0.10236f
C2294 a_14323_962# a_15413_1260# 0.04251f
C2295 digital_0._067_.A VDPWR 1.00583f
C2296 digital_0._108_.Q clk 0.08955f
C2297 digital_0.input2.X digital_0._114_.D 0.1958f
C2298 LELO_GR01_0.x8.x5.XA7.C LELO_GR01_0.x8.x5.XA7.MP1.S 0.04215f
C2299 digital_0._115_.Q a_7643_n702# 0.10048f
C2300 LELO_GR01_0.x8.x1.x5.x9<2>.G a_19356_4659# 0.0124f
C2301 LELO_GR01_0.x7.x1.x5.x8.S a_8552_18000# 0.22449f
C2302 LELO_GR01_0.x7.x6<3>.G LELO_GR01_0.x8.PWRUP_N_1V8 0.15085f
C2303 a_2478_18410# LELO_GR01_0.x7.x19.D 0.0428f
C2304 a_4578_18940# LELO_GR01_0.x7.x18.D 0.07043f
C2305 a_12409_n676# a_12626_n676# 0.11296f
C2306 digital_0._103_.RESET_B a_10641_3132# 0.01264f
C2307 LELO_GR01_0.x7.x21.D clk 0.08198f
C2308 digital_0._067_.B digital_0._110_.Q 0.23129f
C2309 a_4093_3510# a_4201_3132# 0.05722f
C2310 LELO_GR01_0.x7.x15.I2 uio_out<0> 0.01838f
C2311 LELO_GR01_0.x8.PWRUP_N_1V8 LELO_GR01_0.x7.x24.D 1.02091f
C2312 LELO_GR01_0.x7.x10.P a_16872_16564# 0.21389f
C2313 digital_0._116_.Q a_9005_956# 0.08964f
C2314 digital_0._069_.A a_10555_956# 0.09902f
C2315 a_20528_11144# uio_out<0> 0.01903f
C2316 LELO_GR01_0.x7.x29.P uio_out<2> 0.04858f
C2317 digital_0._108_.RESET_B a_6337_2050# 0.29526f
C2318 JNWTR_ORX1_CV_0.A a_6530_4904# 0.01991f
C2319 LELO_GR01_0.PWRUP_1V8 LELO_GR01_0.x8.x1.x5.x8.G 0.01555f
C2320 LELO_GR01_0.x8.x8.D LELO_GR01_0.x8.x5.XA6.MP1.S 0.08476f
C2321 LELO_GR01_0.x8.x1.x5.x6.N a_20156_7909# 0.39909f
C2322 digital_0.hold28.A a_11103_n702# 0.06614f
C2323 LELO_GR01_0.x7.x15.I1 a_9116_6824# 0.01064f
C2324 a_11431_2382# VDPWR 0.24609f
C2325 a_8895_412# a_9150_412# 0.06418f
C2326 a_7181_3926# digital_0._109_.D 0.15276f
C2327 a_4578_18940# VDPWR 0.02654f
C2328 digital_0._069_.A a_6235_3106# 0.01502f
C2329 digital_0._069_.B digital_0._108_.Q 0.09275f
C2330 digital_0.load_slew15.X digital_0.output13.A 0.30872f
C2331 LELO_GR01_0.x8.PWRUP_N_1V8 a_20970_16564# 0.04424f
C2332 LELO_GR01_0.x7.x21.D LELO_GR01_0.x7.x22.D 0.56561f
C2333 digital_0._101_.RESET_B a_4477_2044# 0.0122f
C2334 a_7623_2830# a_7970_2588# 0.05116f
C2335 a_2478_11860# VDPWR 0.36633f
C2336 digital_0._116_.Q digital_0._113_.RESET_B 0.0903f
C2337 digital_0._112_.Q digital_0._113_.D 0.05158f
C2338 a_11951_2146# a_12225_1500# 0.01052f
C2339 a_3471_1474# digital_0._118_.D 0.15255f
C2340 a_9764_4904# uio_out<0> 0.0326f
C2341 a_10412_6824# VDPWR 0.2945f
C2342 a_10196_4904# rst_n 0.01842f
C2343 a_11388_956# a_11673_412# 0.01467f
C2344 digital_0.input1.X ui_in<0> 0.09853f
C2345 a_7055_2588# VDPWR 0.25279f
C2346 a_5834_2740# clk 0.01812f
C2347 digital_0._116_.SET_B a_4118_412# 0.12109f
C2348 a_3982_386# a_4530_626# 0.05758f
C2349 a_5666_4904# a_6098_4904# 0.14233f
C2350 digital_0._107_.RESET_B a_7302_n132# 0.0122f
C2351 a_3814_386# VDPWR 0.26369f
C2352 a_13605_n126# a_14121_246# 0.11535f
C2353 a_13771_n126# a_14339_n158# 0.18517f
C2354 JNWTR_ORX1_CV_0.A a_24210_18544# 0.06169f
C2355 LELO_GR01_0.x8.IBP_BG a_17668_17950# 0.0283f
C2356 LELO_GR01_0.x7.x18.D a_4578_15320# 0.07939f
C2357 LELO_GR01_0.x7.xd1<4>.A a_14358_16610# 0.07599f
C2358 digital_0._110_.D a_11949_3132# 0.21477f
C2359 digital_0._069_.A a_6503_2050# 0.01885f
C2360 LELO_GR01_0.x8.PWRUP_N_1V8 a_22038_11144# 0.01311f
C2361 a_22292_9483# uio_out<2> 0.01199f
C2362 a_9465_2050# a_9886_2410# 0.09016f
C2363 LELO_GR01_0.x8.IBP_BG LELO_GR01_0.x8.x5.CK 0.47213f
C2364 a_11098_3510# VDPWR 0.29664f
C2365 a_14323_962# a_14673_1334# 0.2298f
C2366 a_14157_962# a_15413_1260# 0.04359f
C2367 digital_0._112_.Q a_13306_412# 0.05449f
C2368 digital_0.input2.X a_8729_412# 0.02991f
C2369 LELO_GR01_0.x8.x5.XA7.C LELO_GR01_0.x8.x5.XA7.CN 0.48001f
C2370 digital_0._115_.Q digital_0.hold26.X 0.28428f
C2371 LELO_GR01_0.x8.x7.D a_24508_6687# 0.0355f
C2372 LELO_GR01_0.PWRUP_1V8 LELO_GR01_0.x7.xd1<4>.A 0.70697f
C2373 a_14026_234# VDPWR 0.07761f
C2374 digital_0._067_.A digital_0._110_.Q 0.02392f
C2375 digital_0._067_.B a_12635_3171# 0.02078f
C2376 a_4311_3106# a_4201_3132# 0.09774f
C2377 LELO_GR01_0.x8.PWRUP_N_1V8 a_2478_11860# 0.08228f
C2378 LELO_GR01_0.x7.xd1<4>.A a_11988_13420# 0.09528f
C2379 LELO_GR01_0.x7.x29.P uio_out<3> 0.02629f
C2380 a_22050_14644# LELO_GR01_0.x7.x29.P 0.0199f
C2381 LELO_GR01_0.x8.x8.D LELO_GR01_0.x8.x5.XA6.A 1.28877f
C2382 digital_0.output13.A a_3858_n702# 0.20929f
C2383 digital_0.hold28.A a_11007_n524# 0.06789f
C2384 a_8996_1500# digital_0._114_.Q 0.01113f
C2385 LELO_GR01_0.x8.x3.A uio_out<3> 0.0112f
C2386 a_26926_4851# VDPWR 0.29521f
C2387 digital_0._113_.Q a_14026_234# 0.02109f
C2388 a_10546_2422# VDPWR 0.29724f
C2389 digital_0._114_.D a_9150_412# 0.17109f
C2390 a_9985_386# a_9810_412# 0.23366f
C2391 digital_0.output12.A a_8361_n676# 0.18503f
C2392 JNWTR_ORX1_CV_0.XA2.A VDPWR 0.51537f
C2393 digital_0.load_slew15.X digital_0._108_.Q 0.39674f
C2394 LELO_GR01_0.x8.PWRUP_N_1V8 a_20754_14644# 0.0649f
C2395 LELO_GR01_0.x7.x1.x7.D a_12688_14988# 0.07102f
C2396 LELO_GR01_0.x7.x15.I2 a_14358_15810# 0.03213f
C2397 LELO_GR01_0.x7.x21.D a_2478_14480# 0.04927f
C2398 LELO_GR01_0.x7.x1.x5.x8.G a_6936_14010# 0.01247f
C2399 uo_out<4> uo_out<5> 0.04002f
C2400 digital_0.input1.X digital_0._065_.A2_N 0.08836f
C2401 a_7055_2588# a_7970_2588# 0.11669f
C2402 digital_0._116_.Q a_12959_1742# 0.01673f
C2403 digital_0._110_.Q a_11431_2382# 0.1842f
C2404 digital_0._112_.Q a_12225_1500# 0.61031f
C2405 LELO_GR01_0.x7.x29.P a_23334_13064# 0.51417f
C2406 digital_0._114_.Q a_11673_412# 0.05501f
C2407 a_3982_386# a_4118_412# 0.34236f
C2408 a_6889_2588# VDPWR 0.46474f
C2409 a_7157_n158# a_7720_n132# 0.04983f
C2410 a_13605_n126# digital_0._105_.RESET_B 0.32663f
C2411 JNWTR_ORX1_CV_0.A a_23370_18544# 0.10728f
C2412 JNWTR_TIEL_CV_0.MP0.G a_28996_19150# 0.06712f
C2413 a_20412_18698# a_20412_18378# 0.01f
C2414 digital_0._069_.A a_6337_2050# 0.20455f
C2415 LELO_GR01_0.x8.PWRUP_N_1V8 a_21176_11144# 0.04497f
C2416 a_20754_14644# a_21186_14644# 0.14233f
C2417 a_22292_9483# uio_out<3> 0.01157f
C2418 a_20372_9267# uio_out<0> 0.01022f
C2419 LELO_GR01_0.x8.x5.Q VDPWR 0.26125f
C2420 a_11273_3436# VDPWR 0.40323f
C2421 a_14323_962# a_14891_930# 0.18639f
C2422 a_14157_962# a_14673_1334# 0.11535f
C2423 a_4658_3510# clk 0.0141f
C2424 digital_0._112_.Q a_13481_386# 0.13799f
C2425 a_26930_9733# LELO_GR01_0.x8.x5.XA7.CN 0.06207f
C2426 a_12849_1866# VDPWR 0.13324f
C2427 digital_0._057_.D a_12903_206# 0.18216f
C2428 LELO_GR01_0.x8.x1.x5.IBN a_24508_5627# 0.04366f
C2429 a_12116_n132# VDPWR 0.46737f
C2430 a_12138_n702# a_12409_n676# 0.14228f
C2431 digital_0.load_slew15.X a_5834_2740# 0.01145f
C2432 a_3743_3138# a_4201_3132# 0.03462f
C2433 a_14358_16610# VDPWR 0.4118f
C2434 digital_0.output13.A a_3618_n518# 0.01024f
C2435 digital_0.hold28.A a_10066_n524# 0.37603f
C2436 a_8996_1500# a_10253_930# 0.02665f
C2437 digital_0.clkbuf_1_1__f_clk.A a_11388_956# 0.31527f
C2438 digital_0.input3.X digital_0.hold23.X 0.40399f
C2439 digital_0._113_.Q a_12116_n132# 0.02856f
C2440 a_10721_2348# VDPWR 0.41688f
C2441 a_8729_412# a_9150_412# 0.08813f
C2442 a_6337_2050# clk 0.01012f
C2443 JNWTR_IVX1_CV_0.Y uio_out<4> 0.03976f
C2444 digital_0.output12.A a_7214_n524# 0.03686f
C2445 LELO_GR01_0.PWRUP_1V8 VDPWR 12.8306f
C2446 digital_0.load_slew15.X a_6235_3106# 0.11514f
C2447 LELO_GR01_0.x7.x1.x5.x9<2>.G a_6936_14810# 0.0876f
C2448 a_6889_2588# a_7970_2588# 0.10236f
C2449 digital_0.hold28.A digital_0._104_.RESET_B 0.12906f
C2450 a_7623_2830# a_7405_2588# 0.20964f
C2451 a_7055_2588# a_8145_2562# 0.04176f
C2452 a_11988_13420# VDPWR 0.43667f
C2453 digital_0._116_.Q a_12391_1500# 0.46975f
C2454 a_25510_16564# a_25942_16564# 0.21349f
C2455 digital_0.output6.A a_3858_930# 0.2018f
C2456 digital_0._112_.Q digital_0._063_.B 0.19593f
C2457 a_22038_11144# a_22254_11144# 0.01515f
C2458 a_3982_386# digital_0._116_.SET_B 0.2124f
C2459 a_3814_386# a_4118_412# 0.15326f
C2460 digital_0._114_.Q digital_0._057_.D 0.1217f
C2461 digital_0.input1.X VDPWR 4.60837f
C2462 a_20372_9267# a_20156_8709# 0.01519f
C2463 a_14781_956# VDPWR 0.14272f
C2464 a_7157_n158# a_7467_234# 0.01379f
C2465 a_13605_n126# a_14339_n158# 0.06944f
C2466 digital_0._105_.D a_13771_n126# 0.26638f
C2467 a_6962_n16# a_7720_n132# 0.06418f
C2468 JNWTR_TIEL_CV_0.MP0.G a_28156_19150# 0.05973f
C2469 LELO_GR01_0.x7.xd1<4>.A a_14358_16750# 0.07602f
C2470 m1_7720_5850# ui_in<0> 0.03674f
C2471 digital_0._069_.A a_5787_2146# 0.13005f
C2472 digital_0._116_.Q digital_0.output6.A 0.35713f
C2473 LELO_GR01_0.x7.x11.P VDPWR 0.04261f
C2474 digital_0._101_.RESET_B a_4425_2730# 0.01698f
C2475 LELO_GR01_0.x7.x11.P a_21402_16564# 0.19339f
C2476 digital_0.input1.X digital_0._113_.Q 0.06947f
C2477 a_10533_3510# VDPWR 0.20705f
C2478 a_14157_962# a_14891_930# 0.06944f
C2479 digital_0._112_.Q a_12741_412# 0.02968f
C2480 a_4833_3436# clk 0.01885f
C2481 digital_0.output13.A uo_out<1> 0.04832f
C2482 LELO_GR01_0.x8.x5.Q LELO_GR01_0.x8.x5.XA7.MP1.S 0.08106f
C2483 LELO_GR01_0.x8.IBP_BG a_26146_2651# 0.01522f
C2484 a_12646_1500# VDPWR 0.07876f
C2485 digital_0._057_.D a_11758_188# 0.05684f
C2486 LELO_GR01_0.x8.x1.x7.D a_23138_5627# 0.01243f
C2487 a_24508_7487# LELO_GR01_0.x8.x7.D 0.01243f
C2488 LELO_GR01_0.x7.x1.x5.x8.S a_8552_18648# 0.01766f
C2489 LELO_GR01_0.PWRUP_1V8 LELO_GR01_0.x8.PWRUP_N_1V8 1.41069f
C2490 a_11673_n132# VDPWR 0.37311f
C2491 digital_0._067_.A digital_0._067_.B 0.0927f
C2492 digital_0.clkbuf_1_0__f_clk.X digital_0._118_.RESET_B 0.02881f
C2493 a_11996_16042# VDPWR 0.51334f
C2494 LELO_GR01_0.x7.x29.P uio_out<0> 0.10026f
C2495 LELO_GR01_0.x8.x1.x5.x6.N LELO_GR01_0.x8.x1.x5.x9<2>.G 0.836f
C2496 JNWTR_ORX1_CV_0.A a_6098_4904# 0.02142f
C2497 digital_0.hold28.A a_9417_n702# 0.03595f
C2498 a_8996_1500# a_9930_930# 0.01168f
C2499 a_27638_11144# a_27854_11144# 0.01515f
C2500 digital_0._113_.Q a_11673_n132# 0.02112f
C2501 a_9981_2422# VDPWR 0.20688f
C2502 digital_0.load_slew17.X a_15225_n702# 0.04269f
C2503 a_9463_654# a_9810_412# 0.05116f
C2504 a_10196_4904# a_10628_4904# 0.14233f
C2505 digital_0.output12.A a_6793_n676# 0.06985f
C2506 LELO_GR01_0.x8.x1.x5.x6.N uio_out<0> 0.16488f
C2507 a_24210_19344# VDPWR 0.28233f
C2508 LELO_GR01_0.x8.x8.D uo_out<0> 2.06799f
C2509 LELO_GR01_0.x8.PWRUP_N_1V8 LELO_GR01_0.x7.x11.P 0.1707f
C2510 LELO_GR01_0.x8.VREF_BG a_17304_16564# 0.31305f
C2511 LELO_GR01_0.x7.x1.x7.D a_12688_15788# 0.07449f
C2512 uo_out<3> uo_out<4> 0.04002f
C2513 a_6889_2588# a_8145_2562# 0.04359f
C2514 digital_0.hold28.A digital_0.load_slew17.X 0.38972f
C2515 a_7055_2588# a_7405_2588# 0.21686f
C2516 digital_0._116_.Q digital_0._113_.D 0.02084f
C2517 digital_0.load_slew17.X digital_0.input2.X 1.43539f
C2518 digital_0._112_.Q a_11397_1750# 0.07183f
C2519 digital_0._114_.Q a_10997_386# 0.03347f
C2520 a_7001_110# a_7720_n132# 0.08638f
C2521 a_13605_n126# a_13771_n126# 0.88354f
C2522 LELO_GR01_0.x8.VREF_BG a_17668_17950# 0.0186f
C2523 LELO_GR01_0.x7.xd1<4>.A LELO_GR01_0.x7.x15.I2 4.45319f
C2524 digital_0._069_.A digital_0.output6.A 0.05638f
C2525 digital_0._110_.Q digital_0.input1.X 0.46751f
C2526 LELO_GR01_0.x8.PWRUP_N_1V8 a_20744_11144# 0.03895f
C2527 LELO_GR01_0.x8.PWRUP_N_1V8 a_24510_4435# 0.07045f
C2528 a_10082_11154# a_10514_11154# 0.21349f
C2529 digital_0._112_.Q digital_0._112_.RESET_B 0.1416f
C2530 a_10751_3106# VDPWR 0.21233f
C2531 a_6407_1188# digital_0.hold28.X 0.13591f
C2532 a_14157_962# a_14323_962# 0.88854f
C2533 a_4093_3510# clk 0.01281f
C2534 LELO_GR01_0.x8.IBP_BG a_26146_3451# 0.03772f
C2535 LELO_GR01_0.x8.x5.Q LELO_GR01_0.x8.x5.XA7.CN 0.2542f
C2536 a_26090_9733# LELO_GR01_0.x8.x5.XA7.C 0.06698f
C2537 digital_0.input3.X VDPWR 0.7124f
C2538 LELO_GR01_0.x8.x1.x7.D a_23138_6427# 0.03742f
C2539 LELO_GR01_0.x8.x1.x5.x9<2>.G a_19356_5459# 0.03436f
C2540 a_4578_18940# LELO_GR01_0.x7.x6<3>.G 0.04269f
C2541 a_11898_n518# a_12138_n702# 0.11296f
C2542 digital_0.clkbuf_1_0__f_clk.X digital_0._101_.RESET_B 0.03102f
C2543 a_4093_3510# a_4189_3510# 0.01379f
C2544 a_14358_16750# VDPWR 0.41178f
C2545 LELO_GR01_0.x8.PWRUP_N_1V8 a_7536_12960# 0.0713f
C2546 LELO_GR01_0.x7.x10.P a_16440_16564# 0.4588f
C2547 digital_0.hold28.A digital_0._115_.Q 0.67138f
C2548 digital_0.input1.X a_6758_2410# 0.01933f
C2549 a_2478_11860# LELO_GR01_0.x7.x24.D 0.04279f
C2550 LELO_GR01_0.x8.x1.x5.x6.N a_20156_8709# 0.43217f
C2551 digital_0.output6.A a_6209_386# 0.29721f
C2552 digital_0.hold28.A a_9151_n702# 0.07162f
C2553 digital_0.input2.X digital_0._115_.Q 0.05497f
C2554 a_8996_1500# a_9690_1194# 0.01771f
C2555 LELO_GR01_0.x7.x15.I1 a_8684_6824# 0.01064f
C2556 a_10199_2018# VDPWR 0.21445f
C2557 digital_0.load_slew17.X a_14967_n702# 0.07019f
C2558 a_8895_412# a_9810_412# 0.12532f
C2559 digital_0.output12.A a_6687_n676# 0.10114f
C2560 LELO_GR01_0.x8.x1.x5.x8.S uio_out<0> 0.05793f
C2561 digital_0._100_.RESET_B digital_0._117_.RESET_B 0.0533f
C2562 digital_0.output4.A digital_0.output13.A 0.98451f
C2563 digital_0.load_slew15.X a_4833_3436# 0.02484f
C2564 LELO_GR01_0.x7.x1.x7.D a_11318_14986# 0.10629f
C2565 LELO_GR01_0.x8.PWRUP_N_1V8 a_20538_14644# 0.05456f
C2566 a_6889_2588# a_7405_2588# 0.1152f
C2567 a_7055_2588# a_7623_2830# 0.18122f
C2568 digital_0._116_.Q a_12225_1500# 0.03354f
C2569 a_25294_14644# a_25726_14644# 0.14233f
C2570 LELO_GR01_0.x7.x7.G a_11162_9234# 0.08158f
C2571 digital_0.output13.A digital_0._119_.RESET_B 0.02817f
C2572 a_9332_4904# uio_out<0> 0.0326f
C2573 a_9980_6824# VDPWR 0.0324f
C2574 a_9764_4904# rst_n 0.01842f
C2575 a_4111_1474# a_4369_1474# 0.22264f
C2576 a_3814_386# a_3982_386# 0.10799f
C2577 digital_0._100_.D clk 0.01981f
C2578 digital_0._107_.RESET_B a_7720_n132# 0.01778f
C2579 a_13605_n126# digital_0._105_.D 0.16659f
C2580 a_26926_4851# a_26926_4531# 0.01f
C2581 JNWTR_TIEL_CV_0.Y JNWTR_TIEL_CV_0.MP0.G 0.05437f
C2582 LELO_GR01_0.x7.x6<3>.G a_4578_15320# 0.08841f
C2583 LELO_GR01_0.x7.xd1<4>.A LELO_GR01_0.x7.x1.x7.D 0.3639f
C2584 digital_0.hold21.X uio_out<6> 0.02807f
C2585 a_23824_9183# VDPWR 0.43853f
C2586 a_6853_2422# a_6961_2044# 0.05722f
C2587 LELO_GR01_0.x8.PWRUP_N_1V8 a_24510_5235# 0.07874f
C2588 digital_0._112_.Q a_12959_654# 0.01855f
C2589 a_4311_3106# clk 0.01157f
C2590 a_5486_1334# digital_0.hold28.X 0.01419f
C2591 digital_0._115_.RESET_B a_7786_412# 0.2207f
C2592 digital_0.clkload0.A ui_in<0> 0.07979f
C2593 a_10183_3138# VDPWR 0.57678f
C2594 LELO_GR01_0.x8.IBP_BG a_17850_2665# 0.01485f
C2595 LELO_GR01_0.x8.x5.Q LELO_GR01_0.x8.x5.XA7.C 0.15827f
C2596 digital_0._057_.D a_10721_172# 0.0192f
C2597 a_15634_1474# VDPWR 0.30125f
C2598 LELO_GR01_0.x8.x1.x5.IBN a_24508_6427# 0.04312f
C2599 LELO_GR01_0.x7.x1.x5.x8.S a_6636_17810# 0.04689f
C2600 a_7214_n524# digital_0.hold26.X 0.11101f
C2601 a_4093_3510# a_3998_3498# 0.04983f
C2602 LELO_GR01_0.x7.x15.I2 VDPWR 9.63687f
C2603 digital_0._109_.RESET_B a_7349_3132# 0.0171f
C2604 digital_0.clkload0.A digital_0._102_.D 0.10539f
C2605 LELO_GR01_0.x8.PWRUP_N_1V8 a_7536_13760# 0.06872f
C2606 LELO_GR01_0.x7.x6<3>.G a_4578_12470# 0.17387f
C2607 LELO_GR01_0.x7.xd1<4>.A a_14358_13930# 0.07778f
C2608 digital_0.hold28.A digital_0._060_.A_N 0.319f
C2609 digital_0.clkbuf_1_0__f_clk.X a_4571_962# 0.01387f
C2610 a_21618_14644# LELO_GR01_0.x7.x29.P 0.0199f
C2611 digital_0.hold28.A a_8689_n676# 0.05519f
C2612 digital_0._104_.RESET_B a_15238_1334# 0.24255f
C2613 digital_0.input2.X digital_0._060_.A_N 0.15931f
C2614 a_8996_1500# a_9564_930# 0.01256f
C2615 LELO_GR01_0.x7.x26.P a_28070_13064# 0.22899f
C2616 a_9631_2050# VDPWR 0.58345f
C2617 digital_0.load_slew17.X a_14871_n524# 0.06502f
C2618 a_8895_412# a_9985_386# 0.04251f
C2619 a_9463_654# a_9245_412# 0.20964f
C2620 digital_0.output12.A a_6451_n676# 0.32309f
C2621 digital_0._112_.RESET_B uio_out<5> 0.01169f
C2622 digital_0.hold25.X digital_0._117_.RESET_B 0.03177f
C2623 a_28996_19470# VDPWR 0.28679f
C2624 digital_0._116_.Q digital_0.hold19.X 0.16979f
C2625 LELO_GR01_0.x7.x1.x7.D a_11318_15786# 0.098f
C2626 LELO_GR01_0.x7.x1.x5.x8.G a_6936_14810# 0.0438f
C2627 LELO_GR01_0.x8.PWRUP_N_1V8 a_19680_14644# 0.03243f
C2628 uo_out<2> uo_out<3> 0.04002f
C2629 a_6889_2588# a_7623_2830# 0.07009f
C2630 digital_0._116_.Q digital_0._063_.B 0.03106f
C2631 LELO_GR01_0.x8.x8.D a_26930_9093# 0.30152f
C2632 LELO_GR01_0.x8.PWRUP_N_1V8 a_23824_9183# 0.07045f
C2633 digital_0.load_slew17.X a_8996_1500# 0.04199f
C2634 LELO_GR01_0.x7.x29.P a_22902_13064# 0.04653f
C2635 a_21176_11144# a_22038_11144# 0.04861f
C2636 a_6263_2562# VDPWR 0.23953f
C2637 digital_0._114_.Q a_9985_386# 0.12191f
C2638 digital_0._107_.D digital_0.output12.A 0.13431f
C2639 LELO_GR01_0.x8.PWRUP_N_1V8 LELO_GR01_0.x7.x15.I2 0.3419f
C2640 digital_0.hold21.X uio_out<5> 0.11745f
C2641 digital_0.load_slew15.X digital_0.output6.A 0.03649f
C2642 digital_0.hold28.A digital_0._110_.RESET_B 0.01111f
C2643 digital_0._108_.Q a_7310_2588# 0.03535f
C2644 digital_0._067_.B digital_0.input1.X 0.06946f
C2645 digital_0.clkload0.A digital_0._065_.A2_N 0.47362f
C2646 a_10017_3138# a_10074_2562# 0.01118f
C2647 LELO_GR01_0.x8.PWRUP_N_1V8 a_20528_11144# 0.0267f
C2648 LELO_GR01_0.x7.x15.I2 a_14358_12620# 0.03223f
C2649 a_23824_9983# VDPWR 0.41304f
C2650 a_7071_2018# a_6961_2044# 0.09774f
C2651 LELO_GR01_0.x8.PWRUP_N_1V8 a_19356_4659# 0.07971f
C2652 a_9866_9234# a_10298_9234# 0.14233f
C2653 digital_0._112_.Q a_12391_412# 0.54816f
C2654 a_3743_3138# clk 0.04445f
C2655 a_5661_1260# digital_0.hold28.X 0.06227f
C2656 digital_0._115_.RESET_B a_7961_386# 0.2717f
C2657 a_10017_3138# VDPWR 0.50189f
C2658 LELO_GR01_0.x8.x5.Q a_26930_9733# 0.01857f
C2659 a_15394_1658# VDPWR 0.2411f
C2660 LELO_GR01_0.x8.x1.x5.IBN a_23138_5627# 0.04924f
C2661 a_6793_n676# digital_0.hold26.X 0.13552f
C2662 a_11772_n702# a_11898_n518# 0.34134f
C2663 digital_0.load_slew15.X digital_0._100_.D 0.02447f
C2664 LELO_GR01_0.x7.x1.x7.D VDPWR 7.31029f
C2665 digital_0.clkload0.A a_13513_3138# 0.24455f
C2666 a_11273_3436# digital_0._067_.A 0.08334f
C2667 a_16008_14644# a_16224_14644# 0.01515f
C2668 digital_0.hold28.A a_7155_930# 0.07444f
C2669 digital_0.clkbuf_1_0__f_clk.X a_4405_962# 0.27099f
C2670 digital_0.clkload0.A digital_0._104_.D 0.01129f
C2671 digital_0.load_slew15.A digital_0._114_.RESET_B 0.46709f
C2672 LELO_GR01_0.x8.x1.x5.x6.N LELO_GR01_0.x8.x1.x5.x8.G 2.32381f
C2673 LELO_GR01_0.x8.x1.x5.x8.S a_18456_7909# 0.3991f
C2674 digital_0.hold28.A a_8578_n676# 0.05586f
C2675 digital_0._104_.RESET_B a_15413_1260# 0.27961f
C2676 digital_0.input2.X a_7155_930# 0.02385f
C2677 a_26928_5351# VDPWR 0.30455f
C2678 a_14298_1652# digital_0.hold23.X 0.0633f
C2679 a_26782_11144# a_27638_11144# 0.04898f
C2680 digital_0._113_.Q a_12116_188# 0.1402f
C2681 a_9465_2050# VDPWR 0.4769f
C2682 a_8895_412# a_9245_412# 0.21986f
C2683 a_8729_412# a_9810_412# 0.10236f
C2684 digital_0.output12.A a_5974_n676# 0.0263f
C2685 digital_0.output11.A digital_0.output10.A 0.16386f
C2686 a_12849_778# VDPWR 0.13239f
C2687 digital_0.hold25.X digital_0._100_.RESET_B 0.20198f
C2688 a_28156_19470# VDPWR 0.01736f
C2689 a_12829_3676# digital_0.hold28.A 0.01518f
C2690 a_5215_3676# a_4833_3436# 0.01164f
C2691 digital_0.load_slew17.A digital_0.hold24.X 0.22808f
C2692 digital_0._101_.RESET_B a_4934_2422# 0.24076f
C2693 digital_0._067_.A a_10721_2348# 0.01082f
C2694 a_14358_13930# VDPWR 0.43333f
C2695 digital_0._116_.Q a_11397_1750# 0.11782f
C2696 digital_0._069_.A digital_0._063_.B 0.07845f
C2697 a_6889_2588# a_7055_2588# 0.85951f
C2698 LELO_GR01_0.x8.PWRUP_N_1V8 a_23824_9983# 0.0783f
C2699 a_4015_1652# a_4111_1474# 0.41909f
C2700 digital_0.hold28.A digital_0._106_.D 0.03543f
C2701 digital_0.output13.A a_4005_n158# 0.01555f
C2702 digital_0.load_slew17.X a_14121_246# 0.04828f
C2703 a_4581_2825# clk 0.01275f
C2704 digital_0._060_.A_N a_9150_412# 0.01017f
C2705 a_5450_6824# a_5882_6824# 0.21349f
C2706 a_13513_956# VDPWR 0.42753f
C2707 a_26086_4851# a_26086_4531# 0.01f
C2708 LELO_GR01_0.x8.PWRUP_N_1V8 LELO_GR01_0.x7.x1.x7.D 0.61217f
C2709 digital_0.clkload0.A a_10074_2562# 0.02183f
C2710 LELO_GR01_0.x7.x15.I2 a_14358_13420# 0.04814f
C2711 LELO_GR01_0.x7.x11.P a_20970_16564# 0.42758f
C2712 a_20372_9267# VDPWR 0.17609f
C2713 a_20372_10347# uio_out<2> 0.01019f
C2714 digital_0._116_.Q digital_0._112_.RESET_B 0.16563f
C2715 a_6503_2050# a_6961_2044# 0.03462f
C2716 digital_0._118_.RESET_B digital_0.hold28.X 0.01443f
C2717 digital_0.output13.A ui_in<0> 0.03984f
C2718 digital_0._112_.Q a_12225_412# 0.03217f
C2719 digital_0.hold19.X clk 0.04668f
C2720 digital_0.load_slew17.X digital_0._057_.D 0.08998f
C2721 digital_0._063_.A a_11673_412# 0.01783f
C2722 digital_0._115_.RESET_B a_7221_412# 0.16061f
C2723 digital_0.hold23.X a_14578_1322# 0.01201f
C2724 digital_0.clkload0.A VDPWR 4.10952f
C2725 a_26930_10053# a_26930_9733# 0.01f
C2726 digital_0._057_.D digital_0._106_.RESET_B 0.1952f
C2727 a_15268_1474# VDPWR 0.22859f
C2728 LELO_GR01_0.x8.x1.x5.IBN a_23138_6427# 0.04626f
C2729 digital_0.output11.A VDPWR 0.695f
C2730 digital_0.output10.A a_15537_n426# 0.01849f
C2731 a_3743_3138# a_3998_3498# 0.06418f
C2732 a_11996_16842# VDPWR 0.47143f
C2733 digital_0.clkload0.A a_12889_3171# 0.06293f
C2734 a_11273_3436# a_11098_3510# 0.23366f
C2735 digital_0.input1.X a_11431_2382# 0.04179f
C2736 digital_0.hold28.A a_6761_930# 0.35896f
C2737 digital_0.clkbuf_1_0__f_clk.X a_3858_930# 0.05881f
C2738 digital_0.clkload0.A digital_0._113_.Q 0.5049f
C2739 digital_0._116_.Q digital_0._114_.RESET_B 0.21966f
C2740 LELO_GR01_0.x8.x1.x5.x8.S LELO_GR01_0.x8.x1.x5.x8.G 3.06086f
C2741 JNWTR_ORX1_CV_0.A a_5666_4904# 0.02142f
C2742 digital_0.hold28.A a_8361_n676# 0.07922f
C2743 digital_0._104_.RESET_B a_14673_1334# 0.15622f
C2744 a_14298_1652# digital_0._104_.D 0.11042f
C2745 digital_0._113_.RESET_B a_15537_n132# 0.15506f
C2746 a_7418_2422# VDPWR 0.30054f
C2747 a_8729_412# a_9985_386# 0.04359f
C2748 a_8895_412# a_9463_654# 0.17589f
C2749 digital_0._107_.D a_7643_n702# 0.02881f
C2750 a_12646_412# VDPWR 0.07765f
C2751 LELO_GR01_0.x8.x8.D VDPWR 1.63375f
C2752 digital_0._116_.Q digital_0.clkbuf_1_0__f_clk.X 0.85211f
C2753 a_12718_3676# digital_0.hold28.A 0.04305f
C2754 digital_0.output8.A digital_0._111_.Q 0.01689f
C2755 LELO_GR01_0.x8.PWRUP_N_1V8 a_19248_14644# 0.02887f
C2756 LELO_GR01_0.x8.VREF_BG a_16872_16564# 0.31305f
C2757 LELO_GR01_0.PWRUP_1V8 a_20754_14644# 0.02697f
C2758 digital_0._110_.D a_12094_2588# 0.16124f
C2759 digital_0._069_.A a_11397_1750# 0.03427f
C2760 digital_0._101_.RESET_B a_5109_2348# 0.33823f
C2761 digital_0.load_slew17.X digital_0.clkbuf_1_1__f_clk.A 0.03332f
C2762 digital_0.load_slew17.X digital_0._105_.RESET_B 0.37488f
C2763 a_4425_2730# clk 0.02654f
C2764 LELO_GR01_0.x7.xd1<4>.A LELO_GR01_0.x7.x1.x5.IBN 0.52888f
C2765 a_15537_n426# VDPWR 0.38628f
C2766 a_10721_2348# a_10546_2422# 0.23366f
C2767 digital_0._118_.RESET_B a_5029_956# 0.0122f
C2768 a_4921_1334# a_5029_956# 0.05722f
C2769 digital_0._063_.A digital_0._057_.D 0.03085f
C2770 digital_0._115_.RESET_B a_7439_654# 0.16793f
C2771 digital_0._104_.D a_14578_1322# 0.15816f
C2772 digital_0.clkbuf_1_0__f_clk.X uio_out<1> 0.23348f
C2773 a_3577_3138# clk 0.03012f
C2774 digital_0._109_.Q VDPWR 2.67904f
C2775 digital_0._112_.Q digital_0.clkload0.X 0.05079f
C2776 a_14298_1652# VDPWR 0.09768f
C2777 LELO_GR01_0.x8.x1.x5.IBN a_21558_5709# 0.01549f
C2778 LELO_GR01_0.x7.x1.x5.x8.S a_6636_18610# 0.03292f
C2779 LELO_GR01_0.x8.x8.D LELO_GR01_0.x8.PWRUP_N_1V8 0.33775f
C2780 LELO_GR01_0.PWRUP_1V8 JNWTR_ORX1_CV_0.XA2.A 0.09329f
C2781 a_10089_n132# VDPWR 0.1421f
C2782 digital_0.hold19.X a_3998_3498# 0.16052f
C2783 digital_0._109_.D a_6906_3132# 0.02492f
C2784 digital_0._103_.D a_10438_3498# 0.18336f
C2785 digital_0.clkload0.A digital_0._110_.Q 0.30798f
C2786 a_16008_14644# LELO_GR01_0.x7.x10.P 0.06314f
C2787 digital_0.input1.X a_10546_2422# 0.07247f
C2788 digital_0.hold28.A a_6503_930# 0.06312f
C2789 digital_0.clkbuf_1_0__f_clk.X a_3618_1194# 0.05232f
C2790 LELO_GR01_0.x7.x29.N uio_out<1> 0.04781f
C2791 a_14358_13930# a_14358_13420# 0.02417f
C2792 LELO_GR01_0.x8.x1.x5.x8.S a_18456_8709# 0.45344f
C2793 digital_0.hold28.A a_7214_n524# 0.31818f
C2794 digital_0._104_.RESET_B a_14891_930# 0.17107f
C2795 digital_0.clkbuf_1_1__f_clk.A digital_0._115_.Q 0.01221f
C2796 digital_0.input2.X a_6503_930# 0.01481f
C2797 LELO_GR01_0.x8.x3.A VDPWR 0.62871f
C2798 LELO_GR01_0.x7.x15.I1 a_8252_6824# 0.01064f
C2799 LELO_GR01_0.x7.x26.P a_27638_11144# 0.0187f
C2800 a_7593_2348# VDPWR 0.4188f
C2801 digital_0.output6.A uo_out<1> 0.01222f
C2802 a_8729_412# a_9245_412# 0.10687f
C2803 digital_0._114_.Q a_12903_206# 0.08777f
C2804 a_15685_386# VDPWR 0.3222f
C2805 digital_0._107_.D digital_0.hold26.X 0.2083f
C2806 LELO_GR01_0.x8.x1.x5.x6.N VDPWR 0.06476f
C2807 LELO_GR01_0.x7.x1.x5.x6.N ui_in<0> 0.14051f
C2808 a_12501_3676# digital_0.hold28.A 0.07923f
C2809 JNWTR_ORX1_CV_0.A LELO_GR01_0.x7.x10.P 0.20804f
C2810 digital_0.input1.X a_6889_2588# 0.257f
C2811 digital_0._101_.RESET_B a_4369_2422# 0.15328f
C2812 LELO_GR01_0.x8.x8.D LELO_GR01_0.x8.x5.XA7.MP1.S 0.28786f
C2813 a_8900_4904# uio_out<0> 0.0326f
C2814 digital_0.load_slew17.X a_6315_1474# 0.02845f
C2815 a_9548_6824# VDPWR 0.02394f
C2816 a_9332_4904# rst_n 0.01842f
C2817 a_20744_11144# a_21176_11144# 0.01515f
C2818 digital_0.input2.X a_8689_n132# 0.09274f
C2819 digital_0.load_slew17.X a_14339_n158# 0.02229f
C2820 a_4386_2856# clk 0.04028f
C2821 digital_0._060_.A_N digital_0._057_.D 0.0102f
C2822 digital_0.hold23.X a_15331_564# 0.13052f
C2823 digital_0._115_.D a_6871_412# 0.2732f
C2824 a_5234_4904# a_5666_4904# 0.14233f
C2825 a_14578_1322# VDPWR 0.08292f
C2826 LELO_GR01_0.x7.xd1<4>.A LELO_GR01_0.x7.x21.D 0.0959f
C2827 a_11273_3436# digital_0.input1.X 0.0102f
C2828 LELO_GR01_0.x8.PWRUP_N_1V8 LELO_GR01_0.x7.x29.P 0.23048f
C2829 a_20538_14644# a_20754_14644# 0.01515f
C2830 a_22292_9483# VDPWR 0.02191f
C2831 LELO_GR01_0.x8.IBP_BG LELO_GR01_0.x8.x7.D 0.01988f
C2832 a_5139_930# a_5029_956# 0.09774f
C2833 digital_0.load_slew17.X a_9810_412# 0.01685f
C2834 digital_0._115_.RESET_B a_6871_412# 0.05004f
C2835 digital_0.clkbuf_1_0__f_clk.X clk 0.08283f
C2836 digital_0.output13.A VDPWR 1.52648f
C2837 a_26930_10053# LELO_GR01_0.x8.x5.Q 0.02725f
C2838 a_26090_10053# a_26090_9733# 0.01f
C2839 a_9985_386# a_9981_246# 0.01024f
C2840 a_13306_1500# VDPWR 0.29974f
C2841 a_24210_19344# JNWTR_ORX1_CV_0.XA2.A 0.05912f
C2842 a_3577_3138# a_3998_3498# 0.09313f
C2843 digital_0.load_slew15.X a_4425_2730# 0.03433f
C2844 LELO_GR01_0.x7.x1.x5.IBN VDPWR 0.52822f
C2845 a_10751_3106# a_11098_3510# 0.05116f
C2846 LELO_GR01_0.x7.x6<3>.G a_4578_13270# 0.1739f
C2847 digital_0.input1.X a_10721_2348# 0.06197f
C2848 digital_0.clkbuf_1_0__f_clk.X a_3492_930# 0.04552f
C2849 a_21186_14644# LELO_GR01_0.x7.x29.P 0.0199f
C2850 digital_0._104_.RESET_B a_14323_962# 0.03186f
C2851 digital_0.clkbuf_1_1__f_clk.A digital_0._060_.A_N 0.01683f
C2852 a_6315_1474# digital_0._115_.Q 0.01213f
C2853 digital_0.input2.X a_6407_1188# 0.01252f
C2854 digital_0._113_.RESET_B a_14727_1474# 0.05845f
C2855 LELO_GR01_0.x7.x26.P a_26782_11144# 0.0187f
C2856 a_6853_2422# VDPWR 0.2019f
C2857 digital_0._114_.D a_8895_412# 0.22225f
C2858 a_8729_412# a_9463_654# 0.05348f
C2859 digital_0._114_.Q a_11758_188# 0.09812f
C2860 a_9980_6824# a_10412_6824# 0.21349f
C2861 a_11673_n132# a_12116_n132# 0.02551f
C2862 a_15427_386# VDPWR 0.28056f
C2863 LELO_GR01_0.x8.x1.x5.x8.S VDPWR 1.35071f
C2864 LELO_GR01_0.x7.x1.x5.x8.S ui_in<0> 0.09842f
C2865 digital_0.output8.A digital_0.hold28.A 0.21345f
C2866 digital_0.output4.A a_4093_3510# 0.02057f
C2867 LELO_GR01_0.PWRUP_1V8 LELO_GR01_0.x7.x11.P 0.12151f
C2868 a_9734_16126# a_9734_15874# 0.05415f
C2869 LELO_GR01_0.x7.x1.x5.IBN a_9734_15074# 0.03188f
C2870 uio_in<6> uio_in<7> 0.03102f
C2871 digital_0._116_.Q digital_0._115_.RESET_B 0.12965f
C2872 digital_0._101_.RESET_B a_4587_2018# 0.16612f
C2873 LELO_GR01_0.x7.x11.N a_25510_16564# 0.25817f
C2874 LELO_GR01_0.x7.x7.G a_10514_11154# 0.33397f
C2875 LELO_GR01_0.x8.PWRUP_N_1V8 a_22292_9483# 0.02242f
C2876 LELO_GR01_0.x8.x8.D LELO_GR01_0.x8.x5.XA7.CN 1.51068f
C2877 digital_0._065_.A2_N a_10555_956# 0.05724f
C2878 LELO_GR01_0.x7.x29.P a_22470_13064# 0.01622f
C2879 a_4108_2840# clk 0.01158f
C2880 digital_0.load_slew17.X a_13771_n126# 0.44761f
C2881 digital_0._060_.A_N a_10997_386# 0.11444f
C2882 digital_0.hold23.X JNWTR_IVX1_CV_0.Y 0.04694f
C2883 digital_0._115_.D a_6705_412# 0.17271f
C2884 JNWTR_IVX1_CV_0.Y a_17228_236# 0.01986f
C2885 digital_0._112_.D VDPWR 0.37175f
C2886 LELO_GR01_0.PWRUP_1V8 a_11996_16042# 0.07044f
C2887 LELO_GR01_0.x8.PWRUP_N_1V8 LELO_GR01_0.x7.x1.x5.IBN 0.37056f
C2888 digital_0._109_.Q a_8145_2562# 0.10309f
C2889 digital_0.output4.A digital_0.output6.A 0.11904f
C2890 LELO_GR01_0.PWRUP_1V8 a_20744_11144# 0.02749f
C2891 a_20372_10347# uio_out<0> 0.01097f
C2892 a_10199_2018# a_10546_2422# 0.05116f
C2893 a_6853_2422# a_6949_2422# 0.01379f
C2894 LELO_GR01_0.x7.x15.I1 LELO_GR01_0.x7.x28.e 0.05397f
C2895 LELO_GR01_0.x8.PWRUP_N_1V8 a_19356_5459# 0.07091f
C2896 a_4571_962# a_5029_956# 0.02761f
C2897 digital_0.load_slew17.X a_9985_386# 0.01558f
C2898 digital_0._113_.Q digital_0._112_.D 0.16698f
C2899 digital_0._115_.RESET_B a_6705_412# 0.32383f
C2900 a_3743_3138# uo_out<1> 0.01728f
C2901 digital_0._108_.Q VDPWR 0.7999f
C2902 a_10253_930# digital_0._114_.Q 0.16072f
C2903 a_26090_10053# LELO_GR01_0.x8.x5.Q 0.01772f
C2904 a_13481_1474# VDPWR 0.41625f
C2905 JNWTR_IVX1_CV_0.Y a_18068_556# 0.01772f
C2906 LELO_GR01_0.x8.x1.x5.x8.S LELO_GR01_0.x8.PWRUP_N_1V8 0.87651f
C2907 a_24210_19344# LELO_GR01_0.PWRUP_1V8 0.02594f
C2908 a_23370_19344# JNWTR_ORX1_CV_0.XA2.A 0.06436f
C2909 digital_0.output12.A uio_out<7> 0.15834f
C2910 a_11103_n702# a_11361_n702# 0.22264f
C2911 digital_0.output10.A a_14175_n702# 0.05543f
C2912 digital_0.load_slew15.X a_4386_2856# 0.01351f
C2913 LELO_GR01_0.x7.x21.D VDPWR 0.47013f
C2914 a_10183_3138# a_11098_3510# 0.12532f
C2915 digital_0._118_.RESET_B digital_0.hold22.X 0.01385f
C2916 digital_0.input1.X a_9981_2422# 0.03365f
C2917 digital_0.load_slew17.X a_14323_962# 0.02513f
C2918 digital_0._104_.RESET_B a_14157_962# 0.30695f
C2919 a_6315_1474# digital_0._060_.A_N 0.02403f
C2920 digital_0.input2.X a_5486_1334# 0.0145f
C2921 digital_0.hold22.X a_4921_1334# 0.02302f
C2922 a_26928_5671# VDPWR 0.27923f
C2923 digital_0._113_.RESET_B digital_0.hold23.X 0.05674f
C2924 a_13481_1474# digital_0._113_.Q 0.09983f
C2925 a_26350_11144# a_26782_11144# 0.01515f
C2926 a_8729_412# a_8895_412# 0.72771f
C2927 a_7071_2018# VDPWR 0.21034f
C2928 digital_0._114_.Q a_10546_246# 0.01523f
C2929 JNWTR_IVX1_CV_0.Y rst_n 0.14539f
C2930 a_15331_564# VDPWR 0.16987f
C2931 LELO_GR01_0.x7.x1.x5.x6.N VDPWR 0.10812f
C2932 digital_0.load_slew15.X digital_0.clkbuf_1_0__f_clk.X 0.19843f
C2933 a_14415_3650# a_14673_3650# 0.22264f
C2934 LELO_GR01_0.x7.x1.x5.x8.S rst_n 0.2005f
C2935 a_12189_3650# digital_0.hold28.A 0.04232f
C2936 a_14358_16750# a_14358_16610# 0.11733f
C2937 LELO_GR01_0.x7.x1.x5.IBN a_9734_15874# 0.03039f
C2938 LELO_GR01_0.PWRUP_1V8 a_20538_14644# 0.04171f
C2939 digital_0._116_.Q a_5785_1750# 0.09599f
C2940 digital_0._101_.RESET_B a_4019_2050# 0.02526f
C2941 LELO_GR01_0.x8.x8.D LELO_GR01_0.x8.x5.XA7.C 2.76753f
C2942 digital_0._116_.Q digital_0.output12.A 0.0318f
C2943 a_20528_11144# a_21176_11144# 0.06667f
C2944 a_3821_2562# clk 0.01558f
C2945 digital_0.load_slew17.X digital_0._105_.D 0.04227f
C2946 digital_0._060_.A_N a_9810_412# 0.04191f
C2947 a_9930_930# a_8895_412# 0.01331f
C2948 a_5834_2740# VDPWR 0.11935f
C2949 digital_0.hold23.X a_14990_386# 0.16949f
C2950 a_4696_n132# a_4910_n132# 0.09774f
C2951 a_10555_956# VDPWR 0.30113f
C2952 LELO_GR01_0.x8.PWRUP_N_1V8 LELO_GR01_0.x7.x21.D 1.01745f
C2953 LELO_GR01_0.x7.xd1<4>.A a_4578_16120# 0.02712f
C2954 a_14175_n702# VDPWR 0.21324f
C2955 a_20538_14644# LELO_GR01_0.x7.x11.P 0.06522f
C2956 digital_0.clkbuf_1_0__f_clk.X a_5855_564# 0.02045f
C2957 a_6853_2422# a_6758_2410# 0.04983f
C2958 a_9631_2050# a_10546_2422# 0.12499f
C2959 digital_0._113_.Q a_10555_956# 0.03678f
C2960 digital_0.hold19.X uo_out<1> 0.3563f
C2961 a_6235_3106# VDPWR 0.20377f
C2962 digital_0._113_.Q a_14175_n702# 0.10119f
C2963 a_12741_1500# VDPWR 0.20453f
C2964 JNWTR_IVX1_CV_0.Y a_17228_556# 0.01884f
C2965 digital_0._113_.RESET_B rst_n 0.01285f
C2966 LELO_GR01_0.x8.x1.x5.IBN a_21558_6509# 0.0318f
C2967 LELO_GR01_0.x7.x1.x5.x6.N LELO_GR01_0.x8.PWRUP_N_1V8 0.01151f
C2968 a_23370_19344# LELO_GR01_0.PWRUP_1V8 0.04104f
C2969 a_5974_n676# a_5785_n426# 0.06801f
C2970 digital_0.output10.A digital_0.hold27.X 0.26256f
C2971 a_10017_3138# a_11098_3510# 0.10236f
C2972 a_2478_15790# VDPWR 0.36633f
C2973 digital_0.hold28.A digital_0._108_.D 0.26157f
C2974 a_10183_3138# a_11273_3436# 0.04251f
C2975 a_10751_3106# a_10533_3510# 0.20964f
C2976 a_12189_2588# a_12285_2588# 0.01379f
C2977 digital_0.input1.X a_10199_2018# 0.04358f
C2978 LELO_GR01_0.x7.x29.N uio_out<2> 0.06001f
C2979 digital_0._116_.Q digital_0.hold28.X 0.43768f
C2980 JNWTR_ORX1_CV_0.A a_5234_4904# 0.02142f
C2981 digital_0.load_slew17.X a_14157_962# 0.02587f
C2982 a_6315_1474# a_7155_930# 0.01392f
C2983 digital_0.input2.X a_5661_1260# 0.01355f
C2984 a_26088_5671# VDPWR 0.01369f
C2985 digital_0._113_.RESET_B digital_0._104_.D 0.14716f
C2986 a_8729_412# digital_0._114_.D 0.21987f
C2987 a_6503_2050# VDPWR 0.52701f
C2988 a_9764_4904# a_10196_4904# 0.14233f
C2989 JNWTR_IVX1_CV_0.Y VDPWR 0.59599f
C2990 LELO_GR01_0.x7.x1.x5.x8.S VDPWR 2.01079f
C2991 a_11835_3828# digital_0.hold20.X 0.13551f
C2992 digital_0.load_slew17.A a_11415_3650# 0.04186f
C2993 a_10986_3828# digital_0._111_.Q 0.19245f
C2994 a_11931_3650# digital_0.hold28.A 0.07125f
C2995 digital_0.output4.A a_3743_3138# 0.03979f
C2996 LELO_GR01_0.x8.IBP_BG LELO_GR01_0.x7.x10.P 2.7181f
C2997 LELO_GR01_0.x8.PWRUP_N_1V8 a_18816_14644# 0.02887f
C2998 LELO_GR01_0.x8.VREF_BG a_16440_16564# 0.12517f
C2999 LELO_GR01_0.x7.x15.I2 a_14358_16610# 0.03213f
C3000 LELO_GR01_0.PWRUP_1V8 a_19680_14644# 0.03984f
C3001 uio_in<5> uio_in<6> 0.03102f
C3002 digital_0.hold28.A a_14762_2018# 0.01966f
C3003 a_25078_14644# a_25294_14644# 0.01515f
C3004 LELO_GR01_0.x8.x8.D a_26930_9733# 0.31369f
C3005 digital_0.hold28.A digital_0._107_.D 0.33909f
C3006 digital_0.load_slew17.X a_13605_n126# 0.07514f
C3007 digital_0._060_.A_N a_9985_386# 0.0923f
C3008 a_5144_2954# VDPWR 0.0873f
C3009 digital_0.hold23.X a_14750_570# 0.02874f
C3010 a_4765_n158# a_4910_n132# 0.05722f
C3011 a_9005_956# VDPWR 0.37849f
C3012 a_26928_5351# a_26926_4851# 0.02044f
C3013 LELO_GR01_0.x8.PWRUP_N_1V8 a_2478_15790# 0.08228f
C3014 LELO_GR01_0.x7.x18.D a_4578_16120# 0.07864f
C3015 LELO_GR01_0.PWRUP_1V8 LELO_GR01_0.x7.x15.I2 0.23085f
C3016 a_7643_n702# uio_out<7> 0.02375f
C3017 digital_0.hold27.X VDPWR 0.27305f
C3018 LELO_GR01_0.PWRUP_1V8 a_20528_11144# 0.04388f
C3019 LELO_GR01_0.x7.x10.P a_24210_14644# 0.01276f
C3020 a_20372_9699# VDPWR 0.1669f
C3021 digital_0.clkbuf_1_0__f_clk.X a_5218_778# 0.01624f
C3022 a_9631_2050# a_10721_2348# 0.04206f
C3023 a_9465_2050# a_10546_2422# 0.10236f
C3024 a_10199_2018# a_9981_2422# 0.20964f
C3025 digital_0.hold28.A a_7786_412# 0.0176f
C3026 LELO_GR01_0.x7.x11.N LELO_GR01_0.x7.x26.P 0.04394f
C3027 a_9650_11154# a_10082_11154# 0.21349f
C3028 LELO_GR01_0.x8.VREF_BG LELO_GR01_0.x8.x7.D 0.39898f
C3029 a_3577_3138# uo_out<1> 0.04554f
C3030 digital_0.hold24.X uio_out<2> 0.06138f
C3031 a_5486_1334# digital_0._080_.A2 0.04226f
C3032 a_4658_3510# VDPWR 0.29919f
C3033 a_4921_1334# a_5017_1334# 0.01379f
C3034 a_9985_386# a_9631_n126# 0.01571f
C3035 digital_0._113_.Q digital_0.hold27.X 0.29726f
C3036 digital_0._113_.RESET_B VDPWR 0.51311f
C3037 digital_0._114_.Q a_10066_n524# 0.19386f
C3038 LELO_GR01_0.x7.x1.x5.x8.S LELO_GR01_0.x8.PWRUP_N_1V8 0.6865f
C3039 a_7302_n132# VDPWR 0.1421f
C3040 digital_0.hold18.X a_5785_n426# 0.02809f
C3041 a_11007_n524# a_11103_n702# 0.41909f
C3042 a_10017_3138# a_11273_3436# 0.04348f
C3043 digital_0.hold28.A digital_0._118_.RESET_B 0.0236f
C3044 a_10183_3138# a_10533_3510# 0.2298f
C3045 digital_0.input1.X a_9631_2050# 0.5984f
C3046 digital_0._118_.RESET_B digital_0.input2.X 0.03142f
C3047 LELO_GR01_0.x7.x29.N uio_out<3> 0.01324f
C3048 a_18156_11144# VDPWR 0.01799f
C3049 a_6315_1474# a_6761_930# 0.02203f
C3050 digital_0.input2.X a_4921_1334# 0.01082f
C3051 digital_0.hold22.X a_4571_962# 0.03825f
C3052 digital_0._113_.RESET_B digital_0._113_.Q 0.06051f
C3053 LELO_GR01_0.x7.x15.I1 a_7820_6824# 0.01064f
C3054 a_6337_2050# VDPWR 0.49299f
C3055 digital_0.output6.A ui_in<0> 0.05109f
C3056 digital_0._114_.Q a_9981_246# 0.01244f
C3057 a_10721_172# a_11103_n702# 0.01537f
C3058 a_14990_386# VDPWR 0.23307f
C3059 a_14319_3828# a_14415_3650# 0.41909f
C3060 digital_0.output7.A a_14673_3650# 0.33721f
C3061 a_10986_3828# digital_0.hold20.X 0.0578f
C3062 digital_0.load_slew17.A digital_0._111_.Q 0.0457f
C3063 a_11835_3828# digital_0.hold28.A 0.06142f
C3064 digital_0.output4.A digital_0.hold19.X 0.13728f
C3065 digital_0.load_slew15.X digital_0._115_.RESET_B 0.01898f
C3066 a_6263_2562# digital_0.input1.X 0.0576f
C3067 digital_0._101_.RESET_B a_3853_2050# 0.29551f
C3068 LELO_GR01_0.x8.PWRUP_N_1V8 a_20372_9699# 0.01391f
C3069 a_8468_4904# uio_out<0> 0.0326f
C3070 a_12517_2044# a_12977_2044# 0.04637f
C3071 a_9116_6824# VDPWR 0.01994f
C3072 a_8900_4904# rst_n 0.01842f
C3073 a_20528_11144# a_20744_11144# 0.01515f
C3074 digital_0.load_slew17.X a_12903_206# 0.02868f
C3075 digital_0._060_.A_N a_9245_412# 0.04713f
C3076 a_4726_2954# VDPWR 0.14415f
C3077 digital_0.hold23.X a_14624_386# 0.02107f
C3078 a_4570_n16# a_4910_n132# 0.03462f
C3079 a_10721_172# a_10546_246# 0.23366f
C3080 a_6397_n158# digital_0.output12.A 0.12593f
C3081 LELO_GR01_0.x8.IBP_BG JNWTR_ORX1_CV_0.A 0.85344f
C3082 LELO_GR01_0.PWRUP_1V8 LELO_GR01_0.x7.x1.x7.D 0.33964f
C3083 a_6636_17810# a_6636_17010# 0.0149f
C3084 digital_0._108_.Q a_7405_2588# 0.01667f
C3085 LELO_GR01_0.PWRUP_1V8 a_19666_11144# 0.01763f
C3086 a_19680_14644# a_20538_14644# 0.04885f
C3087 a_6503_2050# a_6758_2410# 0.06121f
C3088 a_9465_2050# a_10721_2348# 0.04358f
C3089 a_9631_2050# a_9981_2422# 0.21963f
C3090 digital_0.clkbuf_1_0__f_clk.X uo_out<1> 0.99683f
C3091 digital_0.hold24.X uio_out<3> 0.04052f
C3092 a_4921_1334# a_4826_1322# 0.04983f
C3093 a_4833_3436# VDPWR 0.41403f
C3094 a_12959_1742# VDPWR 0.21177f
C3095 LELO_GR01_0.x8.x1.x5.x9<2>.G a_21558_5709# 0.07064f
C3096 LELO_GR01_0.x7.x20.D clk 0.08208f
C3097 a_10017_3138# a_10533_3510# 0.11053f
C3098 a_9734_16926# VDPWR 0.04466f
C3099 digital_0.hold28.A digital_0._101_.RESET_B 0.07022f
C3100 a_10183_3138# a_10751_3106# 0.18639f
C3101 LELO_GR01_0.x7.x1.x5.x9<2>.G ui_in<0> 0.16193f
C3102 JNWTR_ORX1_CV_0.A a_24210_14644# 0.0178f
C3103 digital_0.input1.X a_9465_2050# 0.85093f
C3104 a_20754_14644# LELO_GR01_0.x7.x29.P 0.01898f
C3105 digital_0.load_slew17.X digital_0._114_.Q 0.33859f
C3106 digital_0._063_.A a_11388_956# 0.15277f
C3107 a_6315_1474# a_6503_930# 0.02551f
C3108 digital_0.input2.X a_5139_930# 0.01388f
C3109 digital_0.hold22.X a_4405_962# 0.03637f
C3110 a_26930_6213# VDPWR 0.01174f
C3111 LELO_GR01_0.x8.x5.CK uio_out<5> 0.01543f
C3112 a_12741_1500# a_12837_1500# 0.01379f
C3113 a_15634_1474# digital_0.input3.X 0.21856f
C3114 a_5787_2146# VDPWR 0.30415f
C3115 digital_0._114_.Q digital_0._106_.RESET_B 0.02897f
C3116 a_14750_570# VDPWR 0.21886f
C3117 digital_0.output7.A a_14415_3650# 0.09919f
C3118 digital_0.output4.A a_3577_3138# 0.04107f
C3119 a_10986_3828# digital_0.hold28.A 0.31844f
C3120 digital_0.load_slew17.A digital_0.hold20.X 0.30012f
C3121 LELO_GR01_0.x7.x15.I2 a_14358_16750# 0.03211f
C3122 LELO_GR01_0.x7.x1.x7.D a_11996_16042# 0.04055f
C3123 LELO_GR01_0.x7.x21.D a_2478_14990# 0.07916f
C3124 uio_in<4> uio_in<5> 0.03102f
C3125 digital_0._116_.Q a_5159_1474# 0.04967f
C3126 digital_0.hold28.A digital_0._112_.Q 0.12694f
C3127 a_25078_14644# LELO_GR01_0.x7.x11.N 0.21168f
C3128 LELO_GR01_0.x8.x8.D LELO_GR01_0.x8.x5.Q 0.83185f
C3129 LELO_GR01_0.x8.PWRUP_N_1V8 a_22292_9915# 0.09379f
C3130 LELO_GR01_0.PWRUP_1V8 a_20372_9267# 0.04072f
C3131 LELO_GR01_0.x7.x7.G a_10082_11154# 0.05129f
C3132 digital_0.clkbuf_1_0__f_clk.X a_4609_110# 0.26295f
C3133 LELO_GR01_0.x7.x29.P a_21176_11144# 0.01231f
C3134 digital_0.load_slew17.X a_11758_188# 0.10776f
C3135 digital_0._060_.A_N a_9463_654# 0.02268f
C3136 digital_0._106_.RESET_B a_11758_188# 0.01207f
C3137 digital_0._112_.RESET_B a_15537_n132# 0.01612f
C3138 a_26088_5351# a_26086_4851# 0.02044f
C3139 LELO_GR01_0.x8.x3.A a_26926_4851# 0.02226f
C3140 LELO_GR01_0.PWRUP_1V8 a_11996_16842# 0.07815f
C3141 a_4578_17200# a_4578_17060# 0.11733f
C3142 digital_0.clkload0.A digital_0.input1.X 0.16048f
C3143 digital_0.load_slew15.X a_5109_2348# 0.02273f
C3144 digital_0.output13.A a_7055_2588# 0.01416f
C3145 digital_0._118_.RESET_B digital_0._080_.A2 0.0312f
C3146 digital_0.output13.A a_3814_386# 0.02643f
C3147 a_9465_2050# a_9981_2422# 0.11067f
C3148 a_6337_2050# a_6758_2410# 0.08657f
C3149 a_9631_2050# a_10199_2018# 0.17589f
C3150 a_9434_9234# a_9866_9234# 0.14233f
C3151 digital_0.hold28.A uio_out<6> 1.10116f
C3152 a_4921_1334# digital_0._080_.A2 0.02998f
C3153 a_4093_3510# VDPWR 0.20326f
C3154 a_9690_1194# a_9930_930# 0.11296f
C3155 a_12391_1500# VDPWR 0.31755f
C3156 a_9886_234# VDPWR 0.08243f
C3157 a_10017_3138# a_10751_3106# 0.07009f
C3158 LELO_GR01_0.x7.x1.x5.x9<2>.G rst_n 0.0462f
C3159 a_12189_2588# a_12297_2954# 0.05722f
C3160 a_6889_2588# a_7593_2348# 0.0117f
C3161 digital_0.input1.X a_7418_2422# 0.0583f
C3162 LELO_GR01_0.x7.x29.N uio_out<0> 0.07198f
C3163 a_17724_11144# VDPWR 0.02531f
C3164 digital_0.load_slew15.X digital_0.hold28.X 0.10298f
C3165 digital_0.load_slew17.X a_10253_930# 0.03163f
C3166 digital_0._063_.A digital_0._114_.Q 0.33693f
C3167 digital_0._116_.Q a_5868_n676# 0.0126f
C3168 digital_0.output9.A a_15413_1260# 0.1187f
C3169 a_6315_1474# a_6407_1188# 0.01183f
C3170 digital_0.input2.X a_4571_962# 0.05857f
C3171 a_26090_6213# VDPWR 0.01106f
C3172 digital_0.output6.A VDPWR 2.29583f
C3173 digital_0._114_.Q a_10199_n158# 0.01652f
C3174 digital_0.output11.A a_11673_n132# 0.01364f
C3175 a_14624_386# VDPWR 0.2165f
C3176 digital_0.output7.A a_14319_3828# 0.08742f
C3177 digital_0.output4.A digital_0.clkbuf_1_0__f_clk.X 0.11998f
C3178 digital_0.load_slew17.A digital_0.hold28.A 0.74228f
C3179 a_10986_3828# digital_0._103_.D 0.08235f
C3180 LELO_GR01_0.x8.VREF_BG LELO_GR01_0.x7.x10.P 1.44036f
C3181 digital_0._116_.Q digital_0.hold22.X 0.02396f
C3182 digital_0.clkload0.A a_9981_2422# 0.01894f
C3183 LELO_GR01_0.x8.x8.D a_26930_10053# 0.27617f
C3184 LELO_GR01_0.x7.x11.P a_28750_14644# 0.01898f
C3185 a_8684_6824# ui_in<0> 0.01113f
C3186 digital_0.hold28.A a_6962_n16# 0.02877f
C3187 digital_0._063_.A a_11758_188# 0.19905f
C3188 digital_0.load_slew17.X a_10546_246# 0.05733f
C3189 digital_0._060_.A_N a_8895_412# 0.05119f
C3190 digital_0._100_.D VDPWR 0.4864f
C3191 digital_0.hold28.X a_5855_564# 0.02464f
C3192 a_5018_6824# a_5450_6824# 0.21349f
C3193 a_18456_9509# a_18456_8709# 0.0149f
C3194 digital_0._119_.RESET_B a_4910_n132# 0.0122f
C3195 digital_0._114_.D a_9151_n702# 0.11686f
C3196 digital_0._106_.RESET_B a_10546_246# 0.23197f
C3197 LELO_GR01_0.x8.x3.A a_26086_4851# 0.02945f
C3198 LELO_GR01_0.x7.x1.x5.x6.N a_7886_15860# 0.03679f
C3199 digital_0._116_.Q digital_0._101_.D 0.03774f
C3200 digital_0.output13.A a_6889_2588# 0.03125f
C3201 digital_0._108_.Q a_7055_2588# 0.05336f
C3202 LELO_GR01_0.PWRUP_1V8 LELO_GR01_0.x7.x29.P 0.15208f
C3203 a_20372_10347# VDPWR 0.01519f
C3204 a_9465_2050# a_10199_2018# 0.05348f
C3205 digital_0.hold28.A uio_out<5> 0.12857f
C3206 digital_0._060_.A_N digital_0._114_.Q 0.41411f
C3207 a_5139_930# digital_0._080_.A2 0.0192f
C3208 a_4571_962# a_4826_1322# 0.05936f
C3209 a_4311_3106# VDPWR 0.20609f
C3210 digital_0.load_slew17.X a_8729_412# 0.01028f
C3211 digital_0._113_.D VDPWR 0.34082f
C3212 digital_0._080_.A2 digital_0.hold18.X 0.03079f
C3213 LELO_GR01_0.x8.x5.XA5.A LELO_GR01_0.x8.x5.XA3.MP1.S 0.04373f
C3214 LELO_GR01_0.x8.x1.x5.x6.N LELO_GR01_0.PWRUP_1V8 0.23206f
C3215 digital_0.output4.A a_4108_2840# 0.01871f
C3216 a_10017_3138# a_10183_3138# 0.90596f
C3217 LELO_GR01_0.x7.x1.x5.x9<2>.G VDPWR 0.0998f
C3218 LELO_GR01_0.x8.VREF_BG a_25294_14644# 0.01024f
C3219 JNWTR_ORX1_CV_0.A a_23778_14644# 0.02493f
C3220 digital_0._110_.RESET_B a_12297_2954# 0.0122f
C3221 a_12189_2588# a_12094_2588# 0.04983f
C3222 digital_0.input1.X a_7593_2348# 0.06177f
C3223 JNWTR_ORX1_CV_0.A a_4802_4904# 0.02142f
C3224 digital_0._118_.D a_4571_962# 0.22412f
C3225 digital_0.load_slew17.X a_9930_930# 0.22317f
C3226 digital_0._116_.Q a_5785_n426# 0.05027f
C3227 digital_0.input2.X a_4405_962# 0.05903f
C3228 a_24508_6427# VDPWR 0.04298f
C3229 digital_0._113_.D digital_0._113_.Q 0.13305f
C3230 a_15394_1658# a_15634_1474# 0.11296f
C3231 a_26134_13064# LELO_GR01_0.x7.x26.P 0.22964f
C3232 digital_0._114_.Q a_9631_n126# 0.03081f
C3233 a_4477_2044# VDPWR 0.13355f
C3234 a_13306_412# VDPWR 0.27608f
C3235 digital_0._069_.A digital_0._111_.Q 0.5148f
C3236 digital_0.load_slew17.A digital_0._103_.D 0.05237f
C3237 digital_0.output5.A a_3743_3138# 0.02964f
C3238 LELO_GR01_0.x8.PWRUP_N_1V8 a_18384_14644# 0.02887f
C3239 LELO_GR01_0.x7.x1.x5.x9<2>.G a_9734_15074# 0.07821f
C3240 LELO_GR01_0.x7.x1.x7.D LELO_GR01_0.x7.x15.I2 0.05291f
C3241 uio_in<3> uio_in<4> 0.03102f
C3242 digital_0._110_.D a_11839_2588# 0.28168f
C3243 a_24210_14644# a_25078_14644# 0.04824f
C3244 LELO_GR01_0.x8.x8.D a_26090_10053# 0.01564f
C3245 LELO_GR01_0.x8.PWRUP_N_1V8 a_20372_10347# 0.07092f
C3246 digital_0.hold28.A a_7001_110# 0.03327f
C3247 digital_0.load_slew15.X a_5328_n132# 0.01888f
C3248 a_19666_11144# a_20528_11144# 0.04861f
C3249 digital_0._060_.A_N digital_0._114_.D 0.2278f
C3250 digital_0.load_slew17.X a_10721_172# 0.07847f
C3251 a_4512_2954# VDPWR 0.21031f
C3252 digital_0._060_.B VDPWR 0.8894f
C3253 a_10199_n158# a_10546_246# 0.05116f
C3254 digital_0._106_.RESET_B a_10721_172# 0.33297f
C3255 LELO_GR01_0.x8.PWRUP_N_1V8 LELO_GR01_0.x7.x1.x5.x9<2>.G 1.24064f
C3256 LELO_GR01_0.x7.x6<3>.G a_4578_16120# 0.06124f
C3257 LELO_GR01_0.x8.VREF_BG JNWTR_ORX1_CV_0.A 0.8638f
C3258 digital_0._108_.Q a_6889_2588# 0.20914f
C3259 digital_0.output13.A digital_0.input1.X 0.1634f
C3260 a_6906_3132# a_7349_3132# 0.03064f
C3261 LELO_GR01_0.x7.x15.I2 a_14358_13930# 0.04821f
C3262 a_19248_14644# a_19680_14644# 0.01515f
C3263 a_18456_9509# VDPWR 0.40138f
C3264 digital_0.clkbuf_1_0__f_clk.X digital_0._116_.D 0.06069f
C3265 a_9465_2050# a_9631_2050# 0.58439f
C3266 digital_0.hold28.A a_6871_412# 0.03561f
C3267 digital_0._065_.A2_N digital_0._063_.B 0.07695f
C3268 a_4571_962# digital_0._080_.A2 0.54622f
C3269 a_4405_962# a_4826_1322# 0.08968f
C3270 a_3743_3138# VDPWR 0.5824f
C3271 digital_0._112_.Q a_11673_412# 0.15246f
C3272 a_9564_930# a_9690_1194# 0.34134f
C3273 digital_0.hold28.A uio_out<7> 0.24136f
C3274 a_12225_1500# VDPWR 0.40328f
C3275 digital_0._080_.A2 a_5422_n702# 0.0249f
C3276 LELO_GR01_0.x8.x1.x5.x9<2>.G a_21558_6509# 0.07542f
C3277 LELO_GR01_0.x8.x1.x5.x8.S LELO_GR01_0.PWRUP_1V8 0.04338f
C3278 a_7720_n132# VDPWR 0.08228f
C3279 digital_0.output4.A a_3821_2562# 0.02787f
C3280 LELO_GR01_0.x7.x1.x5.x8.G ui_in<0> 0.13458f
C3281 digital_0._108_.D a_6315_1474# 0.01566f
C3282 a_17508_11144# VDPWR 0.03814f
C3283 digital_0.input1.X a_6853_2422# 0.0523f
C3284 a_12407_2830# a_12297_2954# 0.09774f
C3285 digital_0._118_.D a_4405_962# 0.28146f
C3286 digital_0.load_slew17.X a_9690_1194# 0.02336f
C3287 digital_0.hold28.X a_4570_n16# 0.21957f
C3288 a_13481_386# VDPWR 0.40136f
C3289 digital_0.load_slew17.A digital_0._103_.RESET_B 0.19207f
C3290 digital_0.output5.A digital_0.hold19.X 0.14207f
C3291 digital_0._116_.Q digital_0.hold28.A 0.54222f
C3292 a_13978_3650# digital_0.output7.A 0.19817f
C3293 LELO_GR01_0.PWRUP_1V8 a_19032_16564# 0.02035f
C3294 LELO_GR01_0.x7.x1.x5.x9<2>.G a_9734_15874# 0.07742f
C3295 digital_0._116_.Q digital_0.input2.X 0.28045f
C3296 digital_0.load_slew15.X a_5159_1474# 0.0143f
C3297 a_27238_16564# uo_out<0> 0.0116f
C3298 digital_0.clkload0.A a_9631_2050# 0.0398f
C3299 digital_0._110_.D a_11673_2588# 0.16707f
C3300 LELO_GR01_0.x8.x8.D a_23824_9183# 0.01319f
C3301 LELO_GR01_0.x7.xd1<4>.A a_14358_9800# 0.07393f
C3302 LELO_GR01_0.x8.PWRUP_N_1V8 a_18456_9509# 0.08225f
C3303 digital_0.hold28.A digital_0._107_.RESET_B 0.02622f
C3304 a_8684_6824# VDPWR 0.01812f
C3305 a_8036_4904# uio_out<0> 0.0326f
C3306 a_8468_4904# rst_n 0.02453f
C3307 digital_0._060_.A_N a_8729_412# 0.0892f
C3308 digital_0.load_slew17.X a_9981_246# 0.04534f
C3309 digital_0.input2.X digital_0._107_.RESET_B 0.08188f
C3310 digital_0.hold23.X digital_0._112_.RESET_B 0.03501f
C3311 a_4581_2825# VDPWR 0.21157f
C3312 digital_0._113_.Q a_13481_386# 0.01298f
C3313 digital_0.input3.X a_15685_386# 0.05386f
C3314 a_4802_4904# a_5234_4904# 0.14233f
C3315 a_7826_956# VDPWR 0.38831f
C3316 digital_0._106_.RESET_B a_9981_246# 0.15327f
C3317 a_4765_n158# a_5328_n132# 0.04983f
C3318 a_9631_n126# a_10546_246# 0.12532f
C3319 a_17668_18750# LELO_GR01_0.x8.IBP_BG 0.03792f
C3320 digital_0._108_.Q digital_0.input1.X 0.36036f
C3321 LELO_GR01_0.x7.x10.P a_23562_16564# 0.25167f
C3322 a_18456_10309# VDPWR 0.42759f
C3323 digital_0.clkbuf_1_0__f_clk.X a_4746_412# 0.02823f
C3324 digital_0._110_.RESET_B a_12977_2044# 0.15239f
C3325 digital_0.hold28.A a_6705_412# 0.02955f
C3326 digital_0._065_.A2_N a_11397_1750# 0.23515f
C3327 digital_0.clkbuf_1_0__f_clk.X ui_in<0> 0.10867f
C3328 a_4405_962# digital_0._080_.A2 0.05298f
C3329 digital_0.hold19.X VDPWR 0.61914f
C3330 digital_0.hold28.A uio_out<1> 0.01888f
C3331 digital_0._063_.B VDPWR 0.114f
C3332 LELO_GR01_0.x8.x1.x5.x9<2>.G a_20156_5709# 0.08521f
C3333 digital_0.clkload0.A a_10017_3138# 0.25364f
C3334 LELO_GR01_0.x7.x1.x5.x8.G rst_n 0.188f
C3335 digital_0.output8.A digital_0._110_.D 0.10382f
C3336 LELO_GR01_0.x8.VREF_BG LELO_GR01_0.x7.x11.N 0.06908f
C3337 digital_0._110_.Q a_12225_1500# 0.01233f
C3338 a_12929_2562# a_12754_2588# 0.23366f
C3339 LELO_GR01_0.x7.x28.e uio_out<0> 0.04188f
C3340 a_16646_11144# VDPWR 0.027f
C3341 digital_0.input1.X a_7071_2018# 0.04904f
C3342 a_11839_2588# a_12297_2954# 0.03462f
C3343 digital_0.load_slew17.X a_9564_930# 0.0197f
C3344 a_23138_6427# VDPWR 0.042f
C3345 LELO_GR01_0.x8.x5.CK uio_out<4> 0.06343f
C3346 a_12741_1500# a_12849_1866# 0.05722f
C3347 digital_0._063_.B digital_0._113_.Q 0.11351f
C3348 a_15268_1474# a_15394_1658# 0.34134f
C3349 digital_0._118_.D a_3858_930# 0.04095f
C3350 a_25918_11144# a_26350_11144# 0.14233f
C3351 digital_0._114_.Q a_9465_n126# 0.02565f
C3352 digital_0.hold28.X a_4609_110# 0.2739f
C3353 a_9548_6824# a_9980_6824# 0.21349f
C3354 a_12741_412# VDPWR 0.18813f
C3355 digital_0.output5.A a_3577_3138# 0.03934f
C3356 digital_0._069_.A digital_0.hold28.A 0.2176f
C3357 a_11996_16842# LELO_GR01_0.x7.x1.x7.D 0.01242f
C3358 LELO_GR01_0.x7.x1.x5.x9<2>.G a_7886_15060# 0.09093f
C3359 uio_in<2> uio_in<3> 0.03102f
C3360 digital_0.load_slew15.X digital_0.hold22.X 0.10557f
C3361 a_27022_14644# uo_out<0> 0.01189f
C3362 digital_0.load_slew15.A a_8996_1500# 0.10404f
C3363 digital_0._116_.Q digital_0._118_.D 0.02374f
C3364 digital_0.clkload0.A a_9465_2050# 0.03523f
C3365 LELO_GR01_0.x8.x8.D a_23824_9983# 0.0403f
C3366 LELO_GR01_0.x7.xd1<4>.A a_14358_10600# 0.07768f
C3367 LELO_GR01_0.x8.PWRUP_N_1V8 a_18456_10309# 0.07206f
C3368 LELO_GR01_0.x7.x7.G a_9650_11154# 0.0567f
C3369 digital_0._112_.Q digital_0.clkbuf_1_1__f_clk.A 0.01425f
C3370 a_4425_2730# VDPWR 0.48484f
C3371 digital_0.input3.X a_15427_386# 0.09301f
C3372 digital_0.load_slew17.X digital_0._106_.RESET_B 0.40971f
C3373 a_10199_n158# a_9981_246# 0.20964f
C3374 a_4765_n158# a_5075_234# 0.01379f
C3375 a_4570_n16# a_5328_n132# 0.06121f
C3376 a_7099_956# VDPWR 0.47681f
C3377 a_9631_n126# a_10721_172# 0.04251f
C3378 a_10495_n702# VDPWR 0.22031f
C3379 a_12737_n676# uio_out<6> 0.10738f
C3380 a_14029_3510# a_14137_3132# 0.05722f
C3381 a_6179_3132# a_6906_3132# 0.02551f
C3382 a_14358_9800# VDPWR 0.40066f
C3383 digital_0.clkbuf_1_0__f_clk.X a_4610_386# 0.04855f
C3384 digital_0._110_.RESET_B a_12517_2044# 0.01901f
C3385 digital_0.clkload0.A a_13513_956# 0.05786f
C3386 LELO_GR01_0.x7.x15.I1 a_10730_9234# 0.02053f
C3387 digital_0.hold28.A clk 0.12393f
C3388 digital_0.hold22.X a_5855_564# 0.13052f
C3389 a_3577_3138# VDPWR 0.45692f
C3390 digital_0._112_.Q a_10997_386# 0.21804f
C3391 a_11397_1750# VDPWR 0.39039f
C3392 digital_0._118_.D uio_out<1> 0.11305f
C3393 LELO_GR01_0.x8.x1.x5.x9<2>.G a_20156_6509# 0.12529f
C3394 a_9151_n702# a_9417_n702# 0.18284f
C3395 digital_0.output12.A uo_out<0> 0.08734f
C3396 digital_0._117_.RESET_B digital_0._108_.D 0.02801f
C3397 LELO_GR01_0.x7.x7.G a_11318_13928# 0.08481f
C3398 a_14358_14870# a_14358_14730# 0.11733f
C3399 JNWTR_ORX1_CV_0.A a_23562_16564# 0.03427f
C3400 digital_0._116_.Q digital_0._080_.A2 0.29289f
C3401 digital_0.input1.X a_6503_2050# 0.66507f
C3402 a_11839_2588# a_12094_2588# 0.06418f
C3403 digital_0.output6.A a_3982_386# 0.01037f
C3404 a_12741_1500# a_12646_1500# 0.04983f
C3405 digital_0._113_.RESET_B a_12849_1866# 0.0122f
C3406 digital_0.load_slew17.X digital_0._115_.Q 0.02243f
C3407 digital_0._118_.D a_3618_1194# 0.04847f
C3408 LELO_GR01_0.x7.x15.I1 LELO_GR01_0.x7.x31.N 0.01216f
C3409 digital_0._112_.RESET_B VDPWR 0.49432f
C3410 digital_0.output5.A digital_0.clkbuf_1_0__f_clk.X 0.10018f
C3411 a_13738_3834# a_13978_3650# 0.11296f
C3412 digital_0.load_slew15.A digital_0._109_.RESET_B 0.2238f
C3413 a_8336_16210# a_7886_15860# 0.01328f
C3414 LELO_GR01_0.x7.x1.x5.IBN LELO_GR01_0.x7.x15.I2 0.85196f
C3415 uio_out<7> uio_oe<0> 0.04188f
C3416 digital_0._116_.Q a_8996_1500# 0.22559f
C3417 digital_0.load_slew15.A a_8085_1500# 0.23464f
C3418 a_23778_14644# a_24210_14644# 0.01515f
C3419 LELO_GR01_0.PWRUP_1V8 a_20372_9699# 0.02291f
C3420 a_8252_6824# ui_in<0> 0.01812f
C3421 digital_0._116_.Q a_14861_172# 0.03126f
C3422 digital_0.clkload0.A a_12646_412# 0.01378f
C3423 digital_0._063_.A digital_0.load_slew17.X 0.09461f
C3424 LELO_GR01_0.x7.x29.P a_19666_11144# 0.01241f
C3425 digital_0._113_.Q digital_0._112_.RESET_B 0.03559f
C3426 a_4386_2856# VDPWR 0.58636f
C3427 digital_0.input3.X a_15331_564# 0.06382f
C3428 digital_0.load_slew17.X a_10199_n158# 0.04773f
C3429 a_10199_n158# digital_0._106_.RESET_B 0.16611f
C3430 a_4609_110# a_5328_n132# 0.08671f
C3431 digital_0._114_.RESET_B VDPWR 0.28577f
C3432 a_9465_n126# a_10546_246# 0.10236f
C3433 a_9631_n126# a_9981_246# 0.21986f
C3434 digital_0._115_.D ui_in<0> 0.04405f
C3435 LELO_GR01_0.x8.x3.A a_26928_5351# 0.06185f
C3436 LELO_GR01_0.x8.VREF_BG LELO_GR01_0.x8.IBP_BG 1.82271f
C3437 LELO_GR01_0.x8.PWRUP_N_1V8 LELO_GR01_0.x7.x1.x5.x8.G 0.87314f
C3438 LELO_GR01_0.x7.xd1<4>.A a_4578_16260# 0.02715f
C3439 digital_0.hold21.X VDPWR 0.29451f
C3440 a_12626_n676# uio_out<6> 0.0305f
C3441 a_17952_14644# VDPWR 0.01154f
C3442 digital_0.output13.A a_6263_2562# 0.03576f
C3443 digital_0._102_.RESET_B a_14137_3132# 0.01854f
C3444 digital_0.clkbuf_1_0__f_clk.X a_4438_386# 0.80511f
C3445 a_14358_10600# VDPWR 0.41173f
C3446 digital_0.hold22.X a_5218_778# 0.01608f
C3447 digital_0.clkbuf_1_0__f_clk.X VDPWR 3.2398f
C3448 digital_0._060_.A_N a_9417_n702# 0.21739f
C3449 digital_0._116_.D digital_0.output12.A 0.02365f
C3450 digital_0._115_.RESET_B ui_in<0> 0.06503f
C3451 LELO_GR01_0.x8.x1.x5.x9<2>.G a_18756_5709# 0.07336f
C3452 a_4910_n132# VDPWR 0.14291f
C3453 digital_0._117_.RESET_B digital_0._118_.RESET_B 0.02389f
C3454 LELO_GR01_0.x8.VREF_BG a_24210_14644# 0.03359f
C3455 JNWTR_ORX1_CV_0.A a_23346_14644# 0.06043f
C3456 digital_0._116_.Q a_15238_1334# 0.02502f
C3457 LELO_GR01_0.x7.x29.N VDPWR 0.22571f
C3458 digital_0.input1.X a_6337_2050# 0.88302f
C3459 digital_0._110_.RESET_B a_12754_2588# 0.23011f
C3460 a_11673_2588# a_12094_2588# 0.08638f
C3461 JNWTR_ORX1_CV_0.A a_4370_4904# 0.02142f
C3462 LELO_GR01_0.x8.x5.CK uio_out<3> 0.06438f
C3463 a_12959_1742# a_12849_1866# 0.09774f
C3464 digital_0.load_slew17.X digital_0._060_.A_N 0.10855f
C3465 digital_0._118_.D a_3492_930# 0.05418f
C3466 a_9332_4904# a_9764_4904# 0.14233f
C3467 digital_0._106_.D a_10066_n524# 0.08019f
C3468 a_12959_654# VDPWR 0.20326f
C3469 digital_0.load_slew15.X digital_0.hold28.A 0.39788f
C3470 digital_0.load_slew15.A a_7717_3926# 0.05053f
C3471 digital_0._116_.Q digital_0._109_.RESET_B 0.14924f
C3472 LELO_GR01_0.x8.PWRUP_N_1V8 a_17952_14644# 0.02887f
C3473 LELO_GR01_0.x7.x1.x5.x9<2>.G a_7886_15860# 0.0438f
C3474 LELO_GR01_0.x7.x1.x5.IBN LELO_GR01_0.x7.x1.x7.D 0.76824f
C3475 uio_in<1> uio_in<2> 0.03102f
C3476 digital_0._116_.Q a_8085_1500# 0.02437f
C3477 digital_0.load_slew15.A digital_0.clkbuf_1_1__f_clk.A 0.33672f
C3478 digital_0.load_slew15.X digital_0.input2.X 0.51945f
C3479 LELO_GR01_0.x8.x1.x5.x6.N a_20372_9267# 0.03752f
C3480 LELO_GR01_0.x7.x11.P a_28102_16564# 0.24854f
C3481 a_19234_11144# a_19666_11144# 0.01515f
C3482 a_4108_2840# VDPWR 0.30131f
C3483 digital_0.load_slew17.X a_9631_n126# 0.34377f
C3484 digital_0.input3.X JNWTR_IVX1_CV_0.Y 0.07436f
C3485 a_9631_n126# digital_0._106_.RESET_B 0.025f
C3486 a_9465_n126# a_10721_172# 0.04359f
C3487 LELO_GR01_0.x8.x3.A a_26088_5351# 0.09328f
C3488 LELO_GR01_0.x7.x18.D a_4578_16260# 0.07875f
C3489 LELO_GR01_0.x7.xd1<4>.A a_4578_17060# 0.02715f
C3490 a_2478_17610# a_2478_17100# 0.02417f
C3491 a_12409_n676# uio_out<6> 0.0247f
C3492 digital_0._108_.Q a_6263_2562# 0.1333f
C3493 a_14247_3106# a_14137_3132# 0.09774f
C3494 LELO_GR01_0.x8.PWRUP_N_1V8 LELO_GR01_0.x7.x29.N 0.14909f
C3495 digital_0.clkbuf_1_0__f_clk.X a_4530_626# 0.37684f
C3496 a_7593_2348# a_7418_2422# 0.23366f
C3497 a_9218_9234# a_9434_9234# 0.01515f
C3498 LELO_GR01_0.x8.x8.D LELO_GR01_0.x8.x3.A 0.01039f
C3499 digital_0._060_.A_N digital_0._115_.Q 0.51122f
C3500 digital_0.hold24.X VDPWR 0.33129f
C3501 a_22292_9483# a_20372_9267# 0.01515f
C3502 a_8996_1500# clk 0.32451f
C3503 digital_0._060_.A_N a_9151_n702# 0.05057f
C3504 LELO_GR01_0.x8.x1.x5.x9<2>.G a_18756_6509# 0.0876f
C3505 LELO_GR01_0.x8.x1.x7.D a_24508_6687# 0.07119f
C3506 a_8689_n676# a_9151_n702# 0.01329f
C3507 digital_0.output12.A ui_in<0> 0.01916f
C3508 digital_0._117_.RESET_B digital_0._101_.RESET_B 0.02368f
C3509 digital_0.output5.A a_3821_2562# 0.11346f
C3510 digital_0.hold28.A a_14594_3510# 0.04247f
C3511 digital_0.hold24.X a_12889_3171# 0.06547f
C3512 a_11318_14728# LELO_GR01_0.x7.x7.G 0.07043f
C3513 digital_0._116_.Q a_15413_1260# 0.01544f
C3514 a_16214_11144# VDPWR 0.01021f
C3515 digital_0.input1.X a_5787_2146# 0.029f
C3516 a_12407_2830# a_12754_2588# 0.05116f
C3517 digital_0._110_.RESET_B a_12929_2562# 0.29183f
C3518 a_12391_1500# a_12849_1866# 0.02761f
C3519 digital_0._113_.RESET_B digital_0.input3.X 0.31841f
C3520 digital_0.load_slew17.X a_7155_930# 0.02391f
C3521 a_4274_2410# VDPWR 0.07993f
C3522 a_12391_412# VDPWR 0.25666f
C3523 a_13612_3650# a_13738_3834# 0.34134f
C3524 digital_0._069_.A digital_0._109_.RESET_B 0.13826f
C3525 digital_0._116_.Q a_7717_3926# 0.09861f
C3526 LELO_GR01_0.PWRUP_1V8 a_18600_16564# 0.02013f
C3527 LELO_GR01_0.x7.x1.x5.x8.G a_7886_15060# 0.08329f
C3528 a_26806_16564# uo_out<0> 0.01879f
C3529 digital_0._116_.Q digital_0.clkbuf_1_1__f_clk.A 0.51145f
C3530 LELO_GR01_0.x7.x7.G a_9218_9234# 0.04833f
C3531 a_7604_4904# uio_out<0> 0.0326f
C3532 a_8036_4904# rst_n 0.02837f
C3533 a_8252_6824# VDPWR 0.01812f
C3534 LELO_GR01_0.x7.x29.N a_22470_13064# 0.24016f
C3535 a_3821_2562# VDPWR 0.42018f
C3536 digital_0.load_slew17.X digital_0._106_.D 0.02067f
C3537 digital_0.input3.X a_14990_386# 0.0449f
C3538 digital_0._112_.D a_13513_956# 0.17222f
C3539 digital_0._115_.D VDPWR 0.3415f
C3540 a_9465_n126# a_9981_246# 0.11104f
C3541 a_9631_n126# a_10199_n158# 0.17589f
C3542 digital_0.hold28.X ui_in<0> 0.0359f
C3543 a_26928_5671# a_26928_5351# 0.01f
C3544 a_24508_5627# a_24510_5235# 0.03228f
C3545 LELO_GR01_0.x7.x18.D a_4578_17060# 0.07857f
C3546 LELO_GR01_0.x8.VREF_BG a_16018_17950# 0.03062f
C3547 a_12138_n702# uio_out<6> 0.02493f
C3548 digital_0.output4.A a_4019_2050# 0.03374f
C3549 a_13679_3138# a_14137_3132# 0.02761f
C3550 LELO_GR01_0.x7.x10.P a_23130_16564# 0.02514f
C3551 digital_0._108_.RESET_B a_6315_1474# 0.01182f
C3552 digital_0.clkbuf_1_0__f_clk.X a_4118_412# 0.0356f
C3553 digital_0.clkload0.A digital_0._112_.D 0.19682f
C3554 a_7155_930# digital_0._115_.Q 0.42751f
C3555 digital_0._109_.RESET_B clk 0.06624f
C3556 digital_0.hold28.A uio_out<3> 0.0234f
C3557 digital_0._115_.RESET_B VDPWR 0.3818f
C3558 a_12741_412# a_12837_412# 0.01379f
C3559 LELO_GR01_0.x8.x1.x7.D LELO_GR01_0.x8.x7.D 0.31296f
C3560 digital_0._117_.RESET_B a_4201_3132# 0.0122f
C3561 digital_0.hold25.X digital_0._118_.RESET_B 0.23246f
C3562 digital_0.output13.A digital_0._109_.Q 0.65918f
C3563 digital_0.hold24.X digital_0._110_.Q 0.27296f
C3564 LELO_GR01_0.x8.VREF_BG a_23778_14644# 0.01749f
C3565 digital_0.load_slew15.X digital_0._080_.A2 0.28327f
C3566 digital_0._110_.RESET_B a_12189_2588# 0.15328f
C3567 digital_0.input1.X digital_0.output6.A 0.27898f
C3568 digital_0._110_.D digital_0._112_.Q 0.01027f
C3569 a_11839_2588# a_12754_2588# 0.12532f
C3570 a_28318_14644# a_28750_14644# 0.01515f
C3571 digital_0._113_.RESET_B a_15634_1474# 0.05421f
C3572 a_12391_1500# a_12646_1500# 0.05639f
C3573 digital_0._112_.Q a_14157_962# 0.01995f
C3574 a_4934_2422# VDPWR 0.28302f
C3575 digital_0._112_.D a_12646_412# 0.18319f
C3576 digital_0._113_.D a_12116_n132# 0.11811f
C3577 a_12225_412# VDPWR 0.44153f
C3578 digital_0._069_.B digital_0._109_.RESET_B 0.05146f
C3579 LELO_GR01_0.x7.x1.x5.IBN a_9734_16126# 0.03033f
C3580 uio_in<0> uio_in<1> 0.03102f
C3581 digital_0._108_.Q a_7418_2422# 0.04376f
C3582 a_26590_14644# uo_out<0> 0.01813f
C3583 digital_0._116_.Q a_6315_1474# 0.10023f
C3584 digital_0._069_.A digital_0.clkbuf_1_1__f_clk.A 0.17589f
C3585 LELO_GR01_0.PWRUP_1V8 a_20372_10347# 0.0132f
C3586 LELO_GR01_0.x7.x7.G a_8228_9234# 0.04878f
C3587 a_19018_11144# a_19666_11144# 0.06667f
C3588 digital_0.load_slew17.X a_9465_n126# 0.34076f
C3589 digital_0.input3.X a_14750_570# 0.03824f
C3590 a_9465_n126# digital_0._106_.RESET_B 0.29575f
C3591 LELO_GR01_0.x7.xd1<4>.A LELO_GR01_0.x7.x20.D 0.09617f
C3592 a_11898_n518# uio_out<6> 0.02962f
C3593 digital_0.output4.A digital_0._101_.D 0.07036f
C3594 a_18816_14644# a_19248_14644# 0.14233f
C3595 LELO_GR01_0.x7.xd1<4>.A a_15998_11144# 0.01383f
C3596 digital_0._069_.A a_10997_386# 0.15376f
C3597 a_7071_2018# a_7418_2422# 0.05116f
C3598 digital_0.clkbuf_1_0__f_clk.X digital_0._116_.SET_B 0.10059f
C3599 LELO_GR01_0.x7.x3.P a_9650_11154# 0.22903f
C3600 LELO_GR01_0.x7.x15.I1 a_10298_9234# 0.02053f
C3601 a_7155_930# digital_0._060_.A_N 0.25649f
C3602 a_5785_1750# VDPWR 0.45212f
C3603 digital_0.input2.X uo_out<1> 0.03619f
C3604 digital_0._114_.D digital_0._107_.D 0.01863f
C3605 digital_0.clkbuf_1_1__f_clk.A clk 0.08325f
C3606 a_15427_386# a_15685_386# 0.22264f
C3607 LELO_GR01_0.x8.x1.x7.D a_24508_7487# 0.07449f
C3608 LELO_GR01_0.x8.x1.x5.x8.G a_18756_5709# 0.01247f
C3609 LELO_GR01_0.x8.x5.XA5.A LELO_GR01_0.x8.x5.XA3.MN1.S 0.04373f
C3610 LELO_GR01_0.x8.x1.x5.x8.S LELO_GR01_0.x8.x1.x5.x6.N 0.15326f
C3611 digital_0.output12.A VDPWR 0.83044f
C3612 a_8578_n676# a_8689_n676# 0.34134f
C3613 digital_0.hold28.A a_14029_3510# 0.03014f
C3614 a_2478_16300# VDPWR 0.36615f
C3615 digital_0._108_.Q digital_0._109_.Q 0.45233f
C3616 digital_0.hold24.X a_12635_3171# 0.03924f
C3617 JNWTR_ORX1_CV_0.A a_23130_16564# 0.04107f
C3618 digital_0.clkload0.A a_12741_1500# 0.01233f
C3619 LELO_GR01_0.x7.x28.e VDPWR 0.35001f
C3620 a_12407_2830# a_12189_2588# 0.20964f
C3621 a_11839_2588# a_12929_2562# 0.04251f
C3622 a_11673_2588# a_12754_2588# 0.10232f
C3623 digital_0._113_.RESET_B a_15394_1658# 0.05524f
C3624 digital_0._113_.D a_12646_1500# 0.17079f
C3625 a_13481_1474# a_14298_1652# 0.01071f
C3626 digital_0.load_slew17.X a_6503_930# 0.01529f
C3627 digital_0._112_.Q a_11388_956# 0.03217f
C3628 LELO_GR01_0.x8.PWRUP_N_1V8 a_17850_3465# 0.07736f
C3629 a_5109_2348# VDPWR 0.4074f
C3630 digital_0._060_.A_N digital_0._106_.D 0.0378f
C3631 digital_0.clkload0.X VDPWR 0.30522f
C3632 digital_0.load_slew15.X digital_0._109_.RESET_B 0.13693f
C3633 digital_0._069_.A digital_0._109_.D 0.24586f
C3634 LELO_GR01_0.x7.x1.x5.x8.G a_7886_15860# 0.11889f
C3635 digital_0.load_slew15.X a_8085_1500# 0.22875f
C3636 digital_0._116_.Q a_4730_1652# 0.04067f
C3637 digital_0._108_.Q a_7593_2348# 0.14941f
C3638 a_7820_6824# ui_in<0> 0.0312f
C3639 a_15445_2044# digital_0._104_.RESET_B 0.01053f
C3640 a_7388_4904# uio_out<0> 0.01009f
C3641 digital_0._113_.Q digital_0.clkload0.X 0.01348f
C3642 digital_0.input3.X a_14624_386# 0.12626f
C3643 a_4586_6824# a_5018_6824# 0.21349f
C3644 digital_0._106_.D a_9631_n126# 0.28157f
C3645 digital_0.hold28.X VDPWR 0.72346f
C3646 a_9465_n126# a_10199_n158# 0.05348f
C3647 a_26088_5671# a_26088_5351# 0.01f
C3648 a_26928_5671# LELO_GR01_0.x8.x3.A 0.05912f
C3649 a_16018_18750# LELO_GR01_0.x8.VREF_BG 0.01293f
C3650 LELO_GR01_0.x8.PWRUP_N_1V8 a_2478_16300# 0.07785f
C3651 a_11772_n702# uio_out<6> 0.01904f
C3652 a_17520_14644# VDPWR 0.02723f
C3653 LELO_GR01_0.x7.x10.P uio_out<6> 0.04671f
C3654 digital_0.output4.A a_3853_2050# 0.03999f
C3655 digital_0._109_.Q a_5834_2740# 0.02608f
C3656 digital_0._111_.Q a_11107_2562# 0.05623f
C3657 LELO_GR01_0.x7.x1.x5.x9<2>.G a_7536_12960# 0.0124f
C3658 LELO_GR01_0.x7.xd1<4>.A a_14358_10740# 0.07768f
C3659 a_6503_2050# a_7418_2422# 0.12532f
C3660 digital_0.input1.X a_12225_1500# 0.2685f
C3661 digital_0.clkbuf_1_0__f_clk.X a_3982_386# 0.05242f
C3662 a_8228_9234# a_9218_9234# 0.04183f
C3663 digital_0._109_.D clk 0.04646f
C3664 digital_0._115_.Q a_7214_n524# 0.19457f
C3665 digital_0._118_.D uo_out<1> 0.02319f
C3666 LELO_GR01_0.x8.x1.x7.D a_23138_6685# 0.10753f
C3667 LELO_GR01_0.x8.x1.x5.x8.G a_18756_6509# 0.0438f
C3668 digital_0.hold28.A digital_0._102_.RESET_B 0.07102f
C3669 LELO_GR01_0.x7.x20.D VDPWR 0.47032f
C3670 a_6235_3106# digital_0._109_.Q 0.06913f
C3671 digital_0._108_.Q digital_0.output13.A 1.1935f
C3672 JNWTR_ORX1_CV_0.A a_22914_14644# 0.01624f
C3673 digital_0.clkload0.A digital_0._113_.RESET_B 0.03427f
C3674 a_15998_11144# VDPWR 0.04827f
C3675 a_11839_2588# a_12189_2588# 0.2298f
C3676 a_12407_2830# digital_0._110_.RESET_B 0.16613f
C3677 a_11673_2588# a_12929_2562# 0.04348f
C3678 JNWTR_ORX1_CV_0.A a_3938_4904# 0.02142f
C3679 digital_0._113_.RESET_B a_15268_1474# 0.05822f
C3680 a_13481_1474# a_13306_1500# 0.23366f
C3681 a_12225_1500# a_12646_1500# 0.08341f
C3682 digital_0._112_.Q digital_0._114_.Q 0.01919f
C3683 digital_0.load_slew17.X a_6407_1188# 0.01406f
C3684 a_25702_13064# a_26134_13064# 0.21349f
C3685 digital_0._080_.A2 a_4570_n16# 0.01547f
C3686 digital_0._060_.A_N a_9465_n126# 0.01437f
C3687 a_4369_2422# VDPWR 0.20033f
C3688 digital_0._069_.A a_7181_3926# 0.10637f
C3689 digital_0.output4.A digital_0.hold28.A 0.02309f
C3690 digital_0._069_.B digital_0._109_.D 0.31606f
C3691 LELO_GR01_0.x8.PWRUP_N_1V8 a_17520_14644# 0.02887f
C3692 ui_in<7> uio_in<0> 0.03102f
C3693 digital_0._116_.Q a_4369_1474# 0.03961f
C3694 digital_0.load_slew15.X digital_0.clkbuf_1_1__f_clk.A 0.08471f
C3695 digital_0.output4.A digital_0.input2.X 0.28315f
C3696 LELO_GR01_0.x7.x11.P a_27670_16564# 0.02157f
C3697 LELO_GR01_0.x7.x7.G LELO_GR01_0.x7.x3.P 0.20121f
C3698 digital_0.output9.A digital_0._104_.RESET_B 0.01331f
C3699 a_6530_4904# uio_out<0> 0.01009f
C3700 LELO_GR01_0.x7.x29.N a_22038_11144# 0.04014f
C3701 a_14137_3132# VDPWR 0.13238f
C3702 digital_0._116_.D a_5785_n426# 0.02948f
C3703 a_9465_n126# a_9631_n126# 0.71139f
C3704 digital_0._114_.Q uio_out<6> 0.02456f
C3705 a_5029_956# VDPWR 0.13345f
C3706 a_26088_5671# LELO_GR01_0.x8.x3.A 0.06171f
C3707 LELO_GR01_0.x7.xd1<4>.A a_14358_17550# 0.08223f
C3708 LELO_GR01_0.x8.PWRUP_N_1V8 LELO_GR01_0.x7.x20.D 1.01793f
C3709 LELO_GR01_0.x7.x19.D a_2478_16300# 0.01255f
C3710 LELO_GR01_0.x7.x6<3>.G a_4578_16260# 0.06119f
C3711 a_7643_n702# VDPWR 0.20871f
C3712 a_11772_n702# uio_out<5> 0.09496f
C3713 a_11361_n702# uio_out<6> 0.03713f
C3714 LELO_GR01_0.x7.x10.P uio_out<5> 0.07337f
C3715 digital_0._111_.Q a_10285_2910# 0.09477f
C3716 digital_0.output13.A a_5834_2740# 0.03854f
C3717 a_14029_3510# a_14125_3510# 0.01379f
C3718 LELO_GR01_0.x7.x1.x5.x9<2>.G a_7536_13760# 0.03436f
C3719 LELO_GR01_0.x7.xd1<4>.A a_14358_11540# 0.07768f
C3720 a_6503_2050# a_7593_2348# 0.04251f
C3721 a_6337_2050# a_7418_2422# 0.10236f
C3722 a_7071_2018# a_6853_2422# 0.20964f
C3723 digital_0.input1.X digital_0._063_.B 0.05111f
C3724 digital_0.hold22.X ui_in<0> 0.03205f
C3725 JNWTR_IVX1_CV_0.Y a_15685_386# 0.01224f
C3726 a_15331_564# a_15427_386# 0.41909f
C3727 LELO_GR01_0.x8.x1.x5.IBN LELO_GR01_0.x8.x7.D 0.50701f
C3728 LELO_GR01_0.x8.x1.x7.D a_23138_7485# 0.098f
C3729 a_5328_n132# VDPWR 0.08367f
C3730 a_8361_n676# a_8578_n676# 0.11296f
C3731 digital_0.hold28.A a_14247_3106# 0.01984f
C3732 JNWTR_TIEL_CV_0.Y uio_out<7> 0.02105f
C3733 a_2478_17100# VDPWR 0.36635f
C3734 a_6235_3106# digital_0.output13.A 0.42579f
C3735 JNWTR_ORX1_CV_0.A uio_out<6> 0.01618f
C3736 LELO_GR01_0.x8.VREF_BG a_23562_16564# 0.07133f
C3737 digital_0.clkload0.A a_12959_1742# 0.01114f
C3738 a_14358_10740# VDPWR 0.41176f
C3739 a_11839_2588# digital_0._110_.RESET_B 0.0256f
C3740 a_11673_2588# a_12189_2588# 0.11276f
C3741 digital_0._063_.B a_12646_1500# 0.02188f
C3742 digital_0._113_.RESET_B a_14298_1652# 0.04992f
C3743 digital_0._112_.Q a_10253_930# 0.03684f
C3744 digital_0._080_.A2 a_4609_110# 0.03336f
C3745 a_4587_2018# VDPWR 0.20903f
C3746 a_8689_n132# a_8689_n676# 0.01212f
C3747 digital_0._069_.B a_7181_3926# 0.0498f
C3748 digital_0._069_.A digital_0._117_.RESET_B 0.02538f
C3749 a_12718_3676# a_12829_3676# 0.34134f
C3750 digital_0.load_slew15.X digital_0._109_.D 0.02615f
C3751 LELO_GR01_0.PWRUP_1V8 a_18168_16564# 0.02877f
C3752 a_26374_16564# uo_out<0> 0.03548f
C3753 a_25510_16564# uio_out<7> 0.0155f
C3754 digital_0.output4.A digital_0._118_.D 0.01499f
C3755 digital_0._116_.Q a_4111_1474# 0.07156f
C3756 digital_0.load_slew15.X a_6315_1474# 0.01128f
C3757 digital_0._108_.Q a_7071_2018# 0.0176f
C3758 LELO_GR01_0.x8.x1.x5.x6.N a_20372_9699# 0.22481f
C3759 a_23346_14644# a_23778_14644# 0.14233f
C3760 a_7820_6824# VDPWR 0.01812f
C3761 a_7604_4904# rst_n 0.03438f
C3762 LELO_GR01_0.x7.x29.N a_21176_11144# 0.02984f
C3763 a_19018_11144# a_19234_11144# 0.01515f
C3764 a_4370_4904# a_4802_4904# 0.14233f
C3765 a_9465_n126# digital_0._106_.D 0.17578f
C3766 LELO_GR01_0.x7.x19.D LELO_GR01_0.x7.x20.D 0.56721f
C3767 LELO_GR01_0.x7.xd1<4>.A a_17668_17950# 0.07043f
C3768 LELO_GR01_0.x8.PWRUP_N_1V8 a_2478_17100# 0.08243f
C3769 LELO_GR01_0.x7.x6<3>.G a_4578_17060# 0.06102f
C3770 digital_0.hold26.X VDPWR 0.20799f
C3771 a_11361_n702# uio_out<5> 0.1379f
C3772 a_11103_n702# uio_out<6> 0.05255f
C3773 digital_0._111_.Q digital_0._065_.A2_N 0.04647f
C3774 digital_0._108_.Q a_5834_2740# 0.19177f
C3775 a_14029_3510# a_13934_3498# 0.04983f
C3776 LELO_GR01_0.x7.x10.P a_22698_16564# 0.02376f
C3777 LELO_GR01_0.x7.xd1<4>.A a_14358_11680# 0.07768f
C3778 a_6337_2050# a_7593_2348# 0.04359f
C3779 a_6503_2050# a_6853_2422# 0.21907f
C3780 digital_0.load_slew15.A a_8895_412# 0.0113f
C3781 LELO_GR01_0.x7.x3.P a_9218_9234# 0.01873f
C3782 LELO_GR01_0.x8.x8.D a_26930_6213# 0.35757f
C3783 JNWTR_ORX1_CV_0.A LELO_GR01_0.x8.x1.x7.D 0.35751f
C3784 digital_0.hold22.X a_4610_386# 0.03025f
C3785 a_11415_3650# VDPWR 0.15332f
C3786 digital_0._117_.RESET_B clk 0.02723f
C3787 a_5159_1474# VDPWR 0.19046f
C3788 JNWTR_IVX1_CV_0.Y a_15427_386# 0.02787f
C3789 digital_0.hold28.A a_13679_3138# 0.54831f
C3790 a_14358_17550# VDPWR 0.41661f
C3791 a_6235_3106# digital_0._108_.Q 0.27639f
C3792 JNWTR_ORX1_CV_0.A uio_out<5> 0.32234f
C3793 digital_0.output4.A digital_0._080_.A2 0.01573f
C3794 digital_0.clkload0.A a_12391_1500# 0.03155f
C3795 a_14358_11540# VDPWR 0.41176f
C3796 a_11673_2588# digital_0._110_.RESET_B 0.29517f
C3797 a_11839_2588# a_12407_2830# 0.18639f
C3798 digital_0.hold28.A a_14727_1474# 0.21748f
C3799 digital_0._113_.RESET_B a_13306_1500# 0.21676f
C3800 digital_0.load_slew17.X a_5661_1260# 0.02191f
C3801 a_25486_11144# a_25918_11144# 0.14233f
C3802 a_4019_2050# VDPWR 0.26374f
C3803 digital_0._113_.D a_12116_188# 0.08678f
C3804 a_9116_6824# a_9548_6824# 0.21349f
C3805 a_2478_15790# LELO_GR01_0.x7.x21.D 0.04278f
C3806 ui_in<6> ui_in<7> 0.03102f
C3807 a_26158_14644# uo_out<0> 0.03211f
C3808 digital_0.load_slew17.A a_12977_2044# 0.09383f
C3809 a_25294_14644# uio_out<7> 0.01558f
C3810 digital_0._116_.Q a_4015_1652# 0.06256f
C3811 digital_0._109_.Q a_5787_2146# 0.0795f
C3812 LELO_GR01_0.x8.x1.x5.x8.S a_20372_9699# 0.22449f
C3813 a_7388_4904# ui_in<0> 0.0278f
C3814 a_14762_2018# digital_0.load_slew17.X 0.15507f
C3815 digital_0.hold28.X digital_0._116_.SET_B 0.2535f
C3816 digital_0._080_.A2 uo_out<0> 0.154f
C3817 LELO_GR01_0.x7.x19.D a_2478_17100# 0.04966f
C3818 a_11103_n702# uio_out<5> 0.06594f
C3819 a_11007_n524# uio_out<6> 0.05652f
C3820 digital_0._108_.D a_6179_3132# 0.19159f
C3821 digital_0.clkbuf_1_0__f_clk.X digital_0.input1.X 0.04278f
C3822 digital_0._111_.Q a_10074_2562# 0.14549f
C3823 digital_0._109_.RESET_B a_7513_2954# 0.0167f
C3824 LELO_GR01_0.x7.x10.P uio_out<1> 0.02206f
C3825 a_17304_16564# VDPWR 0.01882f
C3826 JNWTR_ORX1_CV_0.A LELO_GR01_0.x7.x15.I1 3.07391f
C3827 LELO_GR01_0.PWRUP_1V8 LELO_GR01_0.x7.x29.N 0.1724f
C3828 LELO_GR01_0.x7.xd1<4>.A a_14358_12480# 0.07695f
C3829 a_6503_2050# a_7071_2018# 0.17589f
C3830 a_6337_2050# a_6853_2422# 0.11025f
C3831 LELO_GR01_0.x7.x3.P a_8228_9234# 0.0187f
C3832 digital_0.hold22.X a_4438_386# 0.30264f
C3833 digital_0._111_.Q VDPWR 0.92926f
C3834 digital_0._100_.RESET_B clk 0.05988f
C3835 digital_0.hold28.A ui_in<0> 0.10389f
C3836 a_6503_930# a_6761_930# 0.22264f
C3837 a_22292_9915# a_22292_9483# 0.14233f
C3838 a_20372_10347# a_20372_9267# 0.0381f
C3839 digital_0.input2.X ui_in<0> 0.6795f
C3840 digital_0.hold22.X VDPWR 0.85729f
C3841 JNWTR_IVX1_CV_0.Y a_15331_564# 0.03645f
C3842 LELO_GR01_0.x8.x5.XA5.A a_26930_7813# 0.02049f
C3843 LELO_GR01_0.x7.x1.x5.x8.S LELO_GR01_0.x7.x1.x5.x6.N 0.15326f
C3844 digital_0.hold28.A digital_0._102_.D 0.0588f
C3845 a_17668_17950# VDPWR 0.40365f
C3846 digital_0._069_.A a_11388_956# 0.07827f
C3847 digital_0.clkload0.A digital_0._113_.D 0.33859f
C3848 a_14358_11680# VDPWR 0.41176f
C3849 a_11673_2588# a_12407_2830# 0.07009f
C3850 digital_0.hold28.A digital_0.hold23.X 0.25288f
C3851 LELO_GR01_0.x8.x5.CK VDPWR 0.89011f
C3852 a_26930_7333# uo_out<0> 0.06533f
C3853 a_12959_1742# a_13306_1500# 0.05116f
C3854 digital_0._113_.RESET_B a_13481_1474# 0.31828f
C3855 digital_0._115_.Q digital_0._107_.D 0.05963f
C3856 digital_0._101_.D VDPWR 0.51353f
C3857 digital_0._114_.D uio_out<7> 0.04697f
C3858 a_8578_n132# a_8578_n676# 0.02141f
C3859 digital_0.load_slew15.X digital_0._117_.RESET_B 0.66421f
C3860 a_12501_3676# a_12718_3676# 0.11296f
C3861 a_9734_16926# LELO_GR01_0.x7.x1.x5.IBN 0.01243f
C3862 LELO_GR01_0.x7.x20.D a_2478_14990# 0.01256f
C3863 uio_out<0> uo_out<7> 0.04002f
C3864 digital_0._116_.Q a_3471_1474# 0.09323f
C3865 digital_0._109_.Q digital_0.output6.A 0.08051f
C3866 digital_0.output13.A a_5787_2146# 0.20621f
C3867 digital_0._108_.Q a_6337_2050# 0.01107f
C3868 JNWTR_ORX1_CV_0.A a_23982_11144# 0.03018f
C3869 a_7388_4904# rst_n 0.02496f
C3870 a_6530_4904# ui_in<0> 0.0207f
C3871 a_15662_2044# a_15773_2044# 0.34134f
C3872 a_6098_4904# uio_out<0> 0.0326f
C3873 digital_0._080_.A2 digital_0._116_.D 0.05981f
C3874 digital_0.input3.X digital_0._112_.RESET_B 0.51331f
C3875 digital_0._115_.Q a_7786_412# 0.04301f
C3876 a_5785_n426# VDPWR 0.22024f
C3877 digital_0.hold27.X a_14175_n702# 0.09101f
C3878 a_11007_n524# uio_out<5> 0.05566f
C3879 a_17088_14644# VDPWR 0.07122f
C3880 LELO_GR01_0.x7.xd1<4>.A a_11162_9234# 0.06208f
C3881 a_6337_2050# a_7071_2018# 0.05348f
C3882 digital_0.load_slew15.A a_8729_412# 0.01003f
C3883 digital_0._116_.Q digital_0._114_.D 0.01083f
C3884 digital_0.clkload0.A digital_0._060_.B 0.0287f
C3885 a_7796_9234# a_8228_9234# 0.01515f
C3886 digital_0.hold22.X a_4530_626# 0.02056f
C3887 digital_0.hold25.X clk 0.05023f
C3888 digital_0.hold20.X VDPWR 0.20866f
C3889 digital_0.hold28.A rst_n 0.01542f
C3890 digital_0._114_.D digital_0._107_.RESET_B 0.03531f
C3891 digital_0._116_.SET_B a_5328_n132# 0.02506f
C3892 LELO_GR01_0.x8.x5.XA5.A a_26090_7813# 0.02736f
C3893 digital_0.output10.A a_15225_n702# 0.32551f
C3894 JNWTR_ORX1_CV_0.A uio_out<1> 0.47664f
C3895 digital_0.hold28.A a_13513_3138# 0.05199f
C3896 a_21252_18378# VDPWR 0.28542f
C3897 digital_0._111_.Q digital_0._110_.Q 0.40253f
C3898 digital_0._069_.A digital_0._114_.Q 0.11348f
C3899 digital_0.clkload0.A a_12225_1500# 0.02839f
C3900 a_14358_12480# VDPWR 0.41154f
C3901 a_11673_2588# a_11839_2588# 0.87953f
C3902 digital_0.hold28.A digital_0._104_.D 0.01437f
C3903 JNWTR_ORX1_CV_0.A a_3506_4904# 0.02142f
C3904 a_27886_14644# a_28318_14644# 0.14233f
C3905 LELO_GR01_0.x7.x15.I2 a_14358_9800# 0.05314f
C3906 digital_0.hold28.A digital_0.output10.A 0.60659f
C3907 a_26090_7333# uo_out<0> 0.05912f
C3908 a_12391_1500# a_13306_1500# 0.12532f
C3909 digital_0._113_.RESET_B a_12741_1500# 0.15227f
C3910 LELO_GR01_0.x8.x7.D uio_out<3> 0.09507f
C3911 a_3853_2050# VDPWR 0.43673f
C3912 a_7221_412# a_7317_412# 0.01379f
C3913 a_8900_4904# a_9332_4904# 0.14233f
C3914 digital_0.load_slew15.X digital_0._100_.RESET_B 0.13419f
C3915 LELO_GR01_0.x8.PWRUP_N_1V8 a_17088_14644# 0.02887f
C3916 LELO_GR01_0.x7.x1.x5.x9<2>.G a_9734_16126# 0.07793f
C3917 ui_in<5> ui_in<6> 0.03102f
C3918 a_4581_2825# a_4891_2588# 0.01379f
C3919 LELO_GR01_0.x7.x11.N uio_out<7> 0.13039f
C3920 a_24210_14644# uio_out<6> 0.02117f
C3921 digital_0.load_slew17.A digital_0._104_.RESET_B 0.17179f
C3922 digital_0._116_.Q a_12977_2044# 0.1029f
C3923 digital_0.output13.A digital_0.output6.A 0.44247f
C3924 digital_0._108_.Q a_5787_2146# 0.2103f
C3925 LELO_GR01_0.x7.x11.P a_27238_16564# 0.02018f
C3926 LELO_GR01_0.x7.x7.G a_7580_11154# 0.09893f
C3927 a_7388_4904# VDPWR 0.04826f
C3928 a_6530_4904# rst_n 0.01345f
C3929 a_11951_2146# digital_0._063_.A 0.12815f
C3930 digital_0._112_.Q digital_0.load_slew17.X 0.10167f
C3931 digital_0.input1.X digital_0._115_.D 0.16136f
C3932 a_18156_11144# a_19018_11144# 0.04861f
C3933 digital_0._113_.RESET_B JNWTR_IVX1_CV_0.Y 0.05671f
C3934 digital_0._115_.Q a_7961_386# 0.16858f
C3935 digital_0._080_.A2 ui_in<0> 0.04989f
C3936 a_26930_6213# a_26928_5671# 0.01876f
C3937 LELO_GR01_0.x8.PWRUP_N_1V8 a_21252_18378# 0.0124f
C3938 a_15225_n702# VDPWR 0.27651f
C3939 LELO_GR01_0.x7.x10.P uio_out<4> 0.04614f
C3940 digital_0.load_slew17.A a_12754_2588# 0.02309f
C3941 a_13679_3138# a_13934_3498# 0.05936f
C3942 a_18600_16564# a_19032_16564# 0.21349f
C3943 a_6337_2050# a_6503_2050# 0.57945f
C3944 digital_0.input1.X digital_0._115_.RESET_B 0.12763f
C3945 a_14358_12620# a_14358_12480# 0.11733f
C3946 JNWTR_ORX1_CV_0.A LELO_GR01_0.x8.x1.x5.IBN 0.41364f
C3947 LELO_GR01_0.x8.IBP_BG LELO_GR01_0.x8.x1.x7.D 0.34321f
C3948 digital_0._118_.D a_4610_386# 0.01235f
C3949 digital_0.hold28.A VDPWR 9.41114f
C3950 a_6407_1188# a_6503_930# 0.41909f
C3951 digital_0._063_.B a_13513_956# 0.04505f
C3952 a_12741_412# a_12849_778# 0.05722f
C3953 digital_0.input2.X VDPWR 1.21475f
C3954 a_14990_386# JNWTR_IVX1_CV_0.Y 0.20274f
C3955 LELO_GR01_0.x8.x1.x5.IBN a_21554_6773# 0.03188f
C3956 LELO_GR01_0.x8.x5.XA5.A LELO_GR01_0.x8.x5.XA4.MP1.S 0.05173f
C3957 digital_0.output10.A a_14967_n702# 0.07618f
C3958 a_6793_n676# a_7214_n524# 0.01569f
C3959 digital_0.hold28.A a_12889_3171# 0.36492f
C3960 JNWTR_ORX1_CV_0.A clk 0.7848f
C3961 LELO_GR01_0.x8.VREF_BG a_23130_16564# 0.06464f
C3962 a_11162_9234# VDPWR 0.01457f
C3963 digital_0.clkload0.A digital_0._063_.B 0.11409f
C3964 digital_0.hold28.A digital_0._113_.Q 0.30888f
C3965 digital_0._069_.A a_10253_930# 0.02944f
C3966 LELO_GR01_0.x7.x15.I2 a_14358_10600# 0.03227f
C3967 digital_0.input1.X a_12225_412# 0.26507f
C3968 LELO_GR01_0.x8.x5.XA3.MP1.S uo_out<0> 0.05612f
C3969 a_26930_7013# VDPWR 0.05926f
C3970 a_12959_1742# a_12741_1500# 0.20964f
C3971 a_12391_1500# a_13481_1474# 0.04251f
C3972 digital_0._115_.Q a_7157_n158# 0.02148f
C3973 a_9353_778# VDPWR 0.14218f
C3974 a_8361_n132# a_8361_n676# 0.02031f
C3975 digital_0.load_slew15.X digital_0.hold25.X 0.17724f
C3976 a_5321_3676# digital_0._100_.RESET_B 0.06915f
C3977 digital_0.output8.A a_12501_3676# 0.2107f
C3978 LELO_GR01_0.PWRUP_1V8 a_17736_16564# 0.05818f
C3979 LELO_GR01_0.x7.x1.x5.x9<2>.G LELO_GR01_0.x7.x1.x5.IBN 0.95897f
C3980 a_25942_16564# uo_out<0> 0.02501f
C3981 a_25078_14644# uio_out<7> 0.01101f
C3982 a_24210_14644# uio_out<5> 0.01789f
C3983 digital_0.load_slew17.A digital_0.load_slew17.X 0.21454f
C3984 digital_0._108_.Q digital_0.output6.A 0.02626f
C3985 LELO_GR01_0.x8.VREF_BG a_25270_13064# 0.01345f
C3986 JNWTR_ORX1_CV_0.A a_23550_11144# 0.03679f
C3987 LELO_GR01_0.x8.x1.x5.x8.S a_20372_10347# 0.01766f
C3988 LELO_GR01_0.x7.x31.N ui_in<0> 0.03052f
C3989 digital_0._112_.Q digital_0._063_.A 0.04419f
C3990 digital_0.output9.A a_15773_2044# 0.05454f
C3991 a_15445_2044# a_15662_2044# 0.11296f
C3992 digital_0.clkload0.A a_12741_412# 0.0383f
C3993 a_6530_4904# VDPWR 0.04859f
C3994 LELO_GR01_0.x7.x29.N a_20528_11144# 0.04127f
C3995 digital_0._115_.Q a_7221_412# 0.01744f
C3996 a_4826_1322# VDPWR 0.07905f
C3997 a_8578_n132# a_8689_n132# 0.34134f
C3998 LELO_GR01_0.x7.x1.x5.x6.N a_8336_16210# 0.39909f
C3999 LELO_GR01_0.x8.PWRUP_N_1V8 a_20412_18378# 0.01046f
C4000 a_14967_n702# VDPWR 0.2813f
C4001 digital_0._069_.A a_10571_2588# 0.01725f
C4002 digital_0.load_slew17.A a_12929_2562# 0.08003f
C4003 digital_0._109_.D a_7310_2588# 0.16937f
C4004 digital_0._102_.D a_13934_3498# 0.16221f
C4005 LELO_GR01_0.x7.x10.P uio_out<2> 0.02192f
C4006 LELO_GR01_0.x7.x10.P a_22266_16564# 0.02316f
C4007 LELO_GR01_0.x7.xd1<4>.A a_10730_9234# 0.011f
C4008 digital_0.load_slew15.X a_8895_412# 0.03256f
C4009 digital_0._065_.A2_N a_8996_1500# 0.02293f
C4010 digital_0._103_.D VDPWR 0.46708f
C4011 digital_0.input1.X digital_0.output12.A 0.26695f
C4012 digital_0._113_.D digital_0._112_.D 0.03199f
C4013 digital_0._112_.RESET_B a_12849_778# 0.0122f
C4014 a_12741_412# a_12646_412# 0.04983f
C4015 digital_0._118_.D VDPWR 0.47254f
C4016 digital_0.load_slew17.X uio_out<5> 0.0255f
C4017 a_21554_7825# a_21554_7573# 0.05415f
C4018 LELO_GR01_0.x8.x5.XA5.A LELO_GR01_0.x8.x5.XA4.MN1.S 0.07879f
C4019 a_14686_246# VDPWR 0.29787f
C4020 digital_0.output10.A a_14871_n524# 0.05511f
C4021 digital_0.hold28.A digital_0._110_.Q 0.24467f
C4022 a_24210_18544# VDPWR 0.2877f
C4023 a_4833_3436# a_4658_3510# 0.23366f
C4024 JNWTR_ORX1_CV_0.A uio_out<4> 1.36796f
C4025 LELO_GR01_0.x8.IBP_BG a_22698_16564# 0.0399f
C4026 digital_0.load_slew15.A a_9564_930# 0.10984f
C4027 digital_0.input1.X digital_0.clkload0.X 0.0693f
C4028 a_26090_7013# VDPWR 0.06915f
C4029 digital_0._112_.Q digital_0._060_.A_N 0.02707f
C4030 a_12391_1500# a_12741_1500# 0.20646f
C4031 a_12959_1742# digital_0._113_.RESET_B 0.15941f
C4032 a_12225_1500# a_13306_1500# 0.10236f
C4033 digital_0._112_.D a_13306_412# 0.0484f
C4034 digital_0._115_.Q a_6962_n16# 0.04244f
C4035 a_7221_412# a_7329_778# 0.05722f
C4036 LELO_GR01_0.x8.x5.XA7.C LELO_GR01_0.x8.x5.CK 0.09614f
C4037 a_9150_412# VDPWR 0.08232f
C4038 a_14861_172# digital_0.output10.A 0.10933f
C4039 a_5215_3676# digital_0._100_.RESET_B 0.08202f
C4040 a_5321_3676# digital_0.hold25.X 0.13114f
C4041 a_12189_3650# a_12501_3676# 0.08501f
C4042 ui_in<4> ui_in<5> 0.03102f
C4043 a_25726_14644# uo_out<0> 0.01623f
C4044 digital_0._100_.D a_5834_2740# 0.08113f
C4045 digital_0.hold28.A a_6758_2410# 0.01088f
C4046 digital_0._116_.Q digital_0._104_.RESET_B 0.21132f
C4047 digital_0.load_slew15.A digital_0.load_slew17.X 0.07051f
C4048 digital_0._069_.A a_12517_2044# 0.04577f
C4049 a_23778_14644# uio_out<6> 0.01221f
C4050 LELO_GR01_0.x8.VREF_BG a_25054_11144# 0.01616f
C4051 LELO_GR01_0.x8.x1.x5.x8.S a_18456_9509# 0.04689f
C4052 LELO_GR01_0.x7.x31.N rst_n 0.06775f
C4053 digital_0.output9.A a_15662_2044# 0.0735f
C4054 digital_0.clkload0.A digital_0._112_.RESET_B 0.04217f
C4055 LELO_GR01_0.x7.x29.N a_19666_11144# 0.02984f
C4056 digital_0._115_.Q a_7439_654# 0.03672f
C4057 digital_0._080_.A2 VDPWR 1.31753f
C4058 a_26090_6213# a_26088_5671# 0.01876f
C4059 LELO_GR01_0.x7.x1.x5.x6.N LELO_GR01_0.x7.x1.x5.x9<2>.G 0.83165f
C4060 a_14871_n524# VDPWR 0.17823f
C4061 a_13513_3138# a_13934_3498# 0.09313f
C4062 LELO_GR01_0.x7.x10.P uio_out<3> 0.02381f
C4063 a_16872_16564# VDPWR 0.02444f
C4064 a_18384_14644# a_18816_14644# 0.14233f
C4065 digital_0.clkload0.A digital_0._114_.RESET_B 0.28573f
C4066 digital_0.output6.A a_6503_2050# 0.11064f
C4067 digital_0.load_slew15.X digital_0._114_.D 0.07006f
C4068 a_27854_11144# uo_out<0> 0.01316f
C4069 LELO_GR01_0.x7.x15.I1 a_9434_9234# 0.02053f
C4070 digital_0._103_.RESET_B VDPWR 0.44486f
C4071 a_14673_3650# uio_out<2> 0.01197f
C4072 a_12959_654# a_12849_778# 0.09774f
C4073 a_14750_570# a_14990_386# 0.11296f
C4074 a_8996_1500# VDPWR 1.26622f
C4075 LELO_GR01_0.x8.x1.x5.IBN a_21554_7573# 0.03042f
C4076 LELO_GR01_0.x8.x5.XA5.A a_26930_8293# 0.07901f
C4077 a_14861_172# VDPWR 0.41248f
C4078 digital_0.output10.A a_13746_n524# 0.07327f
C4079 a_6687_n676# a_6793_n676# 0.41909f
C4080 digital_0._111_.Q digital_0._067_.A 0.70965f
C4081 digital_0.hold28.A a_12635_3171# 0.22282f
C4082 LELO_GR01_0.x8.IBP_BG uio_out<1> 0.06534f
C4083 JNWTR_ORX1_CV_0.A uio_out<2> 1.08732f
C4084 LELO_GR01_0.x8.VREF_BG uio_out<6> 0.82016f
C4085 LELO_GR01_0.x8.IBP_BG a_22482_14644# 0.06888f
C4086 a_10730_9234# VDPWR 0.01081f
C4087 digital_0.load_slew15.A digital_0._115_.Q 0.01104f
C4088 digital_0._116_.Q a_9564_930# 0.02163f
C4089 digital_0._065_.A2_N digital_0._057_.D 0.19574f
C4090 digital_0._063_.B a_13306_1500# 0.045f
C4091 a_12225_1500# a_13481_1474# 0.04359f
C4092 a_12391_1500# digital_0._113_.RESET_B 0.02136f
C4093 a_7221_412# a_7126_412# 0.04983f
C4094 a_7439_654# a_7329_778# 0.09774f
C4095 digital_0._115_.Q a_7001_110# 0.03603f
C4096 digital_0._112_.D a_13481_386# 0.07146f
C4097 LELO_GR01_0.x8.x5.XA7.C LELO_GR01_0.x8.x5.XA1.MN1.S 0.07714f
C4098 a_11673_412# VDPWR 0.37188f
C4099 digital_0._107_.D a_7214_n524# 0.11551f
C4100 digital_0._112_.RESET_B a_15537_n426# 0.171f
C4101 a_5215_3676# digital_0.hold25.X 0.01066f
C4102 a_4979_3676# digital_0._100_.RESET_B 0.06405f
C4103 a_12189_3650# digital_0.output8.A 0.2967f
C4104 uo_out<1> uo_out<2> 0.04012f
C4105 digital_0._100_.D a_5144_2954# 0.16221f
C4106 digital_0._116_.Q digital_0.load_slew17.X 1.04879f
C4107 digital_0._111_.Q a_11431_2382# 0.09446f
C4108 a_23778_14644# uio_out<5> 0.02459f
C4109 LELO_GR01_0.x8.x1.x5.x8.S a_18456_10309# 0.03292f
C4110 LELO_GR01_0.x7.x7.G LELO_GR01_0.x7.x15.I1 0.69304f
C4111 a_23130_16564# a_23562_16564# 0.21349f
C4112 digital_0.output9.A a_15445_2044# 0.23716f
C4113 digital_0.clkload0.A a_12959_654# 0.03872f
C4114 a_5666_4904# uio_out<0> 0.0326f
C4115 LELO_GR01_0.x7.x31.N VDPWR 0.02499f
C4116 a_17724_11144# a_18156_11144# 0.01515f
C4117 a_13934_3498# VDPWR 0.07761f
C4118 digital_0._113_.Q a_11673_412# 0.03324f
C4119 digital_0._115_.Q a_6871_412# 0.03003f
C4120 a_4154_6824# a_4586_6824# 0.21349f
C4121 a_8361_n132# a_8578_n132# 0.11296f
C4122 a_15238_1334# VDPWR 0.29863f
C4123 LELO_GR01_0.x8.x5.CK a_26086_4531# 0.01504f
C4124 LELO_GR01_0.x7.x1.x5.x6.N a_8336_17010# 0.43217f
C4125 a_13746_n524# VDPWR 0.10416f
C4126 a_9151_n702# uio_out<7> 0.01383f
C4127 digital_0.load_slew17.A digital_0._110_.RESET_B 0.4928f
C4128 a_16656_14644# VDPWR 0.03049f
C4129 digital_0._065_.A2_N digital_0.clkbuf_1_1__f_clk.A 0.34f
C4130 digital_0.output6.A a_6337_2050# 0.03742f
C4131 digital_0.load_slew15.X a_8729_412# 0.046f
C4132 LELO_GR01_0.x8.x8.D a_26930_6533# 0.40085f
C4133 LELO_GR01_0.x8.VREF_BG LELO_GR01_0.x8.x1.x7.D 0.2748f
C4134 LELO_GR01_0.x8.IBP_BG LELO_GR01_0.x8.x1.x5.IBN 1.0986f
C4135 digital_0._109_.RESET_B VDPWR 0.34784f
C4136 a_14415_3650# uio_out<2> 0.01559f
C4137 digital_0.input2.X digital_0._116_.SET_B 0.01256f
C4138 a_5661_1260# a_6407_1188# 0.01491f
C4139 digital_0._063_.B digital_0._112_.D 0.22726f
C4140 LELO_GR01_0.x8.PWRUP_N_1V8 a_17850_2665# 0.07043f
C4141 a_8085_1500# VDPWR 0.43254f
C4142 digital_0._112_.RESET_B a_15685_386# 0.04908f
C4143 a_12391_412# a_12849_778# 0.02761f
C4144 digital_0._113_.Q a_13746_n524# 0.2042f
C4145 a_26930_8613# a_26930_8293# 0.01f
C4146 LELO_GR01_0.x8.x5.XA5.A a_26090_8293# 0.09561f
C4147 digital_0.output10.A a_12737_n676# 0.04042f
C4148 a_14121_246# VDPWR 0.19918f
C4149 digital_0.clkbuf_1_0__f_clk.X digital_0._109_.Q 0.02899f
C4150 digital_0._111_.Q a_11098_3510# 0.02563f
C4151 JNWTR_ORX1_CV_0.A uio_out<3> 0.78995f
C4152 a_28996_18831# VDPWR 0.35862f
C4153 a_4311_3106# a_4658_3510# 0.05116f
C4154 LELO_GR01_0.x8.VREF_BG uio_out<5> 0.11334f
C4155 digital_0.hold28.A digital_0._067_.B 0.03715f
C4156 digital_0._069_.B a_7349_3132# 0.0939f
C4157 digital_0.load_slew15.A digital_0._060_.A_N 0.12024f
C4158 JNWTR_ORX1_CV_0.A a_3074_4904# 0.02142f
C4159 digital_0._065_.A2_N a_10997_386# 0.08028f
C4160 digital_0._063_.B a_13481_1474# 0.05501f
C4161 a_12391_1500# a_12959_1742# 0.1745f
C4162 a_12225_1500# a_12741_1500# 0.10591f
C4163 digital_0._113_.D digital_0._113_.RESET_B 0.0128f
C4164 a_25270_13064# a_25702_13064# 0.21349f
C4165 a_6871_412# a_7329_778# 0.02761f
C4166 digital_0._112_.D a_12741_412# 0.03721f
C4167 digital_0._115_.Q digital_0._107_.RESET_B 0.02898f
C4168 LELO_GR01_0.x8.x5.XA7.C a_26930_7013# 0.1046f
C4169 digital_0._105_.RESET_B digital_0.output10.A 0.02137f
C4170 a_14121_246# a_14229_n132# 0.05722f
C4171 digital_0._057_.D VDPWR 0.29805f
C4172 digital_0.output4.A digital_0._100_.RESET_B 0.11602f
C4173 digital_0.load_slew17.A a_12829_3676# 0.05892f
C4174 a_11931_3650# digital_0.output8.A 0.01092f
C4175 LELO_GR01_0.x8.PWRUP_N_1V8 a_16656_14644# 0.02887f
C4176 uo_out<1> uio_in<7> 0.01524f
C4177 ui_in<3> ui_in<4> 0.03102f
C4178 digital_0._116_.Q digital_0._063_.A 0.02243f
C4179 digital_0._069_.A digital_0.load_slew17.X 0.01229f
C4180 digital_0.output4.A a_4111_1474# 0.02257f
C4181 LELO_GR01_0.x8.VREF_BG a_24838_11144# 0.03116f
C4182 JNWTR_ORX1_CV_0.A a_23334_13064# 0.04368f
C4183 LELO_GR01_0.x7.x15.I2 LELO_GR01_0.x7.x28.e 0.20672f
C4184 LELO_GR01_0.x7.x11.P a_26806_16564# 0.01958f
C4185 LELO_GR01_0.x7.x7.G a_7148_9234# 0.05006f
C4186 digital_0.clkload0.A a_12391_412# 0.42157f
C4187 a_6098_4904# VDPWR 0.01883f
C4188 LELO_GR01_0.x7.x29.N LELO_GR01_0.x7.x29.P 1.20691f
C4189 digital_0._113_.Q digital_0._057_.D 0.83281f
C4190 a_11949_3132# VDPWR 0.41107f
C4191 digital_0._115_.Q a_6705_412# 0.02557f
C4192 a_15413_1260# VDPWR 0.42403f
C4193 digital_0._060_.A_N uio_out<7> 0.01067f
C4194 a_8689_n676# uio_out<7> 0.12677f
C4195 a_12737_n676# VDPWR 0.21266f
C4196 digital_0._109_.RESET_B a_7970_2588# 0.23165f
C4197 LELO_GR01_0.x7.x10.P uio_out<0> 0.04851f
C4198 digital_0._108_.D a_6455_3452# 0.08622f
C4199 digital_0.output6.A a_5787_2146# 0.07057f
C4200 a_27638_11144# uo_out<0> 0.01234f
C4201 a_7580_11154# LELO_GR01_0.x7.x3.P 0.22899f
C4202 a_7717_3926# VDPWR 0.37235f
C4203 a_14319_3828# uio_out<2> 0.01208f
C4204 digital_0.input2.X a_3982_386# 0.01632f
C4205 a_5661_1260# a_5486_1334# 0.23366f
C4206 a_20372_10347# a_22292_9915# 0.01515f
C4207 digital_0.clkbuf_1_1__f_clk.A VDPWR 2.96746f
C4208 a_12391_412# a_12646_412# 0.05639f
C4209 digital_0._112_.RESET_B a_15427_386# 0.07401f
C4210 a_14624_386# a_14750_570# 0.34134f
C4211 a_3471_1474# uo_out<1> 0.01581f
C4212 digital_0.load_slew17.X clk 0.02208f
C4213 digital_0.output10.A a_12626_n676# 0.0456f
C4214 a_6451_n676# a_6687_n676# 0.22264f
C4215 digital_0._105_.RESET_B VDPWR 0.52195f
C4216 digital_0.clkbuf_1_0__f_clk.X digital_0.output13.A 0.18952f
C4217 digital_0._111_.Q a_11273_3436# 0.01945f
C4218 LELO_GR01_0.x8.VREF_BG uio_out<7> 0.15309f
C4219 JNWTR_ORX1_CV_0.A uo_out<1> 0.11286f
C4220 a_3743_3138# a_4658_3510# 0.12532f
C4221 LELO_GR01_0.x8.IBP_BG uio_out<4> 0.92674f
C4222 JNWTR_TIEL_CV_0.Y uo_out<0> 0.02633f
C4223 digital_0._069_.A a_6179_3132# 0.01076f
C4224 LELO_GR01_0.x8.VREF_BG a_22698_16564# 0.06458f
C4225 digital_0._116_.Q digital_0._060_.A_N 0.21917f
C4226 digital_0._063_.B a_12741_1500# 0.03579f
C4227 a_12225_1500# digital_0._113_.RESET_B 0.29446f
C4228 digital_0.clkbuf_1_1__f_clk.A digital_0._113_.Q 0.06071f
C4229 digital_0._112_.D digital_0._112_.RESET_B 0.50234f
C4230 a_6871_412# a_7126_412# 0.05936f
C4231 digital_0._060_.A_N digital_0._107_.RESET_B 0.01882f
C4232 LELO_GR01_0.x8.x5.XA7.CN a_26930_7333# 0.04767f
C4233 LELO_GR01_0.x8.x5.XA7.C a_26090_7013# 0.09819f
C4234 digital_0._105_.RESET_B a_14229_n132# 0.01234f
C4235 a_10997_386# VDPWR 0.44744f
C4236 a_4354_3834# digital_0._117_.RESET_B 0.01296f
C4237 a_4594_3650# digital_0._100_.RESET_B 0.01476f
C4238 digital_0.load_slew17.A a_12718_3676# 0.05028f
C4239 JNWTR_ORX1_CV_0.A a_3492_n702# 0.09089f
C4240 a_11931_3650# a_12189_3650# 0.22264f
C4241 LELO_GR01_0.x7.x1.x5.x9<2>.G a_9734_16926# 0.07164f
C4242 LELO_GR01_0.PWRUP_1V8 a_17304_16564# 0.03068f
C4243 uo_out<1> uio_in<6> 0.01524f
C4244 digital_0._069_.A digital_0._063_.A 0.05653f
C4245 a_4512_2954# a_4726_2954# 0.09774f
C4246 a_4581_2825# a_5144_2954# 0.04983f
C4247 digital_0._111_.Q a_10721_2348# 0.12856f
C4248 a_25510_16564# uo_out<0> 0.01628f
C4249 digital_0.output4.A a_4015_1652# 0.0215f
C4250 JNWTR_ORX1_CV_0.A a_23118_11144# 0.03934f
C4251 LELO_GR01_0.x8.VREF_BG a_23982_11144# 0.02375f
C4252 a_22914_14644# a_23346_14644# 0.14233f
C4253 digital_0.clkload0.A a_12225_412# 0.46589f
C4254 a_17508_11144# a_18156_11144# 0.06667f
C4255 digital_0._080_.A2 digital_0._116_.SET_B 0.01838f
C4256 a_3938_4904# a_4370_4904# 0.14233f
C4257 a_14673_1334# VDPWR 0.20848f
C4258 LELO_GR01_0.x8.x5.CK a_26086_4851# 0.01343f
C4259 LELO_GR01_0.x7.x1.x5.x6.N LELO_GR01_0.x7.x1.x5.x8.G 2.32381f
C4260 LELO_GR01_0.x7.x1.x5.x8.S a_6636_16210# 0.3991f
C4261 a_8578_n676# uio_out<7> 0.04362f
C4262 a_12626_n676# VDPWR 0.22031f
C4263 a_4833_3436# a_4512_2954# 0.0119f
C4264 digital_0._109_.RESET_B a_8145_2562# 0.27859f
C4265 digital_0._116_.Q digital_0._110_.RESET_B 0.10541f
C4266 digital_0._111_.Q digital_0.input1.X 0.1283f
C4267 LELO_GR01_0.x7.x10.P a_21834_16564# 0.02289f
C4268 digital_0._118_.RESET_B a_5486_1334# 0.22627f
C4269 a_26782_11144# uo_out<0> 0.02762f
C4270 JNWTR_ORX1_CV_0.A LELO_GR01_0.x8.x1.x5.x9<2>.G 0.10804f
C4271 LELO_GR01_0.x7.x15.I1 a_8228_9234# 0.02669f
C4272 digital_0.output7.A uio_out<2> 0.01528f
C4273 digital_0.hold23.X a_14323_962# 0.03307f
C4274 digital_0._109_.D VDPWR 0.37332f
C4275 a_12225_412# a_12646_412# 0.08671f
C4276 digital_0._112_.RESET_B a_15331_564# 0.062f
C4277 a_6315_1474# VDPWR 1.29194f
C4278 LELO_GR01_0.x8.x1.x5.x9<2>.G a_21554_6773# 0.07821f
C4279 a_26090_8613# a_26090_8293# 0.01f
C4280 a_26930_8613# LELO_GR01_0.x8.x5.XA5.A 0.05912f
C4281 digital_0.output10.A a_12409_n676# 0.05432f
C4282 a_14339_n158# VDPWR 0.20793f
C4283 LELO_GR01_0.x8.IBP_BG uio_out<2> 0.28744f
C4284 JNWTR_ORX1_CV_0.A uio_out<0> 0.19138f
C4285 LELO_GR01_0.x8.VREF_BG uio_out<1> 0.02427f
C4286 a_28996_19150# VDPWR 0.40199f
C4287 a_3743_3138# a_4833_3436# 0.04251f
C4288 a_4311_3106# a_4093_3510# 0.20964f
C4289 a_14415_3650# a_14029_3510# 0.01674f
C4290 LELO_GR01_0.x8.IBP_BG a_22266_16564# 0.0466f
C4291 JNWTR_ORX1_CV_0.A a_2858_4904# 0.02154f
C4292 a_27670_16564# a_28102_16564# 0.21349f
C4293 digital_0._063_.B digital_0._113_.RESET_B 0.46526f
C4294 digital_0._113_.D a_12391_1500# 0.22012f
C4295 a_12225_1500# a_12959_1742# 0.05348f
C4296 a_24508_6687# VDPWR 0.40196f
C4297 a_25054_11144# a_25486_11144# 0.14233f
C4298 digital_0._112_.D a_12959_654# 0.02423f
C4299 a_6705_412# a_7126_412# 0.09313f
C4300 a_8684_6824# a_9116_6824# 0.21349f
C4301 LELO_GR01_0.x8.x5.XA7.CN a_26090_7333# 0.04737f
C4302 LELO_GR01_0.x8.x5.XA7.C a_26930_7333# 0.06658f
C4303 a_14339_n158# a_14229_n132# 0.09774f
C4304 a_9810_412# VDPWR 0.29391f
C4305 digital_0.load_slew17.A a_12501_3676# 0.05256f
C4306 LELO_GR01_0.x7.x1.x5.x9<2>.G a_8336_16210# 0.0408f
C4307 uo_out<1> uio_in<5> 0.01524f
C4308 uo_out<0> uio_in<7> 0.03102f
C4309 ui_in<2> ui_in<3> 0.02544f
C4310 digital_0.load_slew15.X digital_0.load_slew17.X 0.06339f
C4311 a_4425_2730# a_5144_2954# 0.09016f
C4312 a_4581_2825# a_4726_2954# 0.05722f
C4313 a_23562_16564# uio_out<5> 0.02195f
C4314 a_25294_14644# uo_out<0> 0.01016f
C4315 LELO_GR01_0.x7.x15.I2 a_14358_10740# 0.03225f
C4316 digital_0.clkload0.A digital_0.clkload0.X 0.07299f
C4317 digital_0.input1.X a_5785_n426# 0.04141f
C4318 a_14891_930# VDPWR 0.21146f
C4319 LELO_GR01_0.x7.x1.x5.x8.S LELO_GR01_0.x7.x1.x5.x8.G 3.06086f
C4320 LELO_GR01_0.PWRUP_1V8 a_21252_18378# 0.06193f
C4321 a_8361_n676# uio_out<7> 0.04389f
C4322 a_12409_n676# VDPWR 0.23642f
C4323 digital_0._109_.RESET_B a_7405_2588# 0.16304f
C4324 a_16440_16564# VDPWR 0.01613f
C4325 digital_0.clkbuf_1_0__f_clk.X a_5834_2740# 0.0136f
C4326 a_4477_2044# digital_0.output6.A 0.02655f
C4327 digital_0._118_.RESET_B a_5661_1260# 0.27681f
C4328 a_7364_9234# a_7796_9234# 0.14233f
C4329 a_7148_9234# a_8228_9234# 0.0381f
C4330 LELO_GR01_0.x8.VREF_BG LELO_GR01_0.x8.x1.x5.IBN 0.70178f
C4331 a_7181_3926# VDPWR 0.3936f
C4332 a_13978_3650# uio_out<2> 0.01362f
C4333 digital_0.output7.A uio_out<3> 0.0113f
C4334 digital_0.hold23.X a_14157_962# 0.04872f
C4335 digital_0._104_.D a_14323_962# 0.25815f
C4336 a_5139_930# a_5486_1334# 0.05116f
C4337 digital_0._112_.RESET_B JNWTR_IVX1_CV_0.Y 0.12764f
C4338 a_4730_1652# VDPWR 0.11178f
C4339 a_20156_7909# a_19706_7559# 0.01328f
C4340 a_26090_8613# LELO_GR01_0.x8.x5.XA5.A 0.06582f
C4341 digital_0.output10.A a_12138_n702# 0.21927f
C4342 a_13771_n126# VDPWR 0.34252f
C4343 a_3577_3138# a_4658_3510# 0.10236f
C4344 LELO_GR01_0.x8.IBP_BG uio_out<3> 4.85121f
C4345 a_3743_3138# a_4093_3510# 0.2298f
C4346 JNWTR_ORX1_CV_0.A uo_out<0> 0.02495f
C4347 digital_0.output7.A a_14769_3436# 0.10784f
C4348 digital_0._103_.RESET_B digital_0._067_.A 0.01925f
C4349 LELO_GR01_0.x8.IBP_BG a_22050_14644# 0.02573f
C4350 digital_0.output13.A digital_0._115_.RESET_B 0.03636f
C4351 digital_0._109_.Q a_5785_1750# 0.04897f
C4352 a_12225_1500# a_12391_1500# 0.57808f
C4353 digital_0._063_.B a_12959_1742# 0.02229f
C4354 LELO_GR01_0.x8.x7.D VDPWR 1.28065f
C4355 digital_0.load_slew15.X a_9151_n702# 0.02441f
C4356 digital_0._112_.D a_12391_412# 0.22499f
C4357 digital_0._113_.Q a_13771_n126# 0.04626f
C4358 uio_oe<7> VGND 0.0768f
C4359 uio_oe<6> VGND 0.03897f
C4360 uio_oe<5> VGND 0.03918f
C4361 uio_oe<4> VGND 0.03876f
C4362 uio_oe<3> VGND 0.03938f
C4363 uio_oe<2> VGND 0.04022f
C4364 uio_oe<1> VGND 0.03876f
C4365 uio_oe<0> VGND 0.03918f
C4366 uo_out<7> VGND 0.04632f
C4367 uo_out<6> VGND 0.04764f
C4368 uo_out<5> VGND 0.04771f
C4369 uo_out<4> VGND 0.04771f
C4370 uo_out<3> VGND 0.04592f
C4371 uo_out<2> VGND 0.04645f
C4372 uio_in<7> VGND 0.03939f
C4373 uio_in<6> VGND 0.04046f
C4374 uio_in<5> VGND 0.03907f
C4375 uio_in<4> VGND 0.04184f
C4376 uio_in<3> VGND 0.04184f
C4377 uio_in<2> VGND 0.04012f
C4378 uio_in<1> VGND 0.03934f
C4379 uio_in<0> VGND 0.04106f
C4380 ui_in<7> VGND 0.04106f
C4381 ui_in<6> VGND 0.04123f
C4382 ui_in<5> VGND 0.04107f
C4383 ui_in<4> VGND 0.04107f
C4384 ui_in<3> VGND 0.04245f
C4385 ui_in<2> VGND 0.03679f
C4386 ena VGND 0.06012f
C4387 uio_out<6> VGND 9.56845f
C4388 uio_out<5> VGND 6.38595f
C4389 uio_out<7> VGND 10.461f
C4390 uio_out<1> VGND 6.13544f
C4391 clk VGND 6.99873f
C4392 uio_out<4> VGND 7.72964f
C4393 uio_out<2> VGND 3.17681f
C4394 uio_out<3> VGND 6.62217f
C4395 uo_out<1> VGND 12.6853f
C4396 uio_out<0> VGND 11.791f
C4397 uo_out<0> VGND 22.6236f
C4398 ui_in<1> VGND 5.54596f
C4399 ui_in<0> VGND 6.79151f
C4400 rst_n VGND 9.22716f
C4401 VDPWR VGND 0.42841p
C4402 m4_29318_19972# VGND 0.01451f $ **FLOATING
C4403 m1_7720_5850# VGND 0.12028f $ **FLOATING
C4404 a_15537_n426# VGND 0.01494f
C4405 a_14175_n702# VGND 0.3147f
C4406 digital_0.hold27.X VGND 0.59107f
C4407 a_10495_n702# VGND 0.31404f
C4408 digital_0.hold21.X VGND 0.47222f
C4409 a_7643_n702# VGND 0.36371f
C4410 digital_0.hold26.X VGND 0.46166f
C4411 a_5785_n426# VGND 0.01076f
C4412 a_15225_n702# VGND 0.42479f
C4413 a_14967_n702# VGND 0.39137f
C4414 a_14871_n524# VGND 0.23649f
C4415 a_13746_n524# VGND 0.27032f
C4416 a_12737_n676# VGND 0.28608f
C4417 a_12626_n676# VGND 0.27917f
C4418 a_12409_n676# VGND 0.2787f
C4419 a_12138_n702# VGND 0.29021f
C4420 a_11898_n518# VGND 0.29295f
C4421 a_11772_n702# VGND 0.2875f
C4422 a_11361_n702# VGND 0.36858f
C4423 a_11103_n702# VGND 0.37303f
C4424 a_11007_n524# VGND 0.22498f
C4425 a_10066_n524# VGND 0.28231f
C4426 a_9417_n702# VGND 0.24798f
C4427 a_9151_n702# VGND 0.33481f
C4428 a_8689_n676# VGND 0.27576f
C4429 a_8578_n676# VGND 0.27679f
C4430 a_8361_n676# VGND 0.33145f
C4431 a_7214_n524# VGND 0.278f
C4432 a_6793_n676# VGND 0.27569f
C4433 a_6687_n676# VGND 0.40523f
C4434 a_6451_n676# VGND 0.38575f
C4435 a_5974_n676# VGND 0.32421f
C4436 digital_0.hold18.X VGND 0.34102f
C4437 a_5422_n702# VGND 0.34104f
C4438 a_5182_n518# VGND 0.29265f
C4439 a_5056_n702# VGND 0.28906f
C4440 a_4585_n676# VGND 0.24548f
C4441 a_4479_n676# VGND 0.40189f
C4442 a_4243_n676# VGND 0.39528f
C4443 a_3858_n702# VGND 0.30651f
C4444 a_3618_n518# VGND 0.30174f
C4445 a_3492_n702# VGND 0.3124f
C4446 a_15537_n132# VGND 0.01142f
C4447 a_18068_236# VGND 0.08313f $ **FLOATING
C4448 a_17228_236# VGND 0.37057f $ **FLOATING
C4449 digital_0.output10.A VGND 1.55595f
C4450 a_14026_234# VGND 0.07881f
C4451 a_12116_188# VGND 0.30385f
C4452 digital_0.output11.A VGND 0.56779f
C4453 a_9886_234# VGND 0.08173f
C4454 a_7720_n132# VGND 0.08081f
C4455 digital_0.output12.A VGND 0.75099f
C4456 a_5328_n132# VGND 0.07467f
C4457 a_14686_246# VGND 0.27529f
C4458 a_14861_172# VGND 0.60564f
C4459 a_14121_246# VGND 0.2656f
C4460 digital_0._105_.RESET_B VGND 0.6992f
C4461 a_14339_n158# VGND 0.18923f
C4462 a_13771_n126# VGND 0.31384f
C4463 digital_0._105_.D VGND 0.33255f
C4464 a_13605_n126# VGND 0.60689f
C4465 a_12903_206# VGND 0.33203f
C4466 a_11758_188# VGND 0.47541f
C4467 a_10546_246# VGND 0.27746f
C4468 a_10721_172# VGND 0.59147f
C4469 a_9981_246# VGND 0.26437f
C4470 digital_0._106_.RESET_B VGND 0.78864f
C4471 a_10199_n158# VGND 0.18517f
C4472 a_9631_n126# VGND 0.30651f
C4473 digital_0._106_.D VGND 0.36472f
C4474 a_9465_n126# VGND 0.68929f
C4475 a_8689_n132# VGND 0.27577f
C4476 a_8578_n132# VGND 0.27413f
C4477 a_8361_n132# VGND 0.32769f
C4478 digital_0._107_.D VGND 0.29978f
C4479 a_7088_n132# VGND 0.19661f
C4480 a_7157_n158# VGND 0.27362f
C4481 a_6962_n16# VGND 0.33794f
C4482 a_7001_110# VGND 0.60301f
C4483 digital_0._107_.RESET_B VGND 1.28428f
C4484 a_6684_0# VGND 0.31601f
C4485 a_6397_n158# VGND 0.62005f
C4486 a_4696_n132# VGND 0.18571f
C4487 a_4765_n158# VGND 0.25986f
C4488 a_4570_n16# VGND 0.29681f
C4489 a_4609_110# VGND 0.54783f
C4490 digital_0._119_.RESET_B VGND 0.769f
C4491 a_4292_0# VGND 0.2707f
C4492 a_4005_n158# VGND 0.58534f
C4493 a_18068_556# VGND 0.08126f $ **FLOATING
C4494 a_17228_556# VGND 0.34648f $ **FLOATING
C4495 a_12646_412# VGND 0.07397f
C4496 a_15685_386# VGND 0.40086f
C4497 a_15427_386# VGND 0.37199f
C4498 a_15331_564# VGND 0.21632f
C4499 JNWTR_IVX1_CV_0.Y VGND 2.30944f
C4500 a_14990_386# VGND 0.27022f
C4501 a_14750_570# VGND 0.27166f
C4502 a_14624_386# VGND 0.27946f
C4503 a_13306_412# VGND 0.26074f
C4504 a_13481_386# VGND 0.59282f
C4505 a_12741_412# VGND 0.27053f
C4506 digital_0._112_.RESET_B VGND 1.51987f
C4507 a_12959_654# VGND 0.17859f
C4508 a_12391_412# VGND 0.30061f
C4509 a_12225_412# VGND 0.57364f
C4510 digital_0.clkload0.X VGND 0.23313f
C4511 a_9150_412# VGND 0.07837f
C4512 a_11673_412# VGND 0.52256f
C4513 digital_0._057_.D VGND 1.69529f
C4514 a_10997_386# VGND 0.36441f
C4515 a_9810_412# VGND 0.25807f
C4516 a_9985_386# VGND 0.57268f
C4517 a_9245_412# VGND 0.25789f
C4518 a_9463_654# VGND 0.17911f
C4519 a_8895_412# VGND 0.30005f
C4520 digital_0._114_.D VGND 0.45346f
C4521 a_8729_412# VGND 0.61442f
C4522 a_7126_412# VGND 0.0958f
C4523 a_7786_412# VGND 0.26279f
C4524 a_7961_386# VGND 0.60533f
C4525 a_7221_412# VGND 0.26714f
C4526 a_7439_654# VGND 0.17973f
C4527 a_6871_412# VGND 0.32456f
C4528 a_6705_412# VGND 0.6975f
C4529 a_6209_386# VGND 0.38951f
C4530 a_5951_386# VGND 0.37918f
C4531 a_5855_564# VGND 0.23837f
C4532 a_5218_778# VGND 0.09916f
C4533 digital_0._116_.D VGND 0.32309f
C4534 a_4746_412# VGND 0.18058f
C4535 a_4610_386# VGND 0.43371f
C4536 a_4438_386# VGND 0.54991f
C4537 a_4530_626# VGND 0.49968f
C4538 a_4118_412# VGND 0.17894f
C4539 digital_0._116_.SET_B VGND 1.48737f
C4540 a_3982_386# VGND 0.40804f
C4541 a_3814_386# VGND 0.3194f
C4542 a_14578_1322# VGND 0.08f
C4543 digital_0._112_.D VGND 1.26793f
C4544 a_10555_956# VGND 0.01346f
C4545 digital_0._060_.B VGND 0.35144f
C4546 a_7099_956# VGND 0.01146f
C4547 digital_0._114_.RESET_B VGND 0.61671f
C4548 a_7375_1276# VGND 0.32549f
C4549 digital_0._115_.D VGND 0.46648f
C4550 digital_0.hold28.X VGND 0.45262f
C4551 a_4826_1322# VGND 0.07386f
C4552 digital_0._080_.A2 VGND 0.50629f
C4553 a_15238_1334# VGND 0.27003f
C4554 a_15413_1260# VGND 0.60407f
C4555 a_14673_1334# VGND 0.26568f
C4556 a_14891_930# VGND 0.18283f
C4557 a_14323_962# VGND 0.3019f
C4558 a_14157_962# VGND 0.68261f
C4559 a_11388_956# VGND 2.01117f
C4560 digital_0._114_.Q VGND 1.58957f
C4561 a_10253_930# VGND 0.59813f
C4562 a_9930_930# VGND 0.32958f
C4563 a_9690_1194# VGND 0.27908f
C4564 a_9564_930# VGND 0.27435f
C4565 digital_0._115_.Q VGND 1.39174f
C4566 digital_0._060_.A_N VGND 1.84623f
C4567 a_7155_930# VGND 0.52435f
C4568 a_6761_930# VGND 0.39811f
C4569 a_6503_930# VGND 0.3832f
C4570 a_6407_1188# VGND 0.23339f
C4571 a_5486_1334# VGND 0.25799f
C4572 a_5661_1260# VGND 0.58045f
C4573 a_4921_1334# VGND 0.2593f
C4574 a_5139_930# VGND 0.17482f
C4575 a_4571_962# VGND 0.29447f
C4576 a_4405_962# VGND 0.54087f
C4577 a_3858_930# VGND 0.31529f
C4578 a_3618_1194# VGND 0.27795f
C4579 a_3492_930# VGND 0.2902f
C4580 a_14727_1474# VGND 0.28053f
C4581 digital_0.hold23.X VGND 0.35651f
C4582 digital_0._104_.D VGND 0.52659f
C4583 digital_0._113_.Q VGND 1.89821f
C4584 a_12646_1500# VGND 0.07386f
C4585 digital_0.input3.X VGND 0.714f
C4586 a_15634_1474# VGND 0.30025f
C4587 a_15394_1658# VGND 0.26926f
C4588 a_15268_1474# VGND 0.27598f
C4589 a_14298_1652# VGND 0.25891f
C4590 a_13306_1500# VGND 0.2588f
C4591 a_13481_1474# VGND 0.59514f
C4592 a_12741_1500# VGND 0.25707f
C4593 digital_0._113_.RESET_B VGND 1.75192f
C4594 a_12959_1742# VGND 0.17772f
C4595 a_12391_1500# VGND 0.28801f
C4596 digital_0._113_.D VGND 0.51112f
C4597 a_12225_1500# VGND 0.52413f
C4598 digital_0._063_.B VGND 1.69791f
C4599 a_11397_1750# VGND 0.01068f
C4600 digital_0._115_.RESET_B VGND 1.73693f
C4601 a_5159_1474# VGND 0.2988f
C4602 digital_0.hold22.X VGND 0.45366f
C4603 digital_0.input2.X VGND 1.35668f
C4604 digital_0._118_.D VGND 0.71168f
C4605 a_8996_1500# VGND 1.99162f
C4606 a_8085_1500# VGND 0.54976f
C4607 digital_0.clkbuf_1_1__f_clk.A VGND 2.68776f
C4608 a_6315_1474# VGND 1.97756f
C4609 a_4730_1652# VGND 0.26363f
C4610 a_4369_1474# VGND 0.35882f
C4611 a_4111_1474# VGND 0.36806f
C4612 a_4015_1652# VGND 0.2204f
C4613 a_3471_1474# VGND 0.33905f
C4614 a_12977_2044# VGND 0.01014f
C4615 digital_0._104_.RESET_B VGND 0.80996f
C4616 digital_0.load_slew17.X VGND 2.57793f
C4617 digital_0._063_.A VGND 1.28681f
C4618 a_15773_2044# VGND 0.29274f
C4619 a_15662_2044# VGND 0.28215f
C4620 a_15445_2044# VGND 0.31595f
C4621 digital_0.output9.A VGND 0.68989f
C4622 a_14762_2018# VGND 0.32527f
C4623 a_11951_2146# VGND 0.34239f
C4624 digital_0._112_.Q VGND 1.20052f
C4625 a_9886_2410# VGND 0.08003f
C4626 a_6961_2044# VGND 0.01231f
C4627 a_6949_2422# VGND 0.01372f
C4628 a_6758_2410# VGND 0.0749f
C4629 a_11431_2382# VGND 0.33066f
C4630 a_10546_2422# VGND 0.27312f
C4631 a_10721_2348# VGND 0.60086f
C4632 a_9981_2422# VGND 0.26369f
C4633 a_10199_2018# VGND 0.1866f
C4634 a_9631_2050# VGND 0.30281f
C4635 a_9465_2050# VGND 0.68547f
C4636 a_7418_2422# VGND 0.26269f
C4637 a_7593_2348# VGND 0.58583f
C4638 a_6853_2422# VGND 0.2882f
C4639 a_7071_2018# VGND 0.19382f
C4640 a_6503_2050# VGND 0.31952f
C4641 a_6337_2050# VGND 0.61584f
C4642 a_5787_2146# VGND 0.34218f
C4643 digital_0.output6.A VGND 0.66596f
C4644 a_4274_2410# VGND 0.08f
C4645 a_4934_2422# VGND 0.26861f
C4646 a_5109_2348# VGND 0.57989f
C4647 a_4369_2422# VGND 0.26192f
C4648 a_4587_2018# VGND 0.18626f
C4649 a_4019_2050# VGND 0.3041f
C4650 digital_0._101_.D VGND 0.29628f
C4651 a_3853_2050# VGND 0.67211f
C4652 a_26146_2651# VGND 0.4961f $ **FLOATING
C4653 a_26146_3451# VGND 0.52065f $ **FLOATING
C4654 a_17850_2665# VGND 0.49615f $ **FLOATING
C4655 a_12094_2588# VGND 0.07966f
C4656 a_10571_2588# VGND 0.17588f
C4657 a_12754_2588# VGND 0.26698f
C4658 a_12929_2562# VGND 0.59871f
C4659 a_12189_2588# VGND 0.26714f
C4660 digital_0._110_.RESET_B VGND 0.91123f
C4661 a_12407_2830# VGND 0.19162f
C4662 a_11839_2588# VGND 0.30403f
C4663 a_11673_2588# VGND 0.54377f
C4664 digital_0._111_.D VGND 0.70223f
C4665 digital_0._111_.RESET_B VGND 1.02944f
C4666 a_9557_2838# VGND 0.0161f
C4667 digital_0._108_.RESET_B VGND 1.42947f
C4668 a_8837_2838# VGND 0.01556f
C4669 a_7310_2588# VGND 0.07501f
C4670 a_11107_2562# VGND 0.3138f
C4671 a_10285_2910# VGND 0.18339f
C4672 digital_0._065_.A2_N VGND 2.49966f
C4673 a_10074_2562# VGND 0.25831f
C4674 a_7970_2588# VGND 0.28385f
C4675 a_8145_2562# VGND 0.6205f
C4676 a_7405_2588# VGND 0.26624f
C4677 a_7623_2830# VGND 0.1891f
C4678 a_7055_2588# VGND 0.33316f
C4679 a_6889_2588# VGND 0.63503f
C4680 digital_0.input1.X VGND 2.70783f
C4681 a_6263_2562# VGND 0.34707f
C4682 a_5834_2740# VGND 0.26785f
C4683 a_5144_2954# VGND 0.08098f
C4684 digital_0._100_.D VGND 0.62059f
C4685 a_4512_2954# VGND 0.18654f
C4686 a_4581_2825# VGND 0.26382f
C4687 a_4425_2730# VGND 0.63718f
C4688 a_4386_2856# VGND 0.30239f
C4689 a_4108_2840# VGND 0.2756f
C4690 a_3821_2562# VGND 0.59998f
C4691 a_17850_3465# VGND 0.53302f $ **FLOATING
C4692 a_13934_3498# VGND 0.08366f
C4693 a_11949_3132# VGND 0.0165f
C4694 digital_0._110_.D VGND 0.52772f
C4695 a_7349_3132# VGND 0.02304f
C4696 a_6906_3132# VGND 0.01859f
C4697 a_10438_3498# VGND 0.07768f
C4698 a_6455_3452# VGND 0.32408f
C4699 digital_0._108_.D VGND 0.45497f
C4700 digital_0._118_.RESET_B VGND 0.64471f
C4701 digital_0._101_.RESET_B VGND 0.85322f
C4702 a_3998_3498# VGND 0.08293f
C4703 a_14594_3510# VGND 0.2911f
C4704 a_14769_3436# VGND 0.6552f
C4705 a_14029_3510# VGND 0.28204f
C4706 digital_0._102_.RESET_B VGND 0.86315f
C4707 a_14247_3106# VGND 0.20789f
C4708 a_13679_3138# VGND 0.33273f
C4709 digital_0._102_.D VGND 0.63467f
C4710 a_13513_3138# VGND 0.66587f
C4711 a_12889_3171# VGND 0.2821f
C4712 digital_0._110_.Q VGND 1.41336f
C4713 a_12635_3171# VGND 0.31586f
C4714 digital_0._067_.B VGND 0.7224f
C4715 digital_0._067_.A VGND 0.63269f
C4716 a_11098_3510# VGND 0.28501f
C4717 a_11273_3436# VGND 0.60288f
C4718 a_10533_3510# VGND 0.26892f
C4719 a_10751_3106# VGND 0.19476f
C4720 a_10183_3138# VGND 0.32608f
C4721 a_10017_3138# VGND 0.62949f
C4722 digital_0.clkload0.A VGND 3.18997f
C4723 digital_0._109_.Q VGND 0.97292f
C4724 digital_0.output13.A VGND 2.95996f
C4725 digital_0._108_.Q VGND 2.80247f
C4726 a_6235_3106# VGND 0.52699f
C4727 a_4658_3510# VGND 0.2814f
C4728 a_4833_3436# VGND 0.59921f
C4729 a_4093_3510# VGND 0.27298f
C4730 a_4311_3106# VGND 0.19446f
C4731 a_3743_3138# VGND 0.33158f
C4732 digital_0.hold19.X VGND 0.40928f
C4733 a_3577_3138# VGND 0.70753f
C4734 digital_0.clkbuf_1_0__f_clk.X VGND 3.25612f
C4735 digital_0.hold24.X VGND 1.17441f
C4736 a_11415_3650# VGND 0.28102f
C4737 digital_0._111_.Q VGND 0.83961f
C4738 digital_0.hold20.X VGND 0.42338f
C4739 digital_0.hold28.A VGND 4.04616f
C4740 digital_0._103_.D VGND 0.85559f
C4741 digital_0._103_.RESET_B VGND 0.8416f
C4742 digital_0._109_.RESET_B VGND 1.07576f
C4743 a_7717_3926# VGND 0.0175f
C4744 digital_0._109_.D VGND 0.71886f
C4745 a_7181_3926# VGND 0.01811f
C4746 digital_0._117_.RESET_B VGND 1.28752f
C4747 digital_0._100_.RESET_B VGND 1.15642f
C4748 digital_0.hold25.X VGND 0.69049f
C4749 a_14673_3650# VGND 0.42747f
C4750 a_14415_3650# VGND 0.39523f
C4751 a_14319_3828# VGND 0.2339f
C4752 digital_0.output7.A VGND 1.07161f
C4753 a_13978_3650# VGND 0.27636f
C4754 a_13738_3834# VGND 0.28304f
C4755 a_13612_3650# VGND 0.28408f
C4756 a_12829_3676# VGND 0.2867f
C4757 a_12718_3676# VGND 0.28848f
C4758 a_12501_3676# VGND 0.28769f
C4759 digital_0.output8.A VGND 0.93677f
C4760 a_12189_3650# VGND 0.37903f
C4761 a_11931_3650# VGND 0.39671f
C4762 a_11835_3828# VGND 0.24197f
C4763 a_10986_3828# VGND 0.28062f
C4764 digital_0.load_slew17.A VGND 3.09899f
C4765 digital_0.load_slew15.A VGND 2.09697f
C4766 digital_0._116_.Q VGND 6.93488f
C4767 digital_0._069_.A VGND 3.38437f
C4768 digital_0._069_.B VGND 0.76317f
C4769 digital_0.load_slew15.X VGND 4.48206f
C4770 a_5321_3676# VGND 0.23477f
C4771 a_5215_3676# VGND 0.39599f
C4772 a_4979_3676# VGND 0.3916f
C4773 digital_0.output4.A VGND 1.08696f
C4774 a_4594_3650# VGND 0.30015f
C4775 a_4354_3834# VGND 0.28958f
C4776 a_4228_3650# VGND 0.28681f
C4777 digital_0.output5.A VGND 0.55109f
C4778 a_3858_3650# VGND 0.28214f
C4779 a_3618_3834# VGND 0.28038f
C4780 a_3492_3650# VGND 0.29372f
C4781 a_26926_4531# VGND 0.08273f $ **FLOATING
C4782 a_26086_4531# VGND 0.37817f $ **FLOATING
C4783 a_26926_4851# VGND 0.05419f $ **FLOATING
C4784 a_26086_4851# VGND 0.33527f $ **FLOATING
C4785 a_24510_4435# VGND 0.53896f $ **FLOATING
C4786 a_24510_5235# VGND 0.47456f $ **FLOATING
C4787 a_19356_4659# VGND 0.53678f $ **FLOATING
C4788 a_26928_5351# VGND 0.05422f $ **FLOATING
C4789 a_26088_5351# VGND 0.34646f $ **FLOATING
C4790 LELO_GR01_0.x8.x3.A VGND 1.11864f
C4791 a_19356_5459# VGND 0.52649f $ **FLOATING
C4792 a_26928_5671# VGND 0.05685f $ **FLOATING
C4793 a_26088_5671# VGND 0.33398f $ **FLOATING
C4794 a_24508_5627# VGND 0.42047f $ **FLOATING
C4795 a_26930_6213# VGND 0.05804f $ **FLOATING
C4796 a_26090_6213# VGND 0.41859f $ **FLOATING
C4797 a_24508_6427# VGND 0.36248f $ **FLOATING
C4798 a_23138_5627# VGND 0.49653f $ **FLOATING
C4799 a_23138_6427# VGND 0.36615f $ **FLOATING
C4800 a_21558_5709# VGND 0.52382f $ **FLOATING
C4801 a_26090_6533# VGND 0.40042f $ **FLOATING
C4802 a_21558_6509# VGND 0.48005f $ **FLOATING
C4803 a_20156_5709# VGND 0.54389f $ **FLOATING
C4804 a_20156_6509# VGND 0.51027f $ **FLOATING
C4805 a_18756_5709# VGND 0.53141f $ **FLOATING
C4806 a_18756_6509# VGND 0.51605f $ **FLOATING
C4807 LELO_GR01_0.x8.x5.CK VGND 5.30256f
C4808 LELO_GR01_0.x8.x5.XA1.MN1.S VGND 0.09685f
C4809 a_26090_7013# VGND 0.31073f $ **FLOATING
C4810 a_26090_7333# VGND 0.31349f $ **FLOATING
C4811 a_24508_6687# VGND 0.04081f $ **FLOATING
C4812 LELO_GR01_0.x8.x7.D VGND 2.14417f
C4813 a_24508_7487# VGND 0.05146f $ **FLOATING
C4814 a_23138_6685# VGND 0.04601f $ **FLOATING
C4815 a_23138_7485# VGND 0.0513f $ **FLOATING
C4816 a_21554_6773# VGND 0.4626f $ **FLOATING
C4817 LELO_GR01_0.x8.x5.XA3.MN1.S VGND 0.09448f
C4818 a_21554_7573# VGND 0.45893f $ **FLOATING
C4819 a_19706_6759# VGND 0.45452f $ **FLOATING
C4820 a_19706_7559# VGND 0.40866f $ **FLOATING
C4821 a_26090_7813# VGND 0.31584f $ **FLOATING
C4822 LELO_GR01_0.x8.x5.XA4.MN1.S VGND 0.08682f
C4823 a_26090_8293# VGND 0.31036f $ **FLOATING
C4824 LELO_GR01_0.x8.x5.XA5.A VGND 0.98063f
C4825 a_26090_8613# VGND 0.31386f $ **FLOATING
C4826 a_23816_7741# VGND 0.01454f $ **FLOATING
C4827 LELO_GR01_0.x8.x1.x7.D VGND 1.24868f
C4828 a_23816_8541# VGND 0.07131f $ **FLOATING
C4829 a_21554_7825# VGND 0.45845f $ **FLOATING
C4830 LELO_GR01_0.x8.x1.x5.IBN VGND 4.42608f
C4831 a_21554_8625# VGND 0.4857f $ **FLOATING
C4832 a_20156_7909# VGND 0.08029f $ **FLOATING
C4833 LELO_GR01_0.x8.x5.XA6.A VGND 0.95452f
C4834 LELO_GR01_0.x8.x1.x5.x9<2>.G VGND 17.5145f
C4835 a_20156_8709# VGND 0.10069f $ **FLOATING
C4836 a_18456_7909# VGND 0.09539f $ **FLOATING
C4837 LELO_GR01_0.x8.x1.x5.x8.G VGND 5.0504f
C4838 a_18456_8709# VGND 0.07526f $ **FLOATING
C4839 a_11060_4904# VGND 1.93621f $ **FLOATING
C4840 a_10628_4904# VGND 0.53486f
C4841 a_10412_6824# VGND 0.65704f
C4842 a_10196_4904# VGND 0.43951f
C4843 a_9980_6824# VGND 0.65617f
C4844 a_9764_4904# VGND 0.43826f
C4845 a_9548_6824# VGND 0.65537f
C4846 a_9332_4904# VGND 0.43806f
C4847 a_9116_6824# VGND 0.65537f
C4848 a_8900_4904# VGND 0.43801f
C4849 a_8684_6824# VGND 0.65537f
C4850 a_8468_4904# VGND 0.43806f
C4851 a_8252_6824# VGND 0.65537f
C4852 a_8036_4904# VGND 0.43742f
C4853 a_7820_6824# VGND 0.65537f
C4854 a_7604_4904# VGND 0.53132f
C4855 a_7388_4904# VGND 1.85075f $ **FLOATING
C4856 a_6530_4904# VGND 1.85291f $ **FLOATING
C4857 LELO_GR01_0.x7.x31.N VGND 2.27863f
C4858 a_6098_4904# VGND 0.53139f
C4859 a_5882_6824# VGND 0.71483f
C4860 a_5666_4904# VGND 0.43742f
C4861 a_5450_6824# VGND 0.71483f
C4862 a_5234_4904# VGND 0.43742f
C4863 a_5018_6824# VGND 0.71483f
C4864 a_4802_4904# VGND 0.43742f
C4865 a_4586_6824# VGND 0.68272f
C4866 a_4370_4904# VGND 0.43742f
C4867 a_4154_6824# VGND 0.64358f
C4868 a_3938_4904# VGND 0.43742f
C4869 a_3722_6824# VGND 0.6433f
C4870 a_3506_4904# VGND 0.43742f
C4871 a_3290_6824# VGND 0.64498f
C4872 a_3074_4904# VGND 0.53183f
C4873 a_2858_4904# VGND 1.89381f $ **FLOATING
C4874 a_2478_8440# VGND 0.11928f $ **FLOATING
C4875 LELO_GR01_0.x8.x5.XA6.MN1.S VGND 0.08222f
C4876 a_26090_9093# VGND 0.31602f $ **FLOATING
C4877 LELO_GR01_0.x8.x5.XA7.MN0.S VGND 0.0979f
C4878 LELO_GR01_0.x8.x5.XA7.MP1.S VGND 0.12129f
C4879 LELO_GR01_0.x8.x5.XA7.CN VGND 1.44475f
C4880 LELO_GR01_0.x8.x5.XA7.C VGND 2.58683f
C4881 a_26090_9733# VGND 0.3119f $ **FLOATING
C4882 LELO_GR01_0.x8.x5.Q VGND 0.676f
C4883 a_26930_10053# VGND 0.08336f $ **FLOATING
C4884 a_26090_10053# VGND 0.34864f $ **FLOATING
C4885 a_23824_9183# VGND 0.0717f $ **FLOATING
C4886 a_23824_9983# VGND 0.09686f $ **FLOATING
C4887 a_20372_9267# VGND 1.81325f $ **FLOATING
C4888 a_22292_9483# VGND 0.53632f
C4889 a_20372_9699# VGND 0.63171f
C4890 a_22292_9915# VGND 0.53632f
C4891 a_20372_10347# VGND 1.86823f $ **FLOATING
C4892 a_18456_9509# VGND 0.07658f $ **FLOATING
C4893 a_18456_10309# VGND 0.09896f $ **FLOATING
C4894 a_14358_9800# VGND 0.09768f $ **FLOATING
C4895 a_29582_11144# VGND 1.93328f $ **FLOATING
C4896 a_29150_11144# VGND 0.58882f
C4897 a_28934_13064# VGND 0.66729f
C4898 a_28718_11144# VGND 0.51196f
C4899 a_28502_13064# VGND 0.77053f
C4900 a_28286_11144# VGND 0.51428f
C4901 a_28070_13064# VGND 0.70074f
C4902 a_27854_11144# VGND 0.55891f
C4903 a_27638_11144# VGND 1.8955f $ **FLOATING
C4904 a_26782_11144# VGND 1.8706f $ **FLOATING
C4905 LELO_GR01_0.x7.x26.P VGND 2.10449f
C4906 a_26350_11144# VGND 0.53025f
C4907 a_26134_13064# VGND 0.63194f
C4908 a_25918_11144# VGND 0.43595f
C4909 a_25702_13064# VGND 0.63194f
C4910 a_25486_11144# VGND 0.43595f
C4911 a_25270_13064# VGND 0.63194f
C4912 a_25054_11144# VGND 0.52983f
C4913 a_24838_11144# VGND 1.86402f $ **FLOATING
C4914 a_23982_11144# VGND 1.87063f $ **FLOATING
C4915 a_23550_11144# VGND 0.53473f
C4916 a_23334_13064# VGND 0.64234f
C4917 a_23118_11144# VGND 0.51152f
C4918 a_22902_13064# VGND 0.71634f
C4919 a_22686_11144# VGND 0.60167f
C4920 a_22470_13064# VGND 0.63355f
C4921 a_22254_11144# VGND 0.5385f
C4922 a_22038_11144# VGND 1.87049f $ **FLOATING
C4923 a_21176_11144# VGND 1.796f $ **FLOATING
C4924 a_20744_11144# VGND 0.62372f
C4925 a_20528_11144# VGND 1.79601f $ **FLOATING
C4926 a_19666_11144# VGND 1.79761f $ **FLOATING
C4927 LELO_GR01_0.x7.x29.P VGND 8.6973f
C4928 a_19234_11144# VGND 0.62372f
C4929 a_19018_11144# VGND 1.7965f $ **FLOATING
C4930 a_18156_11144# VGND 1.7963f $ **FLOATING
C4931 a_17724_11144# VGND 0.62372f
C4932 a_17508_11144# VGND 1.79886f $ **FLOATING
C4933 a_16646_11144# VGND 1.81369f $ **FLOATING
C4934 LELO_GR01_0.x7.x29.N VGND 8.08216f
C4935 a_16214_11144# VGND 0.63633f
C4936 LELO_GR01_0.x7.x28.e VGND 8.41417f
C4937 a_15998_11144# VGND 1.79633f $ **FLOATING
C4938 a_11162_9234# VGND 1.90869f $ **FLOATING
C4939 a_10730_9234# VGND 0.53953f
C4940 a_10514_11154# VGND 0.65952f
C4941 a_10298_9234# VGND 0.50078f
C4942 a_10082_11154# VGND 1.09286f
C4943 a_9866_9234# VGND 0.87141f
C4944 a_9650_11154# VGND 0.97771f
C4945 a_9434_9234# VGND 0.5658f
C4946 a_9218_9234# VGND 1.8856f $ **FLOATING
C4947 a_8228_9234# VGND 1.82172f $ **FLOATING
C4948 LELO_GR01_0.x7.x3.P VGND 2.43021f
C4949 a_7796_9234# VGND 0.53518f
C4950 a_7580_11154# VGND 0.64099f
C4951 a_7364_9234# VGND 0.53688f
C4952 LELO_GR01_0.x7.x15.I1 VGND 23.9233f
C4953 a_7148_9234# VGND 1.8889f $ **FLOATING
C4954 LELO_GR01_0.x7.x30.N VGND 1.67117f
C4955 a_2478_9240# VGND 0.06519f $ **FLOATING
C4956 a_4578_9400# VGND 0.51407f $ **FLOATING
C4957 a_4578_10200# VGND 0.4881f $ **FLOATING
C4958 a_2478_9750# VGND 0.06306f $ **FLOATING
C4959 a_4578_10610# VGND 0.11513f $ **FLOATING
C4960 LELO_GR01_0.x7.x25.D VGND 0.39447f
C4961 a_2478_10550# VGND 0.0622f $ **FLOATING
C4962 a_4578_11410# VGND 0.05679f $ **FLOATING
C4963 a_2478_11060# VGND 0.06174f $ **FLOATING
C4964 a_4578_11670# VGND 0.3651f $ **FLOATING
C4965 a_14358_12620# VGND 0.0127f $ **FLOATING
C4966 a_14358_13420# VGND 0.0629f $ **FLOATING
C4967 a_11988_12620# VGND 0.11547f $ **FLOATING
C4968 LELO_GR01_0.x7.x24.D VGND 0.16253f
C4969 a_2478_11860# VGND 0.06196f $ **FLOATING
C4970 a_4578_12470# VGND 0.38763f $ **FLOATING
C4971 a_11988_13420# VGND 0.10723f $ **FLOATING
C4972 a_7536_12960# VGND 0.53503f $ **FLOATING
C4973 a_7536_13760# VGND 0.52719f $ **FLOATING
C4974 a_4578_13270# VGND 0.3874f $ **FLOATING
C4975 a_14358_13930# VGND 0.06286f $ **FLOATING
C4976 a_28750_14644# VGND 1.89395f $ **FLOATING
C4977 a_28318_14644# VGND 0.60277f
C4978 a_28102_16564# VGND 0.6342f
C4979 a_27886_14644# VGND 0.43595f
C4980 a_27670_16564# VGND 0.6342f
C4981 a_27454_14644# VGND 0.43595f
C4982 a_27238_16564# VGND 0.6342f
C4983 a_27022_14644# VGND 0.43595f
C4984 a_26806_16564# VGND 0.6342f
C4985 a_26590_14644# VGND 0.43595f
C4986 a_26374_16564# VGND 0.6342f
C4987 a_26158_14644# VGND 0.43595f
C4988 a_25942_16564# VGND 0.6342f
C4989 a_25726_14644# VGND 0.43595f
C4990 a_25510_16564# VGND 0.64152f
C4991 a_25294_14644# VGND 0.52984f
C4992 LELO_GR01_0.x7.x11.N VGND 5.51934f
C4993 a_25078_14644# VGND 1.86531f $ **FLOATING
C4994 a_24210_14644# VGND 1.86955f $ **FLOATING
C4995 a_23778_14644# VGND 0.52981f
C4996 a_23562_16564# VGND 0.63836f
C4997 a_23346_14644# VGND 0.44155f
C4998 a_23130_16564# VGND 0.6618f
C4999 a_22914_14644# VGND 0.49811f
C5000 a_22698_16564# VGND 0.67519f
C5001 a_22482_14644# VGND 0.43595f
C5002 a_22266_16564# VGND 0.63171f
C5003 a_22050_14644# VGND 0.43595f
C5004 a_21834_16564# VGND 0.63171f
C5005 a_21618_14644# VGND 0.43595f
C5006 a_21402_16564# VGND 0.63171f
C5007 a_21186_14644# VGND 0.43595f
C5008 a_20970_16564# VGND 0.63192f
C5009 a_20754_14644# VGND 0.52983f
C5010 LELO_GR01_0.x7.x11.P VGND 8.16148f
C5011 a_20538_14644# VGND 1.8634f $ **FLOATING
C5012 a_19680_14644# VGND 1.86518f $ **FLOATING
C5013 a_19248_14644# VGND 0.52981f
C5014 a_19032_16564# VGND 0.63171f
C5015 a_18816_14644# VGND 0.43595f
C5016 a_18600_16564# VGND 0.63171f
C5017 a_18384_14644# VGND 0.43595f
C5018 a_18168_16564# VGND 0.63171f
C5019 a_17952_14644# VGND 0.43595f
C5020 a_17736_16564# VGND 0.63171f
C5021 a_17520_14644# VGND 0.43595f
C5022 a_17304_16564# VGND 0.63171f
C5023 a_17088_14644# VGND 0.43595f
C5024 a_16872_16564# VGND 0.63171f
C5025 a_16656_14644# VGND 0.43595f
C5026 a_16440_16564# VGND 0.63171f
C5027 a_16224_14644# VGND 0.52984f
C5028 LELO_GR01_0.x7.x10.P VGND 8.07181f
C5029 a_16008_14644# VGND 1.85086f $ **FLOATING
C5030 a_12688_13928# VGND 0.43748f $ **FLOATING
C5031 a_12688_14728# VGND 0.36061f $ **FLOATING
C5032 a_11318_13928# VGND 0.48361f $ **FLOATING
C5033 LELO_GR01_0.x7.x7.G VGND 11.3367f
C5034 a_11318_14728# VGND 0.36615f $ **FLOATING
C5035 a_9738_14010# VGND 0.52514f $ **FLOATING
C5036 a_9738_14810# VGND 0.48005f $ **FLOATING
C5037 a_8336_14010# VGND 0.54416f $ **FLOATING
C5038 a_8336_14810# VGND 0.51027f $ **FLOATING
C5039 a_6936_14010# VGND 0.53615f $ **FLOATING
C5040 a_2478_12370# VGND 0.06248f $ **FLOATING
C5041 LELO_GR01_0.x7.x23.D VGND 0.15069f
C5042 a_2478_13170# VGND 0.06248f $ **FLOATING
C5043 a_6936_14810# VGND 0.51609f $ **FLOATING
C5044 a_4578_14070# VGND 0.38915f $ **FLOATING
C5045 a_2478_13680# VGND 0.06196f $ **FLOATING
C5046 LELO_GR01_0.x7.x22.D VGND 0.15244f
C5047 a_2478_14480# VGND 0.06196f $ **FLOATING
C5048 LELO_GR01_0.x7.x7.S VGND 1.26725f
C5049 a_4580_14870# VGND 0.42944f $ **FLOATING
C5050 a_12688_14988# VGND 0.04043f $ **FLOATING
C5051 a_12688_15788# VGND 0.05055f $ **FLOATING
C5052 a_11318_14986# VGND 0.04601f $ **FLOATING
C5053 a_11318_15786# VGND 0.04997f $ **FLOATING
C5054 a_9734_15074# VGND 0.4626f $ **FLOATING
C5055 a_9734_15874# VGND 0.45893f $ **FLOATING
C5056 a_7886_15060# VGND 0.45452f $ **FLOATING
C5057 a_2478_14990# VGND 0.06248f $ **FLOATING
C5058 a_7886_15860# VGND 0.40866f $ **FLOATING
C5059 a_4578_15320# VGND 0.42975f $ **FLOATING
C5060 a_11996_16042# VGND 0.0144f $ **FLOATING
C5061 LELO_GR01_0.x7.x15.I2 VGND 11.4362f
C5062 LELO_GR01_0.x7.x1.x7.D VGND 1.10877f
C5063 a_11996_16842# VGND 0.09281f $ **FLOATING
C5064 a_9734_16126# VGND 0.45845f $ **FLOATING
C5065 LELO_GR01_0.x7.x1.x5.IBN VGND 4.2508f
C5066 LELO_GR01_0.x7.x21.D VGND 0.15545f
C5067 a_2478_15790# VGND 0.06196f $ **FLOATING
C5068 a_4578_16120# VGND 0.35453f $ **FLOATING
C5069 a_9734_16926# VGND 0.4856f $ **FLOATING
C5070 a_8336_16210# VGND 0.08029f $ **FLOATING
C5071 LELO_GR01_0.x7.x1.x5.x9<2>.G VGND 17.4163f
C5072 a_8336_17010# VGND 0.10069f $ **FLOATING
C5073 a_6636_16210# VGND 0.09526f $ **FLOATING
C5074 LELO_GR01_0.x7.x1.x5.x8.G VGND 4.8751f
C5075 a_6636_17010# VGND 0.07525f $ **FLOATING
C5076 a_4578_16260# VGND 0.35417f $ **FLOATING
C5077 a_4578_17060# VGND 0.35369f $ **FLOATING
C5078 a_2478_16300# VGND 0.06248f $ **FLOATING
C5079 LELO_GR01_0.x7.x20.D VGND 0.1527f
C5080 a_2478_17100# VGND 0.06248f $ **FLOATING
C5081 a_14358_17550# VGND 0.09424f $ **FLOATING
C5082 a_17668_17950# VGND 0.11691f $ **FLOATING
C5083 a_21252_18378# VGND 0.0968f $ **FLOATING
C5084 a_20412_18378# VGND 0.37895f $ **FLOATING
C5085 a_24210_18544# VGND 0.09234f $ **FLOATING
C5086 a_23370_18544# VGND 0.37832f $ **FLOATING
C5087 a_28996_18831# VGND 0.09685f $ **FLOATING
C5088 a_28156_18831# VGND 0.45217f $ **FLOATING
C5089 a_28156_19150# VGND 0.40553f $ **FLOATING
C5090 JNWTR_TIEL_CV_0.MP0.G VGND 0.53304f
C5091 JNWTR_TIEL_CV_0.Y VGND 1.95981f
C5092 JNWTR_ORX1_CV_0.A VGND 10.7341f
C5093 a_21252_18698# VGND 0.08255f $ **FLOATING
C5094 a_20412_18698# VGND 0.34895f $ **FLOATING
C5095 LELO_GR01_0.x8.IBP_BG VGND 36.124f
C5096 a_17668_18750# VGND 0.09304f $ **FLOATING
C5097 a_16018_17950# VGND 0.11578f $ **FLOATING
C5098 LELO_GR01_0.x8.VREF_BG VGND 9.27972f
C5099 a_16018_18750# VGND 0.09304f $ **FLOATING
C5100 a_12688_18180# VGND 0.09276f $ **FLOATING
C5101 a_23370_19024# VGND 0.32818f $ **FLOATING
C5102 a_12688_18980# VGND 0.09416f $ **FLOATING
C5103 a_8552_17568# VGND 1.81111f $ **FLOATING
C5104 a_10472_17784# VGND 0.52984f
C5105 a_8552_18000# VGND 0.63171f
C5106 a_10472_18216# VGND 0.52984f
C5107 a_8552_18648# VGND 1.85408f $ **FLOATING
C5108 a_4578_17200# VGND 0.35396f $ **FLOATING
C5109 a_6636_17810# VGND 0.07597f $ **FLOATING
C5110 a_4578_18000# VGND 0.35276f $ **FLOATING
C5111 a_2478_17610# VGND 0.06196f $ **FLOATING
C5112 a_6636_18610# VGND 0.09407f $ **FLOATING
C5113 a_4578_18140# VGND 0.35276f $ **FLOATING
C5114 LELO_GR01_0.x7.xd1<4>.A VGND 25.1862f
C5115 LELO_GR01_0.x7.x18.D VGND 13.0054f
C5116 LELO_GR01_0.x8.PWRUP_N_1V8 VGND 37.9338f
C5117 LELO_GR01_0.x7.x19.D VGND 0.17422f
C5118 a_2478_18410# VGND 0.09367f $ **FLOATING
C5119 LELO_GR01_0.x7.x6<3>.G VGND 10.1995f
C5120 a_4578_18940# VGND 0.4503f $ **FLOATING
C5121 JNWTR_ORX1_CV_0.XA2.A VGND 0.92272f
C5122 LELO_GR01_0.PWRUP_1V8 VGND 10.9194f
C5123 a_24210_19344# VGND 0.0808f $ **FLOATING
C5124 a_23370_19344# VGND 0.34494f $ **FLOATING
C5125 a_28996_19470# VGND 0.08207f $ **FLOATING
C5126 a_28156_19470# VGND 0.35043f $ **FLOATING
C5127 LELO_GR01_0.x8.x8.D VGND 16.8261f
C5128 LELO_GR01_0.x8.x1.x5.x6.N VGND 6.17676f
C5129 LELO_GR01_0.x8.x1.x5.x8.S VGND 6.15982f
C5130 LELO_GR01_0.x7.x1.x5.x6.N VGND 6.17663f
C5131 LELO_GR01_0.x7.x1.x5.x8.S VGND 6.02113f
.ends
